// One complete reference round from Implementation/PRS/tb/top/no_forks.
// All producer and consumer state machines run concurrently; no periodic stimulus pulses.
// Full 32-bit words, four-phase handshakes, illegal codes, stability, counts and final drain are checked.
// Golden packets and input cases are embedded verbatim from golden/data.act and input/*.txt.
// Match complete packets by destination/content and issued case, allowing arbitration order.
// Initial producer launches differ by 2*TICK per port; transfers remain concurrent.
`include "disciplines.vams"
module router_environment(
    reset,
    C0i_t_0,
    C0i_t_1,
    C0i_t_2,
    C0i_t_3,
    C0i_t_4,
    C0i_t_5,
    C0i_t_6,
    C0i_t_7,
    C0i_t_8,
    C0i_t_9,
    C0i_t_10,
    C0i_t_11,
    C0i_t_12,
    C0i_t_13,
    C0i_t_14,
    C0i_t_15,
    C0i_t_16,
    C0i_t_17,
    C0i_t_18,
    C0i_t_19,
    C0i_t_20,
    C0i_t_21,
    C0i_t_22,
    C0i_t_23,
    C0i_t_24,
    C0i_t_25,
    C0i_t_26,
    C0i_t_27,
    C0i_t_28,
    C0i_t_29,
    C0i_t_30,
    C0i_t_31,
    C0i_f_0,
    C0i_f_1,
    C0i_f_2,
    C0i_f_3,
    C0i_f_4,
    C0i_f_5,
    C0i_f_6,
    C0i_f_7,
    C0i_f_8,
    C0i_f_9,
    C0i_f_10,
    C0i_f_11,
    C0i_f_12,
    C0i_f_13,
    C0i_f_14,
    C0i_f_15,
    C0i_f_16,
    C0i_f_17,
    C0i_f_18,
    C0i_f_19,
    C0i_f_20,
    C0i_f_21,
    C0i_f_22,
    C0i_f_23,
    C0i_f_24,
    C0i_f_25,
    C0i_f_26,
    C0i_f_27,
    C0i_f_28,
    C0i_f_29,
    C0i_f_30,
    C0i_f_31,
    C0i_a,
    C1i_t_0,
    C1i_t_1,
    C1i_t_2,
    C1i_t_3,
    C1i_t_4,
    C1i_t_5,
    C1i_t_6,
    C1i_t_7,
    C1i_t_8,
    C1i_t_9,
    C1i_t_10,
    C1i_t_11,
    C1i_t_12,
    C1i_t_13,
    C1i_t_14,
    C1i_t_15,
    C1i_t_16,
    C1i_t_17,
    C1i_t_18,
    C1i_t_19,
    C1i_t_20,
    C1i_t_21,
    C1i_t_22,
    C1i_t_23,
    C1i_t_24,
    C1i_t_25,
    C1i_t_26,
    C1i_t_27,
    C1i_t_28,
    C1i_t_29,
    C1i_t_30,
    C1i_t_31,
    C1i_f_0,
    C1i_f_1,
    C1i_f_2,
    C1i_f_3,
    C1i_f_4,
    C1i_f_5,
    C1i_f_6,
    C1i_f_7,
    C1i_f_8,
    C1i_f_9,
    C1i_f_10,
    C1i_f_11,
    C1i_f_12,
    C1i_f_13,
    C1i_f_14,
    C1i_f_15,
    C1i_f_16,
    C1i_f_17,
    C1i_f_18,
    C1i_f_19,
    C1i_f_20,
    C1i_f_21,
    C1i_f_22,
    C1i_f_23,
    C1i_f_24,
    C1i_f_25,
    C1i_f_26,
    C1i_f_27,
    C1i_f_28,
    C1i_f_29,
    C1i_f_30,
    C1i_f_31,
    C1i_a,
    C2i_t_0,
    C2i_t_1,
    C2i_t_2,
    C2i_t_3,
    C2i_t_4,
    C2i_t_5,
    C2i_t_6,
    C2i_t_7,
    C2i_t_8,
    C2i_t_9,
    C2i_t_10,
    C2i_t_11,
    C2i_t_12,
    C2i_t_13,
    C2i_t_14,
    C2i_t_15,
    C2i_t_16,
    C2i_t_17,
    C2i_t_18,
    C2i_t_19,
    C2i_t_20,
    C2i_t_21,
    C2i_t_22,
    C2i_t_23,
    C2i_t_24,
    C2i_t_25,
    C2i_t_26,
    C2i_t_27,
    C2i_t_28,
    C2i_t_29,
    C2i_t_30,
    C2i_t_31,
    C2i_f_0,
    C2i_f_1,
    C2i_f_2,
    C2i_f_3,
    C2i_f_4,
    C2i_f_5,
    C2i_f_6,
    C2i_f_7,
    C2i_f_8,
    C2i_f_9,
    C2i_f_10,
    C2i_f_11,
    C2i_f_12,
    C2i_f_13,
    C2i_f_14,
    C2i_f_15,
    C2i_f_16,
    C2i_f_17,
    C2i_f_18,
    C2i_f_19,
    C2i_f_20,
    C2i_f_21,
    C2i_f_22,
    C2i_f_23,
    C2i_f_24,
    C2i_f_25,
    C2i_f_26,
    C2i_f_27,
    C2i_f_28,
    C2i_f_29,
    C2i_f_30,
    C2i_f_31,
    C2i_a,
    C3i_t_0,
    C3i_t_1,
    C3i_t_2,
    C3i_t_3,
    C3i_t_4,
    C3i_t_5,
    C3i_t_6,
    C3i_t_7,
    C3i_t_8,
    C3i_t_9,
    C3i_t_10,
    C3i_t_11,
    C3i_t_12,
    C3i_t_13,
    C3i_t_14,
    C3i_t_15,
    C3i_t_16,
    C3i_t_17,
    C3i_t_18,
    C3i_t_19,
    C3i_t_20,
    C3i_t_21,
    C3i_t_22,
    C3i_t_23,
    C3i_t_24,
    C3i_t_25,
    C3i_t_26,
    C3i_t_27,
    C3i_t_28,
    C3i_t_29,
    C3i_t_30,
    C3i_t_31,
    C3i_f_0,
    C3i_f_1,
    C3i_f_2,
    C3i_f_3,
    C3i_f_4,
    C3i_f_5,
    C3i_f_6,
    C3i_f_7,
    C3i_f_8,
    C3i_f_9,
    C3i_f_10,
    C3i_f_11,
    C3i_f_12,
    C3i_f_13,
    C3i_f_14,
    C3i_f_15,
    C3i_f_16,
    C3i_f_17,
    C3i_f_18,
    C3i_f_19,
    C3i_f_20,
    C3i_f_21,
    C3i_f_22,
    C3i_f_23,
    C3i_f_24,
    C3i_f_25,
    C3i_f_26,
    C3i_f_27,
    C3i_f_28,
    C3i_f_29,
    C3i_f_30,
    C3i_f_31,
    C3i_a,
    Pi_t_0,
    Pi_t_1,
    Pi_t_2,
    Pi_t_3,
    Pi_t_4,
    Pi_t_5,
    Pi_t_6,
    Pi_t_7,
    Pi_t_8,
    Pi_t_9,
    Pi_t_10,
    Pi_t_11,
    Pi_t_12,
    Pi_t_13,
    Pi_t_14,
    Pi_t_15,
    Pi_t_16,
    Pi_t_17,
    Pi_t_18,
    Pi_t_19,
    Pi_t_20,
    Pi_t_21,
    Pi_t_22,
    Pi_t_23,
    Pi_t_24,
    Pi_t_25,
    Pi_t_26,
    Pi_t_27,
    Pi_t_28,
    Pi_t_29,
    Pi_t_30,
    Pi_t_31,
    Pi_f_0,
    Pi_f_1,
    Pi_f_2,
    Pi_f_3,
    Pi_f_4,
    Pi_f_5,
    Pi_f_6,
    Pi_f_7,
    Pi_f_8,
    Pi_f_9,
    Pi_f_10,
    Pi_f_11,
    Pi_f_12,
    Pi_f_13,
    Pi_f_14,
    Pi_f_15,
    Pi_f_16,
    Pi_f_17,
    Pi_f_18,
    Pi_f_19,
    Pi_f_20,
    Pi_f_21,
    Pi_f_22,
    Pi_f_23,
    Pi_f_24,
    Pi_f_25,
    Pi_f_26,
    Pi_f_27,
    Pi_f_28,
    Pi_f_29,
    Pi_f_30,
    Pi_f_31,
    Pi_a,
    C0o_t_0,
    C0o_t_1,
    C0o_t_2,
    C0o_t_3,
    C0o_t_4,
    C0o_t_5,
    C0o_t_6,
    C0o_t_7,
    C0o_t_8,
    C0o_t_9,
    C0o_t_10,
    C0o_t_11,
    C0o_t_12,
    C0o_t_13,
    C0o_t_14,
    C0o_t_15,
    C0o_t_16,
    C0o_t_17,
    C0o_t_18,
    C0o_t_19,
    C0o_t_20,
    C0o_t_21,
    C0o_t_22,
    C0o_t_23,
    C0o_t_24,
    C0o_t_25,
    C0o_t_26,
    C0o_t_27,
    C0o_t_28,
    C0o_t_29,
    C0o_t_30,
    C0o_t_31,
    C0o_f_0,
    C0o_f_1,
    C0o_f_2,
    C0o_f_3,
    C0o_f_4,
    C0o_f_5,
    C0o_f_6,
    C0o_f_7,
    C0o_f_8,
    C0o_f_9,
    C0o_f_10,
    C0o_f_11,
    C0o_f_12,
    C0o_f_13,
    C0o_f_14,
    C0o_f_15,
    C0o_f_16,
    C0o_f_17,
    C0o_f_18,
    C0o_f_19,
    C0o_f_20,
    C0o_f_21,
    C0o_f_22,
    C0o_f_23,
    C0o_f_24,
    C0o_f_25,
    C0o_f_26,
    C0o_f_27,
    C0o_f_28,
    C0o_f_29,
    C0o_f_30,
    C0o_f_31,
    C0o_a,
    C1o_t_0,
    C1o_t_1,
    C1o_t_2,
    C1o_t_3,
    C1o_t_4,
    C1o_t_5,
    C1o_t_6,
    C1o_t_7,
    C1o_t_8,
    C1o_t_9,
    C1o_t_10,
    C1o_t_11,
    C1o_t_12,
    C1o_t_13,
    C1o_t_14,
    C1o_t_15,
    C1o_t_16,
    C1o_t_17,
    C1o_t_18,
    C1o_t_19,
    C1o_t_20,
    C1o_t_21,
    C1o_t_22,
    C1o_t_23,
    C1o_t_24,
    C1o_t_25,
    C1o_t_26,
    C1o_t_27,
    C1o_t_28,
    C1o_t_29,
    C1o_t_30,
    C1o_t_31,
    C1o_f_0,
    C1o_f_1,
    C1o_f_2,
    C1o_f_3,
    C1o_f_4,
    C1o_f_5,
    C1o_f_6,
    C1o_f_7,
    C1o_f_8,
    C1o_f_9,
    C1o_f_10,
    C1o_f_11,
    C1o_f_12,
    C1o_f_13,
    C1o_f_14,
    C1o_f_15,
    C1o_f_16,
    C1o_f_17,
    C1o_f_18,
    C1o_f_19,
    C1o_f_20,
    C1o_f_21,
    C1o_f_22,
    C1o_f_23,
    C1o_f_24,
    C1o_f_25,
    C1o_f_26,
    C1o_f_27,
    C1o_f_28,
    C1o_f_29,
    C1o_f_30,
    C1o_f_31,
    C1o_a,
    C2o_t_0,
    C2o_t_1,
    C2o_t_2,
    C2o_t_3,
    C2o_t_4,
    C2o_t_5,
    C2o_t_6,
    C2o_t_7,
    C2o_t_8,
    C2o_t_9,
    C2o_t_10,
    C2o_t_11,
    C2o_t_12,
    C2o_t_13,
    C2o_t_14,
    C2o_t_15,
    C2o_t_16,
    C2o_t_17,
    C2o_t_18,
    C2o_t_19,
    C2o_t_20,
    C2o_t_21,
    C2o_t_22,
    C2o_t_23,
    C2o_t_24,
    C2o_t_25,
    C2o_t_26,
    C2o_t_27,
    C2o_t_28,
    C2o_t_29,
    C2o_t_30,
    C2o_t_31,
    C2o_f_0,
    C2o_f_1,
    C2o_f_2,
    C2o_f_3,
    C2o_f_4,
    C2o_f_5,
    C2o_f_6,
    C2o_f_7,
    C2o_f_8,
    C2o_f_9,
    C2o_f_10,
    C2o_f_11,
    C2o_f_12,
    C2o_f_13,
    C2o_f_14,
    C2o_f_15,
    C2o_f_16,
    C2o_f_17,
    C2o_f_18,
    C2o_f_19,
    C2o_f_20,
    C2o_f_21,
    C2o_f_22,
    C2o_f_23,
    C2o_f_24,
    C2o_f_25,
    C2o_f_26,
    C2o_f_27,
    C2o_f_28,
    C2o_f_29,
    C2o_f_30,
    C2o_f_31,
    C2o_a,
    C3o_t_0,
    C3o_t_1,
    C3o_t_2,
    C3o_t_3,
    C3o_t_4,
    C3o_t_5,
    C3o_t_6,
    C3o_t_7,
    C3o_t_8,
    C3o_t_9,
    C3o_t_10,
    C3o_t_11,
    C3o_t_12,
    C3o_t_13,
    C3o_t_14,
    C3o_t_15,
    C3o_t_16,
    C3o_t_17,
    C3o_t_18,
    C3o_t_19,
    C3o_t_20,
    C3o_t_21,
    C3o_t_22,
    C3o_t_23,
    C3o_t_24,
    C3o_t_25,
    C3o_t_26,
    C3o_t_27,
    C3o_t_28,
    C3o_t_29,
    C3o_t_30,
    C3o_t_31,
    C3o_f_0,
    C3o_f_1,
    C3o_f_2,
    C3o_f_3,
    C3o_f_4,
    C3o_f_5,
    C3o_f_6,
    C3o_f_7,
    C3o_f_8,
    C3o_f_9,
    C3o_f_10,
    C3o_f_11,
    C3o_f_12,
    C3o_f_13,
    C3o_f_14,
    C3o_f_15,
    C3o_f_16,
    C3o_f_17,
    C3o_f_18,
    C3o_f_19,
    C3o_f_20,
    C3o_f_21,
    C3o_f_22,
    C3o_f_23,
    C3o_f_24,
    C3o_f_25,
    C3o_f_26,
    C3o_f_27,
    C3o_f_28,
    C3o_f_29,
    C3o_f_30,
    C3o_f_31,
    C3o_a,
    Po_t_0,
    Po_t_1,
    Po_t_2,
    Po_t_3,
    Po_t_4,
    Po_t_5,
    Po_t_6,
    Po_t_7,
    Po_t_8,
    Po_t_9,
    Po_t_10,
    Po_t_11,
    Po_t_12,
    Po_t_13,
    Po_t_14,
    Po_t_15,
    Po_t_16,
    Po_t_17,
    Po_t_18,
    Po_t_19,
    Po_t_20,
    Po_t_21,
    Po_t_22,
    Po_t_23,
    Po_t_24,
    Po_t_25,
    Po_t_26,
    Po_t_27,
    Po_t_28,
    Po_t_29,
    Po_t_30,
    Po_t_31,
    Po_f_0,
    Po_f_1,
    Po_f_2,
    Po_f_3,
    Po_f_4,
    Po_f_5,
    Po_f_6,
    Po_f_7,
    Po_f_8,
    Po_f_9,
    Po_f_10,
    Po_f_11,
    Po_f_12,
    Po_f_13,
    Po_f_14,
    Po_f_15,
    Po_f_16,
    Po_f_17,
    Po_f_18,
    Po_f_19,
    Po_f_20,
    Po_f_21,
    Po_f_22,
    Po_f_23,
    Po_f_24,
    Po_f_25,
    Po_f_26,
    Po_f_27,
    Po_f_28,
    Po_f_29,
    Po_f_30,
    Po_f_31,
    Po_a,
    done,
    failed);
inout reset, C0i_t_0, C0i_t_1, C0i_t_2, C0i_t_3, C0i_t_4, C0i_t_5, C0i_t_6, C0i_t_7, C0i_t_8, C0i_t_9, C0i_t_10, C0i_t_11, C0i_t_12, C0i_t_13, C0i_t_14, C0i_t_15, C0i_t_16, C0i_t_17, C0i_t_18, C0i_t_19, C0i_t_20, C0i_t_21, C0i_t_22, C0i_t_23, C0i_t_24, C0i_t_25, C0i_t_26, C0i_t_27, C0i_t_28, C0i_t_29, C0i_t_30, C0i_t_31, C0i_f_0, C0i_f_1, C0i_f_2, C0i_f_3, C0i_f_4, C0i_f_5, C0i_f_6, C0i_f_7, C0i_f_8, C0i_f_9, C0i_f_10, C0i_f_11, C0i_f_12, C0i_f_13, C0i_f_14, C0i_f_15, C0i_f_16, C0i_f_17, C0i_f_18, C0i_f_19, C0i_f_20, C0i_f_21, C0i_f_22, C0i_f_23, C0i_f_24, C0i_f_25, C0i_f_26, C0i_f_27, C0i_f_28, C0i_f_29, C0i_f_30, C0i_f_31, C0i_a, C1i_t_0, C1i_t_1, C1i_t_2, C1i_t_3, C1i_t_4, C1i_t_5, C1i_t_6, C1i_t_7, C1i_t_8, C1i_t_9, C1i_t_10, C1i_t_11, C1i_t_12, C1i_t_13, C1i_t_14, C1i_t_15, C1i_t_16, C1i_t_17, C1i_t_18, C1i_t_19, C1i_t_20, C1i_t_21, C1i_t_22, C1i_t_23, C1i_t_24, C1i_t_25, C1i_t_26, C1i_t_27, C1i_t_28, C1i_t_29, C1i_t_30, C1i_t_31, C1i_f_0, C1i_f_1, C1i_f_2, C1i_f_3, C1i_f_4, C1i_f_5, C1i_f_6, C1i_f_7, C1i_f_8, C1i_f_9, C1i_f_10, C1i_f_11, C1i_f_12, C1i_f_13, C1i_f_14, C1i_f_15, C1i_f_16, C1i_f_17, C1i_f_18, C1i_f_19, C1i_f_20, C1i_f_21, C1i_f_22, C1i_f_23, C1i_f_24, C1i_f_25, C1i_f_26, C1i_f_27, C1i_f_28, C1i_f_29, C1i_f_30, C1i_f_31, C1i_a, C2i_t_0, C2i_t_1, C2i_t_2, C2i_t_3, C2i_t_4, C2i_t_5, C2i_t_6, C2i_t_7, C2i_t_8, C2i_t_9, C2i_t_10, C2i_t_11, C2i_t_12, C2i_t_13, C2i_t_14, C2i_t_15, C2i_t_16, C2i_t_17, C2i_t_18, C2i_t_19, C2i_t_20, C2i_t_21, C2i_t_22, C2i_t_23, C2i_t_24, C2i_t_25, C2i_t_26, C2i_t_27, C2i_t_28, C2i_t_29, C2i_t_30, C2i_t_31, C2i_f_0, C2i_f_1, C2i_f_2, C2i_f_3, C2i_f_4, C2i_f_5, C2i_f_6, C2i_f_7, C2i_f_8, C2i_f_9, C2i_f_10, C2i_f_11, C2i_f_12, C2i_f_13, C2i_f_14, C2i_f_15, C2i_f_16, C2i_f_17, C2i_f_18, C2i_f_19, C2i_f_20, C2i_f_21, C2i_f_22, C2i_f_23, C2i_f_24, C2i_f_25, C2i_f_26, C2i_f_27, C2i_f_28, C2i_f_29, C2i_f_30, C2i_f_31, C2i_a, C3i_t_0, C3i_t_1, C3i_t_2, C3i_t_3, C3i_t_4, C3i_t_5, C3i_t_6, C3i_t_7, C3i_t_8, C3i_t_9, C3i_t_10, C3i_t_11, C3i_t_12, C3i_t_13, C3i_t_14, C3i_t_15, C3i_t_16, C3i_t_17, C3i_t_18, C3i_t_19, C3i_t_20, C3i_t_21, C3i_t_22, C3i_t_23, C3i_t_24, C3i_t_25, C3i_t_26, C3i_t_27, C3i_t_28, C3i_t_29, C3i_t_30, C3i_t_31, C3i_f_0, C3i_f_1, C3i_f_2, C3i_f_3, C3i_f_4, C3i_f_5, C3i_f_6, C3i_f_7, C3i_f_8, C3i_f_9, C3i_f_10, C3i_f_11, C3i_f_12, C3i_f_13, C3i_f_14, C3i_f_15, C3i_f_16, C3i_f_17, C3i_f_18, C3i_f_19, C3i_f_20, C3i_f_21, C3i_f_22, C3i_f_23, C3i_f_24, C3i_f_25, C3i_f_26, C3i_f_27, C3i_f_28, C3i_f_29, C3i_f_30, C3i_f_31, C3i_a, Pi_t_0, Pi_t_1, Pi_t_2, Pi_t_3, Pi_t_4, Pi_t_5, Pi_t_6, Pi_t_7, Pi_t_8, Pi_t_9, Pi_t_10, Pi_t_11, Pi_t_12, Pi_t_13, Pi_t_14, Pi_t_15, Pi_t_16, Pi_t_17, Pi_t_18, Pi_t_19, Pi_t_20, Pi_t_21, Pi_t_22, Pi_t_23, Pi_t_24, Pi_t_25, Pi_t_26, Pi_t_27, Pi_t_28, Pi_t_29, Pi_t_30, Pi_t_31, Pi_f_0, Pi_f_1, Pi_f_2, Pi_f_3, Pi_f_4, Pi_f_5, Pi_f_6, Pi_f_7, Pi_f_8, Pi_f_9, Pi_f_10, Pi_f_11, Pi_f_12, Pi_f_13, Pi_f_14, Pi_f_15, Pi_f_16, Pi_f_17, Pi_f_18, Pi_f_19, Pi_f_20, Pi_f_21, Pi_f_22, Pi_f_23, Pi_f_24, Pi_f_25, Pi_f_26, Pi_f_27, Pi_f_28, Pi_f_29, Pi_f_30, Pi_f_31, Pi_a, C0o_t_0, C0o_t_1, C0o_t_2, C0o_t_3, C0o_t_4, C0o_t_5, C0o_t_6, C0o_t_7, C0o_t_8, C0o_t_9, C0o_t_10, C0o_t_11, C0o_t_12, C0o_t_13, C0o_t_14, C0o_t_15, C0o_t_16, C0o_t_17, C0o_t_18, C0o_t_19, C0o_t_20, C0o_t_21, C0o_t_22, C0o_t_23, C0o_t_24, C0o_t_25, C0o_t_26, C0o_t_27, C0o_t_28, C0o_t_29, C0o_t_30, C0o_t_31, C0o_f_0, C0o_f_1, C0o_f_2, C0o_f_3, C0o_f_4, C0o_f_5, C0o_f_6, C0o_f_7, C0o_f_8, C0o_f_9, C0o_f_10, C0o_f_11, C0o_f_12, C0o_f_13, C0o_f_14, C0o_f_15, C0o_f_16, C0o_f_17, C0o_f_18, C0o_f_19, C0o_f_20, C0o_f_21, C0o_f_22, C0o_f_23, C0o_f_24, C0o_f_25, C0o_f_26, C0o_f_27, C0o_f_28, C0o_f_29, C0o_f_30, C0o_f_31, C0o_a, C1o_t_0, C1o_t_1, C1o_t_2, C1o_t_3, C1o_t_4, C1o_t_5, C1o_t_6, C1o_t_7, C1o_t_8, C1o_t_9, C1o_t_10, C1o_t_11, C1o_t_12, C1o_t_13, C1o_t_14, C1o_t_15, C1o_t_16, C1o_t_17, C1o_t_18, C1o_t_19, C1o_t_20, C1o_t_21, C1o_t_22, C1o_t_23, C1o_t_24, C1o_t_25, C1o_t_26, C1o_t_27, C1o_t_28, C1o_t_29, C1o_t_30, C1o_t_31, C1o_f_0, C1o_f_1, C1o_f_2, C1o_f_3, C1o_f_4, C1o_f_5, C1o_f_6, C1o_f_7, C1o_f_8, C1o_f_9, C1o_f_10, C1o_f_11, C1o_f_12, C1o_f_13, C1o_f_14, C1o_f_15, C1o_f_16, C1o_f_17, C1o_f_18, C1o_f_19, C1o_f_20, C1o_f_21, C1o_f_22, C1o_f_23, C1o_f_24, C1o_f_25, C1o_f_26, C1o_f_27, C1o_f_28, C1o_f_29, C1o_f_30, C1o_f_31, C1o_a, C2o_t_0, C2o_t_1, C2o_t_2, C2o_t_3, C2o_t_4, C2o_t_5, C2o_t_6, C2o_t_7, C2o_t_8, C2o_t_9, C2o_t_10, C2o_t_11, C2o_t_12, C2o_t_13, C2o_t_14, C2o_t_15, C2o_t_16, C2o_t_17, C2o_t_18, C2o_t_19, C2o_t_20, C2o_t_21, C2o_t_22, C2o_t_23, C2o_t_24, C2o_t_25, C2o_t_26, C2o_t_27, C2o_t_28, C2o_t_29, C2o_t_30, C2o_t_31, C2o_f_0, C2o_f_1, C2o_f_2, C2o_f_3, C2o_f_4, C2o_f_5, C2o_f_6, C2o_f_7, C2o_f_8, C2o_f_9, C2o_f_10, C2o_f_11, C2o_f_12, C2o_f_13, C2o_f_14, C2o_f_15, C2o_f_16, C2o_f_17, C2o_f_18, C2o_f_19, C2o_f_20, C2o_f_21, C2o_f_22, C2o_f_23, C2o_f_24, C2o_f_25, C2o_f_26, C2o_f_27, C2o_f_28, C2o_f_29, C2o_f_30, C2o_f_31, C2o_a, C3o_t_0, C3o_t_1, C3o_t_2, C3o_t_3, C3o_t_4, C3o_t_5, C3o_t_6, C3o_t_7, C3o_t_8, C3o_t_9, C3o_t_10, C3o_t_11, C3o_t_12, C3o_t_13, C3o_t_14, C3o_t_15, C3o_t_16, C3o_t_17, C3o_t_18, C3o_t_19, C3o_t_20, C3o_t_21, C3o_t_22, C3o_t_23, C3o_t_24, C3o_t_25, C3o_t_26, C3o_t_27, C3o_t_28, C3o_t_29, C3o_t_30, C3o_t_31, C3o_f_0, C3o_f_1, C3o_f_2, C3o_f_3, C3o_f_4, C3o_f_5, C3o_f_6, C3o_f_7, C3o_f_8, C3o_f_9, C3o_f_10, C3o_f_11, C3o_f_12, C3o_f_13, C3o_f_14, C3o_f_15, C3o_f_16, C3o_f_17, C3o_f_18, C3o_f_19, C3o_f_20, C3o_f_21, C3o_f_22, C3o_f_23, C3o_f_24, C3o_f_25, C3o_f_26, C3o_f_27, C3o_f_28, C3o_f_29, C3o_f_30, C3o_f_31, C3o_a, Po_t_0, Po_t_1, Po_t_2, Po_t_3, Po_t_4, Po_t_5, Po_t_6, Po_t_7, Po_t_8, Po_t_9, Po_t_10, Po_t_11, Po_t_12, Po_t_13, Po_t_14, Po_t_15, Po_t_16, Po_t_17, Po_t_18, Po_t_19, Po_t_20, Po_t_21, Po_t_22, Po_t_23, Po_t_24, Po_t_25, Po_t_26, Po_t_27, Po_t_28, Po_t_29, Po_t_30, Po_t_31, Po_f_0, Po_f_1, Po_f_2, Po_f_3, Po_f_4, Po_f_5, Po_f_6, Po_f_7, Po_f_8, Po_f_9, Po_f_10, Po_f_11, Po_f_12, Po_f_13, Po_f_14, Po_f_15, Po_f_16, Po_f_17, Po_f_18, Po_f_19, Po_f_20, Po_f_21, Po_f_22, Po_f_23, Po_f_24, Po_f_25, Po_f_26, Po_f_27, Po_f_28, Po_f_29, Po_f_30, Po_f_31, Po_a, done, failed;
electrical reset, C0i_t_0, C0i_t_1, C0i_t_2, C0i_t_3, C0i_t_4, C0i_t_5, C0i_t_6, C0i_t_7, C0i_t_8, C0i_t_9, C0i_t_10, C0i_t_11, C0i_t_12, C0i_t_13, C0i_t_14, C0i_t_15, C0i_t_16, C0i_t_17, C0i_t_18, C0i_t_19, C0i_t_20, C0i_t_21, C0i_t_22, C0i_t_23, C0i_t_24, C0i_t_25, C0i_t_26, C0i_t_27, C0i_t_28, C0i_t_29, C0i_t_30, C0i_t_31, C0i_f_0, C0i_f_1, C0i_f_2, C0i_f_3, C0i_f_4, C0i_f_5, C0i_f_6, C0i_f_7, C0i_f_8, C0i_f_9, C0i_f_10, C0i_f_11, C0i_f_12, C0i_f_13, C0i_f_14, C0i_f_15, C0i_f_16, C0i_f_17, C0i_f_18, C0i_f_19, C0i_f_20, C0i_f_21, C0i_f_22, C0i_f_23, C0i_f_24, C0i_f_25, C0i_f_26, C0i_f_27, C0i_f_28, C0i_f_29, C0i_f_30, C0i_f_31, C0i_a, C1i_t_0, C1i_t_1, C1i_t_2, C1i_t_3, C1i_t_4, C1i_t_5, C1i_t_6, C1i_t_7, C1i_t_8, C1i_t_9, C1i_t_10, C1i_t_11, C1i_t_12, C1i_t_13, C1i_t_14, C1i_t_15, C1i_t_16, C1i_t_17, C1i_t_18, C1i_t_19, C1i_t_20, C1i_t_21, C1i_t_22, C1i_t_23, C1i_t_24, C1i_t_25, C1i_t_26, C1i_t_27, C1i_t_28, C1i_t_29, C1i_t_30, C1i_t_31, C1i_f_0, C1i_f_1, C1i_f_2, C1i_f_3, C1i_f_4, C1i_f_5, C1i_f_6, C1i_f_7, C1i_f_8, C1i_f_9, C1i_f_10, C1i_f_11, C1i_f_12, C1i_f_13, C1i_f_14, C1i_f_15, C1i_f_16, C1i_f_17, C1i_f_18, C1i_f_19, C1i_f_20, C1i_f_21, C1i_f_22, C1i_f_23, C1i_f_24, C1i_f_25, C1i_f_26, C1i_f_27, C1i_f_28, C1i_f_29, C1i_f_30, C1i_f_31, C1i_a, C2i_t_0, C2i_t_1, C2i_t_2, C2i_t_3, C2i_t_4, C2i_t_5, C2i_t_6, C2i_t_7, C2i_t_8, C2i_t_9, C2i_t_10, C2i_t_11, C2i_t_12, C2i_t_13, C2i_t_14, C2i_t_15, C2i_t_16, C2i_t_17, C2i_t_18, C2i_t_19, C2i_t_20, C2i_t_21, C2i_t_22, C2i_t_23, C2i_t_24, C2i_t_25, C2i_t_26, C2i_t_27, C2i_t_28, C2i_t_29, C2i_t_30, C2i_t_31, C2i_f_0, C2i_f_1, C2i_f_2, C2i_f_3, C2i_f_4, C2i_f_5, C2i_f_6, C2i_f_7, C2i_f_8, C2i_f_9, C2i_f_10, C2i_f_11, C2i_f_12, C2i_f_13, C2i_f_14, C2i_f_15, C2i_f_16, C2i_f_17, C2i_f_18, C2i_f_19, C2i_f_20, C2i_f_21, C2i_f_22, C2i_f_23, C2i_f_24, C2i_f_25, C2i_f_26, C2i_f_27, C2i_f_28, C2i_f_29, C2i_f_30, C2i_f_31, C2i_a, C3i_t_0, C3i_t_1, C3i_t_2, C3i_t_3, C3i_t_4, C3i_t_5, C3i_t_6, C3i_t_7, C3i_t_8, C3i_t_9, C3i_t_10, C3i_t_11, C3i_t_12, C3i_t_13, C3i_t_14, C3i_t_15, C3i_t_16, C3i_t_17, C3i_t_18, C3i_t_19, C3i_t_20, C3i_t_21, C3i_t_22, C3i_t_23, C3i_t_24, C3i_t_25, C3i_t_26, C3i_t_27, C3i_t_28, C3i_t_29, C3i_t_30, C3i_t_31, C3i_f_0, C3i_f_1, C3i_f_2, C3i_f_3, C3i_f_4, C3i_f_5, C3i_f_6, C3i_f_7, C3i_f_8, C3i_f_9, C3i_f_10, C3i_f_11, C3i_f_12, C3i_f_13, C3i_f_14, C3i_f_15, C3i_f_16, C3i_f_17, C3i_f_18, C3i_f_19, C3i_f_20, C3i_f_21, C3i_f_22, C3i_f_23, C3i_f_24, C3i_f_25, C3i_f_26, C3i_f_27, C3i_f_28, C3i_f_29, C3i_f_30, C3i_f_31, C3i_a, Pi_t_0, Pi_t_1, Pi_t_2, Pi_t_3, Pi_t_4, Pi_t_5, Pi_t_6, Pi_t_7, Pi_t_8, Pi_t_9, Pi_t_10, Pi_t_11, Pi_t_12, Pi_t_13, Pi_t_14, Pi_t_15, Pi_t_16, Pi_t_17, Pi_t_18, Pi_t_19, Pi_t_20, Pi_t_21, Pi_t_22, Pi_t_23, Pi_t_24, Pi_t_25, Pi_t_26, Pi_t_27, Pi_t_28, Pi_t_29, Pi_t_30, Pi_t_31, Pi_f_0, Pi_f_1, Pi_f_2, Pi_f_3, Pi_f_4, Pi_f_5, Pi_f_6, Pi_f_7, Pi_f_8, Pi_f_9, Pi_f_10, Pi_f_11, Pi_f_12, Pi_f_13, Pi_f_14, Pi_f_15, Pi_f_16, Pi_f_17, Pi_f_18, Pi_f_19, Pi_f_20, Pi_f_21, Pi_f_22, Pi_f_23, Pi_f_24, Pi_f_25, Pi_f_26, Pi_f_27, Pi_f_28, Pi_f_29, Pi_f_30, Pi_f_31, Pi_a, C0o_t_0, C0o_t_1, C0o_t_2, C0o_t_3, C0o_t_4, C0o_t_5, C0o_t_6, C0o_t_7, C0o_t_8, C0o_t_9, C0o_t_10, C0o_t_11, C0o_t_12, C0o_t_13, C0o_t_14, C0o_t_15, C0o_t_16, C0o_t_17, C0o_t_18, C0o_t_19, C0o_t_20, C0o_t_21, C0o_t_22, C0o_t_23, C0o_t_24, C0o_t_25, C0o_t_26, C0o_t_27, C0o_t_28, C0o_t_29, C0o_t_30, C0o_t_31, C0o_f_0, C0o_f_1, C0o_f_2, C0o_f_3, C0o_f_4, C0o_f_5, C0o_f_6, C0o_f_7, C0o_f_8, C0o_f_9, C0o_f_10, C0o_f_11, C0o_f_12, C0o_f_13, C0o_f_14, C0o_f_15, C0o_f_16, C0o_f_17, C0o_f_18, C0o_f_19, C0o_f_20, C0o_f_21, C0o_f_22, C0o_f_23, C0o_f_24, C0o_f_25, C0o_f_26, C0o_f_27, C0o_f_28, C0o_f_29, C0o_f_30, C0o_f_31, C0o_a, C1o_t_0, C1o_t_1, C1o_t_2, C1o_t_3, C1o_t_4, C1o_t_5, C1o_t_6, C1o_t_7, C1o_t_8, C1o_t_9, C1o_t_10, C1o_t_11, C1o_t_12, C1o_t_13, C1o_t_14, C1o_t_15, C1o_t_16, C1o_t_17, C1o_t_18, C1o_t_19, C1o_t_20, C1o_t_21, C1o_t_22, C1o_t_23, C1o_t_24, C1o_t_25, C1o_t_26, C1o_t_27, C1o_t_28, C1o_t_29, C1o_t_30, C1o_t_31, C1o_f_0, C1o_f_1, C1o_f_2, C1o_f_3, C1o_f_4, C1o_f_5, C1o_f_6, C1o_f_7, C1o_f_8, C1o_f_9, C1o_f_10, C1o_f_11, C1o_f_12, C1o_f_13, C1o_f_14, C1o_f_15, C1o_f_16, C1o_f_17, C1o_f_18, C1o_f_19, C1o_f_20, C1o_f_21, C1o_f_22, C1o_f_23, C1o_f_24, C1o_f_25, C1o_f_26, C1o_f_27, C1o_f_28, C1o_f_29, C1o_f_30, C1o_f_31, C1o_a, C2o_t_0, C2o_t_1, C2o_t_2, C2o_t_3, C2o_t_4, C2o_t_5, C2o_t_6, C2o_t_7, C2o_t_8, C2o_t_9, C2o_t_10, C2o_t_11, C2o_t_12, C2o_t_13, C2o_t_14, C2o_t_15, C2o_t_16, C2o_t_17, C2o_t_18, C2o_t_19, C2o_t_20, C2o_t_21, C2o_t_22, C2o_t_23, C2o_t_24, C2o_t_25, C2o_t_26, C2o_t_27, C2o_t_28, C2o_t_29, C2o_t_30, C2o_t_31, C2o_f_0, C2o_f_1, C2o_f_2, C2o_f_3, C2o_f_4, C2o_f_5, C2o_f_6, C2o_f_7, C2o_f_8, C2o_f_9, C2o_f_10, C2o_f_11, C2o_f_12, C2o_f_13, C2o_f_14, C2o_f_15, C2o_f_16, C2o_f_17, C2o_f_18, C2o_f_19, C2o_f_20, C2o_f_21, C2o_f_22, C2o_f_23, C2o_f_24, C2o_f_25, C2o_f_26, C2o_f_27, C2o_f_28, C2o_f_29, C2o_f_30, C2o_f_31, C2o_a, C3o_t_0, C3o_t_1, C3o_t_2, C3o_t_3, C3o_t_4, C3o_t_5, C3o_t_6, C3o_t_7, C3o_t_8, C3o_t_9, C3o_t_10, C3o_t_11, C3o_t_12, C3o_t_13, C3o_t_14, C3o_t_15, C3o_t_16, C3o_t_17, C3o_t_18, C3o_t_19, C3o_t_20, C3o_t_21, C3o_t_22, C3o_t_23, C3o_t_24, C3o_t_25, C3o_t_26, C3o_t_27, C3o_t_28, C3o_t_29, C3o_t_30, C3o_t_31, C3o_f_0, C3o_f_1, C3o_f_2, C3o_f_3, C3o_f_4, C3o_f_5, C3o_f_6, C3o_f_7, C3o_f_8, C3o_f_9, C3o_f_10, C3o_f_11, C3o_f_12, C3o_f_13, C3o_f_14, C3o_f_15, C3o_f_16, C3o_f_17, C3o_f_18, C3o_f_19, C3o_f_20, C3o_f_21, C3o_f_22, C3o_f_23, C3o_f_24, C3o_f_25, C3o_f_26, C3o_f_27, C3o_f_28, C3o_f_29, C3o_f_30, C3o_f_31, C3o_a, Po_t_0, Po_t_1, Po_t_2, Po_t_3, Po_t_4, Po_t_5, Po_t_6, Po_t_7, Po_t_8, Po_t_9, Po_t_10, Po_t_11, Po_t_12, Po_t_13, Po_t_14, Po_t_15, Po_t_16, Po_t_17, Po_t_18, Po_t_19, Po_t_20, Po_t_21, Po_t_22, Po_t_23, Po_t_24, Po_t_25, Po_t_26, Po_t_27, Po_t_28, Po_t_29, Po_t_30, Po_t_31, Po_f_0, Po_f_1, Po_f_2, Po_f_3, Po_f_4, Po_f_5, Po_f_6, Po_f_7, Po_f_8, Po_f_9, Po_f_10, Po_f_11, Po_f_12, Po_f_13, Po_f_14, Po_f_15, Po_f_16, Po_f_17, Po_f_18, Po_f_19, Po_f_20, Po_f_21, Po_f_22, Po_f_23, Po_f_24, Po_f_25, Po_f_26, Po_f_27, Po_f_28, Po_f_29, Po_f_30, Po_f_31, Po_a, done, failed;
parameter real SUPPLY=0.0;
parameter real TICK=10p from (0:inf);
parameter real TD=100p from (0:inf);
parameter real EDGE=10p from (0:inf);
parameter real STOP_TIME=20u from (0:inf);
integer active, finished, failure, reported, all_complete, quiescent;
integer j;
real threshold, stop_after, release_time;
integer tx_index[0:4], tx_phase[0:4], tx_valid[0:4], tx_word[0:4], input_spacer[0:4];
integer rx_index[0:4], rx_phase[0:4], ack[0:4], valid_word[0:4], spacer[0:4], illegal[0:4], word[0:4], held[0:4];
integer k, candidate, same;
integer length[0:4], packet[0:79], hits[0:99], issued[0:55];
// Observe at 10 ps during all transactions; no checker wakeups while reset is held.
parameter real CHECK_START=100.01n from (0:inf);
analog function integer stimulus;
  input port_id, index;
  integer port_id, index;
  begin
    stimulus=0;
    case (port_id)
      0: begin
        case (index)
          0: stimulus=2147479614; // 0x7ffff03e
          1: stimulus=-4033; // 0xfffff03f
          2: stimulus=1610608686; // 0x5ffff02e
          3: stimulus=-4049; // 0xfffff02f
          4: stimulus=1073737758; // 0x3ffff01e
          5: stimulus=-4065; // 0xfffff01f
          6: stimulus=536866830; // 0x1ffff00e
          7: stimulus=-4081; // 0xfffff00f
          8: stimulus=-4018; // 0xfffff04e
          9: stimulus=-4018; // 0xfffff04e
          10: stimulus=-4017; // 0xfffff04f
          11: stimulus=-2147479458; // 0x8000105e
          12: stimulus=881680386; // 0x348d6002
          13: stimulus=-1160008445; // 0xbadbad03
          14: stimulus=-2147479458; // 0x8000105e
          15: stimulus=880967954; // 0x34828112
          16: stimulus=2; // 0x00000002
          17: stimulus=-1160008445; // 0xbadbad03
          18: stimulus=-2147479458; // 0x8000105e
          19: stimulus=881681170; // 0x348d6312
          20: stimulus=-2079326206; // 0x84100002
          21: stimulus=-1160008445; // 0xbadbad03
          22: stimulus=-2147479458; // 0x8000105e
          23: stimulus=881615634; // 0x348c6312
          24: stimulus=-2079189886; // 0x84121482
          25: stimulus=1143021570; // 0x44212002
          26: stimulus=-1160008445; // 0xbadbad03
          27: stimulus=-2147479458; // 0x8000105e
          28: stimulus=-249266174; // 0xf1248002
          29: stimulus=-1160008445; // 0xbadbad03
        endcase
      end
      1: begin
        case (index)
          0: stimulus=2147479870; // 0x7ffff13e
          1: stimulus=-3777; // 0xfffff13f
          2: stimulus=1610608942; // 0x5ffff12e
          3: stimulus=-3793; // 0xfffff12f
          4: stimulus=1073738014; // 0x3ffff11e
          5: stimulus=-3809; // 0xfffff11f
          6: stimulus=536867086; // 0x1ffff10e
          7: stimulus=-3825; // 0xfffff10f
          8: stimulus=-3762; // 0xfffff14e
          9: stimulus=-3762; // 0xfffff14e
          10: stimulus=-3761; // 0xfffff14f
          11: stimulus=-2147479202; // 0x8000115e
          12: stimulus=881680386; // 0x348d6002
          13: stimulus=-1160008429; // 0xbadbad13
          14: stimulus=-2147479202; // 0x8000115e
          15: stimulus=880967954; // 0x34828112
          16: stimulus=2; // 0x00000002
          17: stimulus=-1160008429; // 0xbadbad13
          18: stimulus=-2147479202; // 0x8000115e
          19: stimulus=881681170; // 0x348d6312
          20: stimulus=-2079326206; // 0x84100002
          21: stimulus=-1160008429; // 0xbadbad13
          22: stimulus=-2147479202; // 0x8000115e
          23: stimulus=881615634; // 0x348c6312
          24: stimulus=-2079189886; // 0x84121482
          25: stimulus=1143021570; // 0x44212002
          26: stimulus=-1160008429; // 0xbadbad13
          27: stimulus=-2147479202; // 0x8000115e
          28: stimulus=-249266174; // 0xf1248002
          29: stimulus=-1160008429; // 0xbadbad13
        endcase
      end
      2: begin
        case (index)
          0: stimulus=2147480126; // 0x7ffff23e
          1: stimulus=-3521; // 0xfffff23f
          2: stimulus=1610609198; // 0x5ffff22e
          3: stimulus=-3537; // 0xfffff22f
          4: stimulus=1073738270; // 0x3ffff21e
          5: stimulus=-3553; // 0xfffff21f
          6: stimulus=536867342; // 0x1ffff20e
          7: stimulus=-3569; // 0xfffff20f
          8: stimulus=-3506; // 0xfffff24e
          9: stimulus=-3506; // 0xfffff24e
          10: stimulus=-3505; // 0xfffff24f
          11: stimulus=-2147478946; // 0x8000125e
          12: stimulus=881680386; // 0x348d6002
          13: stimulus=-1160008413; // 0xbadbad23
          14: stimulus=-2147478946; // 0x8000125e
          15: stimulus=880967954; // 0x34828112
          16: stimulus=2; // 0x00000002
          17: stimulus=-1160008413; // 0xbadbad23
          18: stimulus=-2147478946; // 0x8000125e
          19: stimulus=881681170; // 0x348d6312
          20: stimulus=-2079326206; // 0x84100002
          21: stimulus=-1160008413; // 0xbadbad23
          22: stimulus=-2147478946; // 0x8000125e
          23: stimulus=881615634; // 0x348c6312
          24: stimulus=-2079189886; // 0x84121482
          25: stimulus=1143021570; // 0x44212002
          26: stimulus=-1160008413; // 0xbadbad23
          27: stimulus=-2147478946; // 0x8000125e
          28: stimulus=-249266174; // 0xf1248002
          29: stimulus=-1160008413; // 0xbadbad23
        endcase
      end
      3: begin
        case (index)
          0: stimulus=2147480382; // 0x7ffff33e
          1: stimulus=-3265; // 0xfffff33f
          2: stimulus=1610609454; // 0x5ffff32e
          3: stimulus=-3281; // 0xfffff32f
          4: stimulus=1073738526; // 0x3ffff31e
          5: stimulus=-3297; // 0xfffff31f
          6: stimulus=536867598; // 0x1ffff30e
          7: stimulus=-3313; // 0xfffff30f
          8: stimulus=-3250; // 0xfffff34e
          9: stimulus=-3250; // 0xfffff34e
          10: stimulus=-3249; // 0xfffff34f
          11: stimulus=-2147478690; // 0x8000135e
          12: stimulus=881680386; // 0x348d6002
          13: stimulus=-1160008397; // 0xbadbad33
          14: stimulus=-2147478690; // 0x8000135e
          15: stimulus=880967954; // 0x34828112
          16: stimulus=2; // 0x00000002
          17: stimulus=-1160008397; // 0xbadbad33
          18: stimulus=-2147478690; // 0x8000135e
          19: stimulus=881681170; // 0x348d6312
          20: stimulus=-2079326206; // 0x84100002
          21: stimulus=-1160008397; // 0xbadbad33
          22: stimulus=-2147478690; // 0x8000135e
          23: stimulus=881615634; // 0x348c6312
          24: stimulus=-2079189886; // 0x84121482
          25: stimulus=1143021570; // 0x44212002
          26: stimulus=-1160008397; // 0xbadbad33
          27: stimulus=-2147478690; // 0x8000135e
          28: stimulus=-249266174; // 0xf1248002
          29: stimulus=-1160008397; // 0xbadbad33
        endcase
      end
      4: begin
        case (index)
          0: stimulus=-3012; // 0xfffff43c
          1: stimulus=-3009; // 0xfffff43f
          2: stimulus=-1073744852; // 0xbffff42c
          3: stimulus=-3025; // 0xfffff42f
          4: stimulus=2147480604; // 0x7ffff41c
          5: stimulus=-3041; // 0xfffff41f
          6: stimulus=1073738764; // 0x3ffff40c
          7: stimulus=-3057; // 0xfffff40f
          8: stimulus=881680386; // 0x348d6002
          9: stimulus=-1160008381; // 0xbadbad43
          10: stimulus=-2147478436; // 0x8000145c
          11: stimulus=881680386; // 0x348d6002
          12: stimulus=-1160008381; // 0xbadbad43
          13: stimulus=-2147478436; // 0x8000145c
          14: stimulus=881680386; // 0x348d6002
          15: stimulus=-1160008381; // 0xbadbad43
          16: stimulus=-2147478436; // 0x8000145c
          17: stimulus=880967954; // 0x34828112
          18: stimulus=2; // 0x00000002
          19: stimulus=-1160008381; // 0xbadbad43
          20: stimulus=-2147478436; // 0x8000145c
          21: stimulus=881681170; // 0x348d6312
          22: stimulus=-2079326206; // 0x84100002
          23: stimulus=-1160008381; // 0xbadbad43
          24: stimulus=-2147478436; // 0x8000145c
          25: stimulus=881615634; // 0x348c6312
          26: stimulus=-2079189886; // 0x84121482
          27: stimulus=1143021570; // 0x44212002
          28: stimulus=-1160008381; // 0xbadbad43
          29: stimulus=-2147478436; // 0x8000145c
          30: stimulus=-249266174; // 0xf1248002
          31: stimulus=-1160008381; // 0xbadbad43
          32: stimulus=881680386; // 0x348d6002
          33: stimulus=-1160008381; // 0xbadbad43
          34: stimulus=880967954; // 0x34828112
          35: stimulus=2; // 0x00000002
          36: stimulus=-1160008381; // 0xbadbad43
          37: stimulus=881681170; // 0x348d6312
          38: stimulus=-2079326206; // 0x84100002
          39: stimulus=-1160008381; // 0xbadbad43
          40: stimulus=881615634; // 0x348c6312
          41: stimulus=-2079189886; // 0x84121482
          42: stimulus=1143021570; // 0x44212002
          43: stimulus=-1160008381; // 0xbadbad43
          44: stimulus=-249266174; // 0xf1248002
          45: stimulus=-1160008381; // 0xbadbad43
        endcase
      end
    endcase
  end
endfunction
analog function integer case_id;
  input port_id, index;
  integer port_id, index;
  begin
    case_id=0;
    case (port_id)
      0: begin
        case (index)
          2: case_id=1; // 0x00000001
          3: case_id=1; // 0x00000001
          4: case_id=2; // 0x00000002
          5: case_id=2; // 0x00000002
          6: case_id=3; // 0x00000003
          7: case_id=3; // 0x00000003
          8: case_id=4; // 0x00000004
          9: case_id=4; // 0x00000004
          10: case_id=4; // 0x00000004
          11: case_id=5; // 0x00000005
          12: case_id=5; // 0x00000005
          13: case_id=5; // 0x00000005
          14: case_id=6; // 0x00000006
          15: case_id=6; // 0x00000006
          16: case_id=6; // 0x00000006
          17: case_id=6; // 0x00000006
          18: case_id=7; // 0x00000007
          19: case_id=7; // 0x00000007
          20: case_id=7; // 0x00000007
          21: case_id=7; // 0x00000007
          22: case_id=8; // 0x00000008
          23: case_id=8; // 0x00000008
          24: case_id=8; // 0x00000008
          25: case_id=8; // 0x00000008
          26: case_id=8; // 0x00000008
          27: case_id=9; // 0x00000009
          28: case_id=9; // 0x00000009
          29: case_id=9; // 0x00000009
        endcase
      end
      1: begin
        case (index)
          0: case_id=10; // 0x0000000a
          1: case_id=10; // 0x0000000a
          2: case_id=11; // 0x0000000b
          3: case_id=11; // 0x0000000b
          4: case_id=12; // 0x0000000c
          5: case_id=12; // 0x0000000c
          6: case_id=13; // 0x0000000d
          7: case_id=13; // 0x0000000d
          8: case_id=14; // 0x0000000e
          9: case_id=14; // 0x0000000e
          10: case_id=14; // 0x0000000e
          11: case_id=15; // 0x0000000f
          12: case_id=15; // 0x0000000f
          13: case_id=15; // 0x0000000f
          14: case_id=16; // 0x00000010
          15: case_id=16; // 0x00000010
          16: case_id=16; // 0x00000010
          17: case_id=16; // 0x00000010
          18: case_id=17; // 0x00000011
          19: case_id=17; // 0x00000011
          20: case_id=17; // 0x00000011
          21: case_id=17; // 0x00000011
          22: case_id=18; // 0x00000012
          23: case_id=18; // 0x00000012
          24: case_id=18; // 0x00000012
          25: case_id=18; // 0x00000012
          26: case_id=18; // 0x00000012
          27: case_id=19; // 0x00000013
          28: case_id=19; // 0x00000013
          29: case_id=19; // 0x00000013
        endcase
      end
      2: begin
        case (index)
          0: case_id=20; // 0x00000014
          1: case_id=20; // 0x00000014
          2: case_id=21; // 0x00000015
          3: case_id=21; // 0x00000015
          4: case_id=22; // 0x00000016
          5: case_id=22; // 0x00000016
          6: case_id=23; // 0x00000017
          7: case_id=23; // 0x00000017
          8: case_id=24; // 0x00000018
          9: case_id=24; // 0x00000018
          10: case_id=24; // 0x00000018
          11: case_id=25; // 0x00000019
          12: case_id=25; // 0x00000019
          13: case_id=25; // 0x00000019
          14: case_id=26; // 0x0000001a
          15: case_id=26; // 0x0000001a
          16: case_id=26; // 0x0000001a
          17: case_id=26; // 0x0000001a
          18: case_id=27; // 0x0000001b
          19: case_id=27; // 0x0000001b
          20: case_id=27; // 0x0000001b
          21: case_id=27; // 0x0000001b
          22: case_id=28; // 0x0000001c
          23: case_id=28; // 0x0000001c
          24: case_id=28; // 0x0000001c
          25: case_id=28; // 0x0000001c
          26: case_id=28; // 0x0000001c
          27: case_id=29; // 0x0000001d
          28: case_id=29; // 0x0000001d
          29: case_id=29; // 0x0000001d
        endcase
      end
      3: begin
        case (index)
          0: case_id=30; // 0x0000001e
          1: case_id=30; // 0x0000001e
          2: case_id=31; // 0x0000001f
          3: case_id=31; // 0x0000001f
          4: case_id=32; // 0x00000020
          5: case_id=32; // 0x00000020
          6: case_id=33; // 0x00000021
          7: case_id=33; // 0x00000021
          8: case_id=34; // 0x00000022
          9: case_id=34; // 0x00000022
          10: case_id=34; // 0x00000022
          11: case_id=35; // 0x00000023
          12: case_id=35; // 0x00000023
          13: case_id=35; // 0x00000023
          14: case_id=36; // 0x00000024
          15: case_id=36; // 0x00000024
          16: case_id=36; // 0x00000024
          17: case_id=36; // 0x00000024
          18: case_id=37; // 0x00000025
          19: case_id=37; // 0x00000025
          20: case_id=37; // 0x00000025
          21: case_id=37; // 0x00000025
          22: case_id=38; // 0x00000026
          23: case_id=38; // 0x00000026
          24: case_id=38; // 0x00000026
          25: case_id=38; // 0x00000026
          26: case_id=38; // 0x00000026
          27: case_id=39; // 0x00000027
          28: case_id=39; // 0x00000027
          29: case_id=39; // 0x00000027
        endcase
      end
      4: begin
        case (index)
          0: case_id=40; // 0x00000028
          1: case_id=40; // 0x00000028
          2: case_id=41; // 0x00000029
          3: case_id=41; // 0x00000029
          4: case_id=42; // 0x0000002a
          5: case_id=42; // 0x0000002a
          6: case_id=43; // 0x0000002b
          7: case_id=43; // 0x0000002b
          8: case_id=44; // 0x0000002c
          9: case_id=44; // 0x0000002c
          10: case_id=45; // 0x0000002d
          11: case_id=45; // 0x0000002d
          12: case_id=45; // 0x0000002d
          13: case_id=46; // 0x0000002e
          14: case_id=46; // 0x0000002e
          15: case_id=46; // 0x0000002e
          16: case_id=47; // 0x0000002f
          17: case_id=47; // 0x0000002f
          18: case_id=47; // 0x0000002f
          19: case_id=47; // 0x0000002f
          20: case_id=48; // 0x00000030
          21: case_id=48; // 0x00000030
          22: case_id=48; // 0x00000030
          23: case_id=48; // 0x00000030
          24: case_id=49; // 0x00000031
          25: case_id=49; // 0x00000031
          26: case_id=49; // 0x00000031
          27: case_id=49; // 0x00000031
          28: case_id=49; // 0x00000031
          29: case_id=50; // 0x00000032
          30: case_id=50; // 0x00000032
          31: case_id=50; // 0x00000032
          32: case_id=51; // 0x00000033
          33: case_id=51; // 0x00000033
          34: case_id=52; // 0x00000034
          35: case_id=52; // 0x00000034
          36: case_id=52; // 0x00000034
          37: case_id=53; // 0x00000035
          38: case_id=53; // 0x00000035
          39: case_id=53; // 0x00000035
          40: case_id=54; // 0x00000036
          41: case_id=54; // 0x00000036
          42: case_id=54; // 0x00000036
          43: case_id=54; // 0x00000036
          44: case_id=55; // 0x00000037
          45: case_id=55; // 0x00000037
        endcase
      end
    endcase
  end
endfunction
analog function integer case_start;
  input port_id, index;
  integer port_id, index;
  begin
    case_start=0;
    case (port_id)
      0: begin
        case (index)
          0: case_start=1; // 0x00000001
          2: case_start=1; // 0x00000001
          4: case_start=1; // 0x00000001
          6: case_start=1; // 0x00000001
          8: case_start=1; // 0x00000001
          11: case_start=1; // 0x00000001
          14: case_start=1; // 0x00000001
          18: case_start=1; // 0x00000001
          22: case_start=1; // 0x00000001
          27: case_start=1; // 0x00000001
        endcase
      end
      1: begin
        case (index)
          0: case_start=1; // 0x00000001
          2: case_start=1; // 0x00000001
          4: case_start=1; // 0x00000001
          6: case_start=1; // 0x00000001
          8: case_start=1; // 0x00000001
          11: case_start=1; // 0x00000001
          14: case_start=1; // 0x00000001
          18: case_start=1; // 0x00000001
          22: case_start=1; // 0x00000001
          27: case_start=1; // 0x00000001
        endcase
      end
      2: begin
        case (index)
          0: case_start=1; // 0x00000001
          2: case_start=1; // 0x00000001
          4: case_start=1; // 0x00000001
          6: case_start=1; // 0x00000001
          8: case_start=1; // 0x00000001
          11: case_start=1; // 0x00000001
          14: case_start=1; // 0x00000001
          18: case_start=1; // 0x00000001
          22: case_start=1; // 0x00000001
          27: case_start=1; // 0x00000001
        endcase
      end
      3: begin
        case (index)
          0: case_start=1; // 0x00000001
          2: case_start=1; // 0x00000001
          4: case_start=1; // 0x00000001
          6: case_start=1; // 0x00000001
          8: case_start=1; // 0x00000001
          11: case_start=1; // 0x00000001
          14: case_start=1; // 0x00000001
          18: case_start=1; // 0x00000001
          22: case_start=1; // 0x00000001
          27: case_start=1; // 0x00000001
        endcase
      end
      4: begin
        case (index)
          0: case_start=1; // 0x00000001
          2: case_start=1; // 0x00000001
          4: case_start=1; // 0x00000001
          6: case_start=1; // 0x00000001
          8: case_start=1; // 0x00000001
          10: case_start=1; // 0x00000001
          13: case_start=1; // 0x00000001
          16: case_start=1; // 0x00000001
          20: case_start=1; // 0x00000001
          24: case_start=1; // 0x00000001
          29: case_start=1; // 0x00000001
          32: case_start=1; // 0x00000001
          34: case_start=1; // 0x00000001
          37: case_start=1; // 0x00000001
          40: case_start=1; // 0x00000001
          44: case_start=1; // 0x00000001
        endcase
      end
    endcase
  end
endfunction
analog function integer gold_case;
  input port_id, index;
  integer port_id, index;
  begin
    gold_case=0;
    case (port_id)
      0: begin
        case (index)
          1: gold_case=1; // 0x00000001
          2: gold_case=2; // 0x00000002
          3: gold_case=3; // 0x00000003
          4: gold_case=4; // 0x00000004
          5: gold_case=5; // 0x00000005
          6: gold_case=5; // 0x00000005
          7: gold_case=6; // 0x00000006
          8: gold_case=6; // 0x00000006
          9: gold_case=7; // 0x00000007
          10: gold_case=7; // 0x00000007
          11: gold_case=8; // 0x00000008
          12: gold_case=8; // 0x00000008
          13: gold_case=9; // 0x00000009
          14: gold_case=9; // 0x00000009
          15: gold_case=9; // 0x00000009
          16: gold_case=9; // 0x00000009
          17: gold_case=10; // 0x0000000a
          18: gold_case=11; // 0x0000000b
          19: gold_case=12; // 0x0000000c
          20: gold_case=13; // 0x0000000d
          21: gold_case=14; // 0x0000000e
          22: gold_case=15; // 0x0000000f
          23: gold_case=15; // 0x0000000f
          24: gold_case=16; // 0x00000010
          25: gold_case=16; // 0x00000010
          26: gold_case=17; // 0x00000011
          27: gold_case=17; // 0x00000011
          28: gold_case=18; // 0x00000012
          29: gold_case=18; // 0x00000012
          30: gold_case=19; // 0x00000013
          31: gold_case=19; // 0x00000013
          32: gold_case=19; // 0x00000013
          33: gold_case=19; // 0x00000013
          34: gold_case=20; // 0x00000014
          35: gold_case=21; // 0x00000015
          36: gold_case=22; // 0x00000016
          37: gold_case=23; // 0x00000017
          38: gold_case=24; // 0x00000018
          39: gold_case=25; // 0x00000019
          40: gold_case=25; // 0x00000019
          41: gold_case=26; // 0x0000001a
          42: gold_case=26; // 0x0000001a
          43: gold_case=27; // 0x0000001b
          44: gold_case=27; // 0x0000001b
          45: gold_case=28; // 0x0000001c
          46: gold_case=28; // 0x0000001c
          47: gold_case=29; // 0x0000001d
          48: gold_case=29; // 0x0000001d
          49: gold_case=29; // 0x0000001d
          50: gold_case=29; // 0x0000001d
          51: gold_case=30; // 0x0000001e
          52: gold_case=31; // 0x0000001f
          53: gold_case=32; // 0x00000020
          54: gold_case=33; // 0x00000021
          55: gold_case=34; // 0x00000022
          56: gold_case=35; // 0x00000023
          57: gold_case=35; // 0x00000023
          58: gold_case=36; // 0x00000024
          59: gold_case=36; // 0x00000024
          60: gold_case=37; // 0x00000025
          61: gold_case=37; // 0x00000025
          62: gold_case=38; // 0x00000026
          63: gold_case=38; // 0x00000026
          64: gold_case=39; // 0x00000027
          65: gold_case=39; // 0x00000027
          66: gold_case=39; // 0x00000027
          67: gold_case=39; // 0x00000027
          68: gold_case=40; // 0x00000028
          69: gold_case=41; // 0x00000029
          70: gold_case=42; // 0x0000002a
          71: gold_case=43; // 0x0000002b
          72: gold_case=44; // 0x0000002c
          73: gold_case=44; // 0x0000002c
          74: gold_case=45; // 0x0000002d
          75: gold_case=45; // 0x0000002d
          76: gold_case=46; // 0x0000002e
          77: gold_case=46; // 0x0000002e
          78: gold_case=47; // 0x0000002f
          79: gold_case=47; // 0x0000002f
          80: gold_case=48; // 0x00000030
          81: gold_case=48; // 0x00000030
          82: gold_case=49; // 0x00000031
          83: gold_case=49; // 0x00000031
          84: gold_case=50; // 0x00000032
          85: gold_case=50; // 0x00000032
          86: gold_case=50; // 0x00000032
          87: gold_case=50; // 0x00000032
          88: gold_case=51; // 0x00000033
          89: gold_case=51; // 0x00000033
          90: gold_case=52; // 0x00000034
          91: gold_case=52; // 0x00000034
          92: gold_case=53; // 0x00000035
          93: gold_case=53; // 0x00000035
          94: gold_case=54; // 0x00000036
          95: gold_case=54; // 0x00000036
          96: gold_case=55; // 0x00000037
          97: gold_case=55; // 0x00000037
          98: gold_case=55; // 0x00000037
          99: gold_case=55; // 0x00000037
        endcase
      end
    endcase
  end
endfunction
analog function integer gold_port;
  input port_id, index;
  integer port_id, index;
  begin
    gold_port=0;
    case (port_id)
      0: begin
        case (index)
          0: gold_port=3; // 0x00000003
          1: gold_port=2; // 0x00000002
          2: gold_port=1; // 0x00000001
          4: gold_port=4; // 0x00000004
          5: gold_port=2; // 0x00000002
          6: gold_port=3; // 0x00000003
          7: gold_port=2; // 0x00000002
          8: gold_port=3; // 0x00000003
          9: gold_port=2; // 0x00000002
          10: gold_port=3; // 0x00000003
          11: gold_port=2; // 0x00000002
          12: gold_port=3; // 0x00000003
          14: gold_port=1; // 0x00000001
          15: gold_port=2; // 0x00000002
          16: gold_port=3; // 0x00000003
          17: gold_port=3; // 0x00000003
          18: gold_port=2; // 0x00000002
          19: gold_port=1; // 0x00000001
          21: gold_port=4; // 0x00000004
          22: gold_port=2; // 0x00000002
          23: gold_port=3; // 0x00000003
          24: gold_port=2; // 0x00000002
          25: gold_port=3; // 0x00000003
          26: gold_port=2; // 0x00000002
          27: gold_port=3; // 0x00000003
          28: gold_port=2; // 0x00000002
          29: gold_port=3; // 0x00000003
          31: gold_port=1; // 0x00000001
          32: gold_port=2; // 0x00000002
          33: gold_port=3; // 0x00000003
          34: gold_port=3; // 0x00000003
          35: gold_port=2; // 0x00000002
          36: gold_port=1; // 0x00000001
          38: gold_port=4; // 0x00000004
          39: gold_port=2; // 0x00000002
          40: gold_port=3; // 0x00000003
          41: gold_port=2; // 0x00000002
          42: gold_port=3; // 0x00000003
          43: gold_port=2; // 0x00000002
          44: gold_port=3; // 0x00000003
          45: gold_port=2; // 0x00000002
          46: gold_port=3; // 0x00000003
          48: gold_port=1; // 0x00000001
          49: gold_port=2; // 0x00000002
          50: gold_port=3; // 0x00000003
          51: gold_port=3; // 0x00000003
          52: gold_port=2; // 0x00000002
          53: gold_port=1; // 0x00000001
          55: gold_port=4; // 0x00000004
          56: gold_port=2; // 0x00000002
          57: gold_port=3; // 0x00000003
          58: gold_port=2; // 0x00000002
          59: gold_port=3; // 0x00000003
          60: gold_port=2; // 0x00000002
          61: gold_port=3; // 0x00000003
          62: gold_port=2; // 0x00000002
          63: gold_port=3; // 0x00000003
          65: gold_port=1; // 0x00000001
          66: gold_port=2; // 0x00000002
          67: gold_port=3; // 0x00000003
          68: gold_port=3; // 0x00000003
          69: gold_port=2; // 0x00000002
          70: gold_port=1; // 0x00000001
          72: gold_port=2; // 0x00000002
          73: gold_port=3; // 0x00000003
          74: gold_port=2; // 0x00000002
          75: gold_port=3; // 0x00000003
          76: gold_port=2; // 0x00000002
          77: gold_port=3; // 0x00000003
          78: gold_port=2; // 0x00000002
          79: gold_port=3; // 0x00000003
          80: gold_port=2; // 0x00000002
          81: gold_port=3; // 0x00000003
          82: gold_port=2; // 0x00000002
          83: gold_port=3; // 0x00000003
          85: gold_port=1; // 0x00000001
          86: gold_port=2; // 0x00000002
          87: gold_port=3; // 0x00000003
          88: gold_port=2; // 0x00000002
          89: gold_port=3; // 0x00000003
          90: gold_port=2; // 0x00000002
          91: gold_port=3; // 0x00000003
          92: gold_port=2; // 0x00000002
          93: gold_port=3; // 0x00000003
          94: gold_port=2; // 0x00000002
          95: gold_port=3; // 0x00000003
          97: gold_port=1; // 0x00000001
          98: gold_port=2; // 0x00000002
          99: gold_port=3; // 0x00000003
        endcase
      end
    endcase
  end
endfunction
analog function integer gold_len;
  input port_id, index;
  integer port_id, index;
  begin
    gold_len=0;
    case (port_id)
      0: begin
        case (index)
          0: gold_len=2; // 0x00000002
          1: gold_len=2; // 0x00000002
          2: gold_len=2; // 0x00000002
          3: gold_len=2; // 0x00000002
          4: gold_len=3; // 0x00000003
          5: gold_len=2; // 0x00000002
          6: gold_len=2; // 0x00000002
          7: gold_len=2; // 0x00000002
          8: gold_len=2; // 0x00000002
          9: gold_len=2; // 0x00000002
          10: gold_len=2; // 0x00000002
          11: gold_len=3; // 0x00000003
          12: gold_len=3; // 0x00000003
          13: gold_len=2; // 0x00000002
          14: gold_len=2; // 0x00000002
          15: gold_len=2; // 0x00000002
          16: gold_len=2; // 0x00000002
          17: gold_len=2; // 0x00000002
          18: gold_len=2; // 0x00000002
          19: gold_len=2; // 0x00000002
          20: gold_len=2; // 0x00000002
          21: gold_len=3; // 0x00000003
          22: gold_len=2; // 0x00000002
          23: gold_len=2; // 0x00000002
          24: gold_len=2; // 0x00000002
          25: gold_len=2; // 0x00000002
          26: gold_len=2; // 0x00000002
          27: gold_len=2; // 0x00000002
          28: gold_len=3; // 0x00000003
          29: gold_len=3; // 0x00000003
          30: gold_len=2; // 0x00000002
          31: gold_len=2; // 0x00000002
          32: gold_len=2; // 0x00000002
          33: gold_len=2; // 0x00000002
          34: gold_len=2; // 0x00000002
          35: gold_len=2; // 0x00000002
          36: gold_len=2; // 0x00000002
          37: gold_len=2; // 0x00000002
          38: gold_len=3; // 0x00000003
          39: gold_len=2; // 0x00000002
          40: gold_len=2; // 0x00000002
          41: gold_len=2; // 0x00000002
          42: gold_len=2; // 0x00000002
          43: gold_len=2; // 0x00000002
          44: gold_len=2; // 0x00000002
          45: gold_len=3; // 0x00000003
          46: gold_len=3; // 0x00000003
          47: gold_len=2; // 0x00000002
          48: gold_len=2; // 0x00000002
          49: gold_len=2; // 0x00000002
          50: gold_len=2; // 0x00000002
          51: gold_len=2; // 0x00000002
          52: gold_len=2; // 0x00000002
          53: gold_len=2; // 0x00000002
          54: gold_len=2; // 0x00000002
          55: gold_len=3; // 0x00000003
          56: gold_len=2; // 0x00000002
          57: gold_len=2; // 0x00000002
          58: gold_len=2; // 0x00000002
          59: gold_len=2; // 0x00000002
          60: gold_len=2; // 0x00000002
          61: gold_len=2; // 0x00000002
          62: gold_len=3; // 0x00000003
          63: gold_len=3; // 0x00000003
          64: gold_len=2; // 0x00000002
          65: gold_len=2; // 0x00000002
          66: gold_len=2; // 0x00000002
          67: gold_len=2; // 0x00000002
          68: gold_len=2; // 0x00000002
          69: gold_len=2; // 0x00000002
          70: gold_len=2; // 0x00000002
          71: gold_len=2; // 0x00000002
          72: gold_len=2; // 0x00000002
          73: gold_len=2; // 0x00000002
          74: gold_len=2; // 0x00000002
          75: gold_len=2; // 0x00000002
          76: gold_len=2; // 0x00000002
          77: gold_len=2; // 0x00000002
          78: gold_len=2; // 0x00000002
          79: gold_len=2; // 0x00000002
          80: gold_len=2; // 0x00000002
          81: gold_len=2; // 0x00000002
          82: gold_len=3; // 0x00000003
          83: gold_len=3; // 0x00000003
          84: gold_len=2; // 0x00000002
          85: gold_len=2; // 0x00000002
          86: gold_len=2; // 0x00000002
          87: gold_len=2; // 0x00000002
          88: gold_len=2; // 0x00000002
          89: gold_len=2; // 0x00000002
          90: gold_len=2; // 0x00000002
          91: gold_len=2; // 0x00000002
          92: gold_len=2; // 0x00000002
          93: gold_len=2; // 0x00000002
          94: gold_len=3; // 0x00000003
          95: gold_len=3; // 0x00000003
          96: gold_len=2; // 0x00000002
          97: gold_len=2; // 0x00000002
          98: gold_len=2; // 0x00000002
          99: gold_len=2; // 0x00000002
        endcase
      end
    endcase
  end
endfunction
analog function integer gold_word;
  input port_id, index;
  integer port_id, index;
  begin
    gold_word=0;
    case (port_id)
      0: begin
        case (index)
          0: gold_word=-61378; // 0xffff103e
          1: gold_word=-4033; // 0xfffff03f
          16: gold_word=-61394; // 0xffff102e
          17: gold_word=-4049; // 0xfffff02f
          32: gold_word=-61410; // 0xffff101e
          33: gold_word=-4065; // 0xfffff01f
          48: gold_word=-61426; // 0xffff100e
          49: gold_word=-4081; // 0xfffff00f
          64: gold_word=-12210; // 0xffffd04e
          65: gold_word=-4018; // 0xfffff04e
          66: gold_word=-4017; // 0xfffff04f
          80: gold_word=1291845634; // 0x4d000002
          81: gold_word=-1160008445; // 0xbadbad03
          96: gold_word=-2046820350; // 0x86000002
          97: gold_word=-1160008445; // 0xbadbad03
          112: gold_word=1108344834; // 0x42100002
          113: gold_word=-1160008445; // 0xbadbad03
          128: gold_word=-2012217342; // 0x88100002
          129: gold_word=-1160008445; // 0xbadbad03
          144: gold_word=1295089666; // 0x4d318002
          145: gold_word=-1160008445; // 0xbadbad03
          160: gold_word=-2042560510; // 0x86410002
          161: gold_word=-1160008445; // 0xbadbad03
          176: gold_word=1278284306; // 0x4c311212
          177: gold_word=1142947842; // 0x44200002
          178: gold_word=-1160008445; // 0xbadbad03
          192: gold_word=-2038151150; // 0x86844812
          193: gold_word=536870914; // 0x20000002
          194: gold_word=-1160008445; // 0xbadbad03
          208: gold_word=268435458; // 0x10000002
          209: gold_word=-1160008445; // 0xbadbad03
          224: gold_word=536870914; // 0x20000002
          225: gold_word=-1160008445; // 0xbadbad03
          240: gold_word=1073741826; // 0x40000002
          241: gold_word=-1160008445; // 0xbadbad03
          256: gold_word=-2147483646; // 0x80000002
          257: gold_word=-1160008445; // 0xbadbad03
          272: gold_word=-61122; // 0xffff113e
          273: gold_word=-3777; // 0xfffff13f
          288: gold_word=-61138; // 0xffff112e
          289: gold_word=-3793; // 0xfffff12f
          304: gold_word=-61154; // 0xffff111e
          305: gold_word=-3809; // 0xfffff11f
          320: gold_word=-61170; // 0xffff110e
          321: gold_word=-3825; // 0xfffff10f
          336: gold_word=-11954; // 0xffffd14e
          337: gold_word=-3762; // 0xfffff14e
          338: gold_word=-3761; // 0xfffff14f
          352: gold_word=1291845634; // 0x4d000002
          353: gold_word=-1160008429; // 0xbadbad13
          368: gold_word=-2046820350; // 0x86000002
          369: gold_word=-1160008429; // 0xbadbad13
          384: gold_word=1108344834; // 0x42100002
          385: gold_word=-1160008429; // 0xbadbad13
          400: gold_word=-2012217342; // 0x88100002
          401: gold_word=-1160008429; // 0xbadbad13
          416: gold_word=1295089666; // 0x4d318002
          417: gold_word=-1160008429; // 0xbadbad13
          432: gold_word=-2042560510; // 0x86410002
          433: gold_word=-1160008429; // 0xbadbad13
          448: gold_word=1278284306; // 0x4c311212
          449: gold_word=1142947842; // 0x44200002
          450: gold_word=-1160008429; // 0xbadbad13
          464: gold_word=-2038151150; // 0x86844812
          465: gold_word=536870914; // 0x20000002
          466: gold_word=-1160008429; // 0xbadbad13
          480: gold_word=268435458; // 0x10000002
          481: gold_word=-1160008429; // 0xbadbad13
          496: gold_word=536870914; // 0x20000002
          497: gold_word=-1160008429; // 0xbadbad13
          512: gold_word=1073741826; // 0x40000002
          513: gold_word=-1160008429; // 0xbadbad13
          528: gold_word=-2147483646; // 0x80000002
          529: gold_word=-1160008429; // 0xbadbad13
          544: gold_word=-60866; // 0xffff123e
          545: gold_word=-3521; // 0xfffff23f
          560: gold_word=-60882; // 0xffff122e
          561: gold_word=-3537; // 0xfffff22f
          576: gold_word=-60898; // 0xffff121e
          577: gold_word=-3553; // 0xfffff21f
          592: gold_word=-60914; // 0xffff120e
          593: gold_word=-3569; // 0xfffff20f
          608: gold_word=-11698; // 0xffffd24e
          609: gold_word=-3506; // 0xfffff24e
          610: gold_word=-3505; // 0xfffff24f
          624: gold_word=1291845634; // 0x4d000002
          625: gold_word=-1160008413; // 0xbadbad23
          640: gold_word=-2046820350; // 0x86000002
          641: gold_word=-1160008413; // 0xbadbad23
          656: gold_word=1108344834; // 0x42100002
          657: gold_word=-1160008413; // 0xbadbad23
          672: gold_word=-2012217342; // 0x88100002
          673: gold_word=-1160008413; // 0xbadbad23
          688: gold_word=1295089666; // 0x4d318002
          689: gold_word=-1160008413; // 0xbadbad23
          704: gold_word=-2042560510; // 0x86410002
          705: gold_word=-1160008413; // 0xbadbad23
          720: gold_word=1278284306; // 0x4c311212
          721: gold_word=1142947842; // 0x44200002
          722: gold_word=-1160008413; // 0xbadbad23
          736: gold_word=-2038151150; // 0x86844812
          737: gold_word=536870914; // 0x20000002
          738: gold_word=-1160008413; // 0xbadbad23
          752: gold_word=268435458; // 0x10000002
          753: gold_word=-1160008413; // 0xbadbad23
          768: gold_word=536870914; // 0x20000002
          769: gold_word=-1160008413; // 0xbadbad23
          784: gold_word=1073741826; // 0x40000002
          785: gold_word=-1160008413; // 0xbadbad23
          800: gold_word=-2147483646; // 0x80000002
          801: gold_word=-1160008413; // 0xbadbad23
          816: gold_word=-60610; // 0xffff133e
          817: gold_word=-3265; // 0xfffff33f
          832: gold_word=-60626; // 0xffff132e
          833: gold_word=-3281; // 0xfffff32f
          848: gold_word=-60642; // 0xffff131e
          849: gold_word=-3297; // 0xfffff31f
          864: gold_word=-60658; // 0xffff130e
          865: gold_word=-3313; // 0xfffff30f
          880: gold_word=-11442; // 0xffffd34e
          881: gold_word=-3250; // 0xfffff34e
          882: gold_word=-3249; // 0xfffff34f
          896: gold_word=1291845634; // 0x4d000002
          897: gold_word=-1160008397; // 0xbadbad33
          912: gold_word=-2046820350; // 0x86000002
          913: gold_word=-1160008397; // 0xbadbad33
          928: gold_word=1108344834; // 0x42100002
          929: gold_word=-1160008397; // 0xbadbad33
          944: gold_word=-2012217342; // 0x88100002
          945: gold_word=-1160008397; // 0xbadbad33
          960: gold_word=1295089666; // 0x4d318002
          961: gold_word=-1160008397; // 0xbadbad33
          976: gold_word=-2042560510; // 0x86410002
          977: gold_word=-1160008397; // 0xbadbad33
          992: gold_word=1278284306; // 0x4c311212
          993: gold_word=1142947842; // 0x44200002
          994: gold_word=-1160008397; // 0xbadbad33
          1008: gold_word=-2038151150; // 0x86844812
          1009: gold_word=536870914; // 0x20000002
          1010: gold_word=-1160008397; // 0xbadbad33
          1024: gold_word=268435458; // 0x10000002
          1025: gold_word=-1160008397; // 0xbadbad33
          1040: gold_word=536870914; // 0x20000002
          1041: gold_word=-1160008397; // 0xbadbad33
          1056: gold_word=1073741826; // 0x40000002
          1057: gold_word=-1160008397; // 0xbadbad33
          1072: gold_word=-2147483646; // 0x80000002
          1073: gold_word=-1160008397; // 0xbadbad33
          1088: gold_word=-27588; // 0xffff943c
          1089: gold_word=-3009; // 0xfffff43f
          1104: gold_word=-27604; // 0xffff942c
          1105: gold_word=-3025; // 0xfffff42f
          1120: gold_word=-27620; // 0xffff941c
          1121: gold_word=-3041; // 0xfffff41f
          1136: gold_word=-27636; // 0xffff940c
          1137: gold_word=-3057; // 0xfffff40f
          1152: gold_word=1291845634; // 0x4d000002
          1153: gold_word=-1160008381; // 0xbadbad43
          1168: gold_word=-2046820350; // 0x86000002
          1169: gold_word=-1160008381; // 0xbadbad43
          1184: gold_word=1291845634; // 0x4d000002
          1185: gold_word=-1160008381; // 0xbadbad43
          1200: gold_word=-2046820350; // 0x86000002
          1201: gold_word=-1160008381; // 0xbadbad43
          1216: gold_word=1291845634; // 0x4d000002
          1217: gold_word=-1160008381; // 0xbadbad43
          1232: gold_word=-2046820350; // 0x86000002
          1233: gold_word=-1160008381; // 0xbadbad43
          1248: gold_word=1108344834; // 0x42100002
          1249: gold_word=-1160008381; // 0xbadbad43
          1264: gold_word=-2012217342; // 0x88100002
          1265: gold_word=-1160008381; // 0xbadbad43
          1280: gold_word=1295089666; // 0x4d318002
          1281: gold_word=-1160008381; // 0xbadbad43
          1296: gold_word=-2042560510; // 0x86410002
          1297: gold_word=-1160008381; // 0xbadbad43
          1312: gold_word=1278284306; // 0x4c311212
          1313: gold_word=1142947842; // 0x44200002
          1314: gold_word=-1160008381; // 0xbadbad43
          1328: gold_word=-2038151150; // 0x86844812
          1329: gold_word=536870914; // 0x20000002
          1330: gold_word=-1160008381; // 0xbadbad43
          1344: gold_word=268435458; // 0x10000002
          1345: gold_word=-1160008381; // 0xbadbad43
          1360: gold_word=536870914; // 0x20000002
          1361: gold_word=-1160008381; // 0xbadbad43
          1376: gold_word=1073741826; // 0x40000002
          1377: gold_word=-1160008381; // 0xbadbad43
          1392: gold_word=-2147483646; // 0x80000002
          1393: gold_word=-1160008381; // 0xbadbad43
          1408: gold_word=1291845634; // 0x4d000002
          1409: gold_word=-1160008381; // 0xbadbad43
          1424: gold_word=-2046820350; // 0x86000002
          1425: gold_word=-1160008381; // 0xbadbad43
          1440: gold_word=1108344834; // 0x42100002
          1441: gold_word=-1160008381; // 0xbadbad43
          1456: gold_word=-2012217342; // 0x88100002
          1457: gold_word=-1160008381; // 0xbadbad43
          1472: gold_word=1295089666; // 0x4d318002
          1473: gold_word=-1160008381; // 0xbadbad43
          1488: gold_word=-2042560510; // 0x86410002
          1489: gold_word=-1160008381; // 0xbadbad43
          1504: gold_word=1278284306; // 0x4c311212
          1505: gold_word=1142947842; // 0x44200002
          1506: gold_word=-1160008381; // 0xbadbad43
          1520: gold_word=-2038151150; // 0x86844812
          1521: gold_word=536870914; // 0x20000002
          1522: gold_word=-1160008381; // 0xbadbad43
          1536: gold_word=268435458; // 0x10000002
          1537: gold_word=-1160008381; // 0xbadbad43
          1552: gold_word=536870914; // 0x20000002
          1553: gold_word=-1160008381; // 0xbadbad43
          1568: gold_word=1073741826; // 0x40000002
          1569: gold_word=-1160008381; // 0xbadbad43
          1584: gold_word=-2147483646; // 0x80000002
          1585: gold_word=-1160008381; // 0xbadbad43
        endcase
      end
    endcase
  end
endfunction
// Supply-current sampling continues after the functional round, with reset low.
parameter real IDLE_SETTLE=20n from (0:inf);
parameter real IDLE_WINDOW=20n from (0:inf);
parameter real IDLE_MARGIN=1n from (0:inf);
integer idle_started, idle_completed;
real idle_start;
analog begin
  @(initial_step) begin
    idle_start=-1; idle_started=0; idle_completed=0;
    active=0; finished=0; failure=0; reported=0;
    threshold=0.5*SUPPLY; stop_after=-1; release_time=-1;
    for (j=0;j<5;j=j+1) begin tx_index[j]=0; tx_phase[j]=0; tx_valid[j]=0; tx_word[j]=0; end
    for (j=0;j<5;j=j+1) begin rx_index[j]=0; rx_phase[j]=0; ack[j]=0; held[j]=0; end
    for (j=0;j<5;j=j+1) length[j]=0;
    for (j=0;j<80;j=j+1) packet[j]=0;
    for (j=0;j<100;j=j+1) hits[j]=0;
    for (j=0;j<56;j=j+1) issued[j]=0;
    if (SUPPLY<=0) begin failure=1; $display("SIM_ERROR reason=invalid_supply"); end
  end
  @(timer(CHECK_START,TICK)) begin
    input_spacer[0]=1;
    if (V(C0i_t_0)>=threshold || V(C0i_f_0)>=threshold) input_spacer[0]=0;
    if (V(C0i_t_1)>=threshold || V(C0i_f_1)>=threshold) input_spacer[0]=0;
    if (V(C0i_t_2)>=threshold || V(C0i_f_2)>=threshold) input_spacer[0]=0;
    if (V(C0i_t_3)>=threshold || V(C0i_f_3)>=threshold) input_spacer[0]=0;
    if (V(C0i_t_4)>=threshold || V(C0i_f_4)>=threshold) input_spacer[0]=0;
    if (V(C0i_t_5)>=threshold || V(C0i_f_5)>=threshold) input_spacer[0]=0;
    if (V(C0i_t_6)>=threshold || V(C0i_f_6)>=threshold) input_spacer[0]=0;
    if (V(C0i_t_7)>=threshold || V(C0i_f_7)>=threshold) input_spacer[0]=0;
    if (V(C0i_t_8)>=threshold || V(C0i_f_8)>=threshold) input_spacer[0]=0;
    if (V(C0i_t_9)>=threshold || V(C0i_f_9)>=threshold) input_spacer[0]=0;
    if (V(C0i_t_10)>=threshold || V(C0i_f_10)>=threshold) input_spacer[0]=0;
    if (V(C0i_t_11)>=threshold || V(C0i_f_11)>=threshold) input_spacer[0]=0;
    if (V(C0i_t_12)>=threshold || V(C0i_f_12)>=threshold) input_spacer[0]=0;
    if (V(C0i_t_13)>=threshold || V(C0i_f_13)>=threshold) input_spacer[0]=0;
    if (V(C0i_t_14)>=threshold || V(C0i_f_14)>=threshold) input_spacer[0]=0;
    if (V(C0i_t_15)>=threshold || V(C0i_f_15)>=threshold) input_spacer[0]=0;
    if (V(C0i_t_16)>=threshold || V(C0i_f_16)>=threshold) input_spacer[0]=0;
    if (V(C0i_t_17)>=threshold || V(C0i_f_17)>=threshold) input_spacer[0]=0;
    if (V(C0i_t_18)>=threshold || V(C0i_f_18)>=threshold) input_spacer[0]=0;
    if (V(C0i_t_19)>=threshold || V(C0i_f_19)>=threshold) input_spacer[0]=0;
    if (V(C0i_t_20)>=threshold || V(C0i_f_20)>=threshold) input_spacer[0]=0;
    if (V(C0i_t_21)>=threshold || V(C0i_f_21)>=threshold) input_spacer[0]=0;
    if (V(C0i_t_22)>=threshold || V(C0i_f_22)>=threshold) input_spacer[0]=0;
    if (V(C0i_t_23)>=threshold || V(C0i_f_23)>=threshold) input_spacer[0]=0;
    if (V(C0i_t_24)>=threshold || V(C0i_f_24)>=threshold) input_spacer[0]=0;
    if (V(C0i_t_25)>=threshold || V(C0i_f_25)>=threshold) input_spacer[0]=0;
    if (V(C0i_t_26)>=threshold || V(C0i_f_26)>=threshold) input_spacer[0]=0;
    if (V(C0i_t_27)>=threshold || V(C0i_f_27)>=threshold) input_spacer[0]=0;
    if (V(C0i_t_28)>=threshold || V(C0i_f_28)>=threshold) input_spacer[0]=0;
    if (V(C0i_t_29)>=threshold || V(C0i_f_29)>=threshold) input_spacer[0]=0;
    if (V(C0i_t_30)>=threshold || V(C0i_f_30)>=threshold) input_spacer[0]=0;
    if (V(C0i_t_31)>=threshold || V(C0i_f_31)>=threshold) input_spacer[0]=0;
    input_spacer[1]=1;
    if (V(C1i_t_0)>=threshold || V(C1i_f_0)>=threshold) input_spacer[1]=0;
    if (V(C1i_t_1)>=threshold || V(C1i_f_1)>=threshold) input_spacer[1]=0;
    if (V(C1i_t_2)>=threshold || V(C1i_f_2)>=threshold) input_spacer[1]=0;
    if (V(C1i_t_3)>=threshold || V(C1i_f_3)>=threshold) input_spacer[1]=0;
    if (V(C1i_t_4)>=threshold || V(C1i_f_4)>=threshold) input_spacer[1]=0;
    if (V(C1i_t_5)>=threshold || V(C1i_f_5)>=threshold) input_spacer[1]=0;
    if (V(C1i_t_6)>=threshold || V(C1i_f_6)>=threshold) input_spacer[1]=0;
    if (V(C1i_t_7)>=threshold || V(C1i_f_7)>=threshold) input_spacer[1]=0;
    if (V(C1i_t_8)>=threshold || V(C1i_f_8)>=threshold) input_spacer[1]=0;
    if (V(C1i_t_9)>=threshold || V(C1i_f_9)>=threshold) input_spacer[1]=0;
    if (V(C1i_t_10)>=threshold || V(C1i_f_10)>=threshold) input_spacer[1]=0;
    if (V(C1i_t_11)>=threshold || V(C1i_f_11)>=threshold) input_spacer[1]=0;
    if (V(C1i_t_12)>=threshold || V(C1i_f_12)>=threshold) input_spacer[1]=0;
    if (V(C1i_t_13)>=threshold || V(C1i_f_13)>=threshold) input_spacer[1]=0;
    if (V(C1i_t_14)>=threshold || V(C1i_f_14)>=threshold) input_spacer[1]=0;
    if (V(C1i_t_15)>=threshold || V(C1i_f_15)>=threshold) input_spacer[1]=0;
    if (V(C1i_t_16)>=threshold || V(C1i_f_16)>=threshold) input_spacer[1]=0;
    if (V(C1i_t_17)>=threshold || V(C1i_f_17)>=threshold) input_spacer[1]=0;
    if (V(C1i_t_18)>=threshold || V(C1i_f_18)>=threshold) input_spacer[1]=0;
    if (V(C1i_t_19)>=threshold || V(C1i_f_19)>=threshold) input_spacer[1]=0;
    if (V(C1i_t_20)>=threshold || V(C1i_f_20)>=threshold) input_spacer[1]=0;
    if (V(C1i_t_21)>=threshold || V(C1i_f_21)>=threshold) input_spacer[1]=0;
    if (V(C1i_t_22)>=threshold || V(C1i_f_22)>=threshold) input_spacer[1]=0;
    if (V(C1i_t_23)>=threshold || V(C1i_f_23)>=threshold) input_spacer[1]=0;
    if (V(C1i_t_24)>=threshold || V(C1i_f_24)>=threshold) input_spacer[1]=0;
    if (V(C1i_t_25)>=threshold || V(C1i_f_25)>=threshold) input_spacer[1]=0;
    if (V(C1i_t_26)>=threshold || V(C1i_f_26)>=threshold) input_spacer[1]=0;
    if (V(C1i_t_27)>=threshold || V(C1i_f_27)>=threshold) input_spacer[1]=0;
    if (V(C1i_t_28)>=threshold || V(C1i_f_28)>=threshold) input_spacer[1]=0;
    if (V(C1i_t_29)>=threshold || V(C1i_f_29)>=threshold) input_spacer[1]=0;
    if (V(C1i_t_30)>=threshold || V(C1i_f_30)>=threshold) input_spacer[1]=0;
    if (V(C1i_t_31)>=threshold || V(C1i_f_31)>=threshold) input_spacer[1]=0;
    input_spacer[2]=1;
    if (V(C2i_t_0)>=threshold || V(C2i_f_0)>=threshold) input_spacer[2]=0;
    if (V(C2i_t_1)>=threshold || V(C2i_f_1)>=threshold) input_spacer[2]=0;
    if (V(C2i_t_2)>=threshold || V(C2i_f_2)>=threshold) input_spacer[2]=0;
    if (V(C2i_t_3)>=threshold || V(C2i_f_3)>=threshold) input_spacer[2]=0;
    if (V(C2i_t_4)>=threshold || V(C2i_f_4)>=threshold) input_spacer[2]=0;
    if (V(C2i_t_5)>=threshold || V(C2i_f_5)>=threshold) input_spacer[2]=0;
    if (V(C2i_t_6)>=threshold || V(C2i_f_6)>=threshold) input_spacer[2]=0;
    if (V(C2i_t_7)>=threshold || V(C2i_f_7)>=threshold) input_spacer[2]=0;
    if (V(C2i_t_8)>=threshold || V(C2i_f_8)>=threshold) input_spacer[2]=0;
    if (V(C2i_t_9)>=threshold || V(C2i_f_9)>=threshold) input_spacer[2]=0;
    if (V(C2i_t_10)>=threshold || V(C2i_f_10)>=threshold) input_spacer[2]=0;
    if (V(C2i_t_11)>=threshold || V(C2i_f_11)>=threshold) input_spacer[2]=0;
    if (V(C2i_t_12)>=threshold || V(C2i_f_12)>=threshold) input_spacer[2]=0;
    if (V(C2i_t_13)>=threshold || V(C2i_f_13)>=threshold) input_spacer[2]=0;
    if (V(C2i_t_14)>=threshold || V(C2i_f_14)>=threshold) input_spacer[2]=0;
    if (V(C2i_t_15)>=threshold || V(C2i_f_15)>=threshold) input_spacer[2]=0;
    if (V(C2i_t_16)>=threshold || V(C2i_f_16)>=threshold) input_spacer[2]=0;
    if (V(C2i_t_17)>=threshold || V(C2i_f_17)>=threshold) input_spacer[2]=0;
    if (V(C2i_t_18)>=threshold || V(C2i_f_18)>=threshold) input_spacer[2]=0;
    if (V(C2i_t_19)>=threshold || V(C2i_f_19)>=threshold) input_spacer[2]=0;
    if (V(C2i_t_20)>=threshold || V(C2i_f_20)>=threshold) input_spacer[2]=0;
    if (V(C2i_t_21)>=threshold || V(C2i_f_21)>=threshold) input_spacer[2]=0;
    if (V(C2i_t_22)>=threshold || V(C2i_f_22)>=threshold) input_spacer[2]=0;
    if (V(C2i_t_23)>=threshold || V(C2i_f_23)>=threshold) input_spacer[2]=0;
    if (V(C2i_t_24)>=threshold || V(C2i_f_24)>=threshold) input_spacer[2]=0;
    if (V(C2i_t_25)>=threshold || V(C2i_f_25)>=threshold) input_spacer[2]=0;
    if (V(C2i_t_26)>=threshold || V(C2i_f_26)>=threshold) input_spacer[2]=0;
    if (V(C2i_t_27)>=threshold || V(C2i_f_27)>=threshold) input_spacer[2]=0;
    if (V(C2i_t_28)>=threshold || V(C2i_f_28)>=threshold) input_spacer[2]=0;
    if (V(C2i_t_29)>=threshold || V(C2i_f_29)>=threshold) input_spacer[2]=0;
    if (V(C2i_t_30)>=threshold || V(C2i_f_30)>=threshold) input_spacer[2]=0;
    if (V(C2i_t_31)>=threshold || V(C2i_f_31)>=threshold) input_spacer[2]=0;
    input_spacer[3]=1;
    if (V(C3i_t_0)>=threshold || V(C3i_f_0)>=threshold) input_spacer[3]=0;
    if (V(C3i_t_1)>=threshold || V(C3i_f_1)>=threshold) input_spacer[3]=0;
    if (V(C3i_t_2)>=threshold || V(C3i_f_2)>=threshold) input_spacer[3]=0;
    if (V(C3i_t_3)>=threshold || V(C3i_f_3)>=threshold) input_spacer[3]=0;
    if (V(C3i_t_4)>=threshold || V(C3i_f_4)>=threshold) input_spacer[3]=0;
    if (V(C3i_t_5)>=threshold || V(C3i_f_5)>=threshold) input_spacer[3]=0;
    if (V(C3i_t_6)>=threshold || V(C3i_f_6)>=threshold) input_spacer[3]=0;
    if (V(C3i_t_7)>=threshold || V(C3i_f_7)>=threshold) input_spacer[3]=0;
    if (V(C3i_t_8)>=threshold || V(C3i_f_8)>=threshold) input_spacer[3]=0;
    if (V(C3i_t_9)>=threshold || V(C3i_f_9)>=threshold) input_spacer[3]=0;
    if (V(C3i_t_10)>=threshold || V(C3i_f_10)>=threshold) input_spacer[3]=0;
    if (V(C3i_t_11)>=threshold || V(C3i_f_11)>=threshold) input_spacer[3]=0;
    if (V(C3i_t_12)>=threshold || V(C3i_f_12)>=threshold) input_spacer[3]=0;
    if (V(C3i_t_13)>=threshold || V(C3i_f_13)>=threshold) input_spacer[3]=0;
    if (V(C3i_t_14)>=threshold || V(C3i_f_14)>=threshold) input_spacer[3]=0;
    if (V(C3i_t_15)>=threshold || V(C3i_f_15)>=threshold) input_spacer[3]=0;
    if (V(C3i_t_16)>=threshold || V(C3i_f_16)>=threshold) input_spacer[3]=0;
    if (V(C3i_t_17)>=threshold || V(C3i_f_17)>=threshold) input_spacer[3]=0;
    if (V(C3i_t_18)>=threshold || V(C3i_f_18)>=threshold) input_spacer[3]=0;
    if (V(C3i_t_19)>=threshold || V(C3i_f_19)>=threshold) input_spacer[3]=0;
    if (V(C3i_t_20)>=threshold || V(C3i_f_20)>=threshold) input_spacer[3]=0;
    if (V(C3i_t_21)>=threshold || V(C3i_f_21)>=threshold) input_spacer[3]=0;
    if (V(C3i_t_22)>=threshold || V(C3i_f_22)>=threshold) input_spacer[3]=0;
    if (V(C3i_t_23)>=threshold || V(C3i_f_23)>=threshold) input_spacer[3]=0;
    if (V(C3i_t_24)>=threshold || V(C3i_f_24)>=threshold) input_spacer[3]=0;
    if (V(C3i_t_25)>=threshold || V(C3i_f_25)>=threshold) input_spacer[3]=0;
    if (V(C3i_t_26)>=threshold || V(C3i_f_26)>=threshold) input_spacer[3]=0;
    if (V(C3i_t_27)>=threshold || V(C3i_f_27)>=threshold) input_spacer[3]=0;
    if (V(C3i_t_28)>=threshold || V(C3i_f_28)>=threshold) input_spacer[3]=0;
    if (V(C3i_t_29)>=threshold || V(C3i_f_29)>=threshold) input_spacer[3]=0;
    if (V(C3i_t_30)>=threshold || V(C3i_f_30)>=threshold) input_spacer[3]=0;
    if (V(C3i_t_31)>=threshold || V(C3i_f_31)>=threshold) input_spacer[3]=0;
    input_spacer[4]=1;
    if (V(Pi_t_0)>=threshold || V(Pi_f_0)>=threshold) input_spacer[4]=0;
    if (V(Pi_t_1)>=threshold || V(Pi_f_1)>=threshold) input_spacer[4]=0;
    if (V(Pi_t_2)>=threshold || V(Pi_f_2)>=threshold) input_spacer[4]=0;
    if (V(Pi_t_3)>=threshold || V(Pi_f_3)>=threshold) input_spacer[4]=0;
    if (V(Pi_t_4)>=threshold || V(Pi_f_4)>=threshold) input_spacer[4]=0;
    if (V(Pi_t_5)>=threshold || V(Pi_f_5)>=threshold) input_spacer[4]=0;
    if (V(Pi_t_6)>=threshold || V(Pi_f_6)>=threshold) input_spacer[4]=0;
    if (V(Pi_t_7)>=threshold || V(Pi_f_7)>=threshold) input_spacer[4]=0;
    if (V(Pi_t_8)>=threshold || V(Pi_f_8)>=threshold) input_spacer[4]=0;
    if (V(Pi_t_9)>=threshold || V(Pi_f_9)>=threshold) input_spacer[4]=0;
    if (V(Pi_t_10)>=threshold || V(Pi_f_10)>=threshold) input_spacer[4]=0;
    if (V(Pi_t_11)>=threshold || V(Pi_f_11)>=threshold) input_spacer[4]=0;
    if (V(Pi_t_12)>=threshold || V(Pi_f_12)>=threshold) input_spacer[4]=0;
    if (V(Pi_t_13)>=threshold || V(Pi_f_13)>=threshold) input_spacer[4]=0;
    if (V(Pi_t_14)>=threshold || V(Pi_f_14)>=threshold) input_spacer[4]=0;
    if (V(Pi_t_15)>=threshold || V(Pi_f_15)>=threshold) input_spacer[4]=0;
    if (V(Pi_t_16)>=threshold || V(Pi_f_16)>=threshold) input_spacer[4]=0;
    if (V(Pi_t_17)>=threshold || V(Pi_f_17)>=threshold) input_spacer[4]=0;
    if (V(Pi_t_18)>=threshold || V(Pi_f_18)>=threshold) input_spacer[4]=0;
    if (V(Pi_t_19)>=threshold || V(Pi_f_19)>=threshold) input_spacer[4]=0;
    if (V(Pi_t_20)>=threshold || V(Pi_f_20)>=threshold) input_spacer[4]=0;
    if (V(Pi_t_21)>=threshold || V(Pi_f_21)>=threshold) input_spacer[4]=0;
    if (V(Pi_t_22)>=threshold || V(Pi_f_22)>=threshold) input_spacer[4]=0;
    if (V(Pi_t_23)>=threshold || V(Pi_f_23)>=threshold) input_spacer[4]=0;
    if (V(Pi_t_24)>=threshold || V(Pi_f_24)>=threshold) input_spacer[4]=0;
    if (V(Pi_t_25)>=threshold || V(Pi_f_25)>=threshold) input_spacer[4]=0;
    if (V(Pi_t_26)>=threshold || V(Pi_f_26)>=threshold) input_spacer[4]=0;
    if (V(Pi_t_27)>=threshold || V(Pi_f_27)>=threshold) input_spacer[4]=0;
    if (V(Pi_t_28)>=threshold || V(Pi_f_28)>=threshold) input_spacer[4]=0;
    if (V(Pi_t_29)>=threshold || V(Pi_f_29)>=threshold) input_spacer[4]=0;
    if (V(Pi_t_30)>=threshold || V(Pi_f_30)>=threshold) input_spacer[4]=0;
    if (V(Pi_t_31)>=threshold || V(Pi_f_31)>=threshold) input_spacer[4]=0;
    valid_word[0]=1; spacer[0]=1; illegal[0]=0; word[0]=0;
    if (V(C0o_t_0)<threshold && V(C0o_f_0)<threshold) valid_word[0]=0;
    if (V(C0o_t_0)>=threshold || V(C0o_f_0)>=threshold) spacer[0]=0;
    if (V(C0o_t_0)>=threshold && V(C0o_f_0)>=threshold) illegal[0]=1;
    if (V(C0o_t_0)>=threshold) word[0]=word[0] | (1 << 0);
    if (V(C0o_t_1)<threshold && V(C0o_f_1)<threshold) valid_word[0]=0;
    if (V(C0o_t_1)>=threshold || V(C0o_f_1)>=threshold) spacer[0]=0;
    if (V(C0o_t_1)>=threshold && V(C0o_f_1)>=threshold) illegal[0]=1;
    if (V(C0o_t_1)>=threshold) word[0]=word[0] | (1 << 1);
    if (V(C0o_t_2)<threshold && V(C0o_f_2)<threshold) valid_word[0]=0;
    if (V(C0o_t_2)>=threshold || V(C0o_f_2)>=threshold) spacer[0]=0;
    if (V(C0o_t_2)>=threshold && V(C0o_f_2)>=threshold) illegal[0]=1;
    if (V(C0o_t_2)>=threshold) word[0]=word[0] | (1 << 2);
    if (V(C0o_t_3)<threshold && V(C0o_f_3)<threshold) valid_word[0]=0;
    if (V(C0o_t_3)>=threshold || V(C0o_f_3)>=threshold) spacer[0]=0;
    if (V(C0o_t_3)>=threshold && V(C0o_f_3)>=threshold) illegal[0]=1;
    if (V(C0o_t_3)>=threshold) word[0]=word[0] | (1 << 3);
    if (V(C0o_t_4)<threshold && V(C0o_f_4)<threshold) valid_word[0]=0;
    if (V(C0o_t_4)>=threshold || V(C0o_f_4)>=threshold) spacer[0]=0;
    if (V(C0o_t_4)>=threshold && V(C0o_f_4)>=threshold) illegal[0]=1;
    if (V(C0o_t_4)>=threshold) word[0]=word[0] | (1 << 4);
    if (V(C0o_t_5)<threshold && V(C0o_f_5)<threshold) valid_word[0]=0;
    if (V(C0o_t_5)>=threshold || V(C0o_f_5)>=threshold) spacer[0]=0;
    if (V(C0o_t_5)>=threshold && V(C0o_f_5)>=threshold) illegal[0]=1;
    if (V(C0o_t_5)>=threshold) word[0]=word[0] | (1 << 5);
    if (V(C0o_t_6)<threshold && V(C0o_f_6)<threshold) valid_word[0]=0;
    if (V(C0o_t_6)>=threshold || V(C0o_f_6)>=threshold) spacer[0]=0;
    if (V(C0o_t_6)>=threshold && V(C0o_f_6)>=threshold) illegal[0]=1;
    if (V(C0o_t_6)>=threshold) word[0]=word[0] | (1 << 6);
    if (V(C0o_t_7)<threshold && V(C0o_f_7)<threshold) valid_word[0]=0;
    if (V(C0o_t_7)>=threshold || V(C0o_f_7)>=threshold) spacer[0]=0;
    if (V(C0o_t_7)>=threshold && V(C0o_f_7)>=threshold) illegal[0]=1;
    if (V(C0o_t_7)>=threshold) word[0]=word[0] | (1 << 7);
    if (V(C0o_t_8)<threshold && V(C0o_f_8)<threshold) valid_word[0]=0;
    if (V(C0o_t_8)>=threshold || V(C0o_f_8)>=threshold) spacer[0]=0;
    if (V(C0o_t_8)>=threshold && V(C0o_f_8)>=threshold) illegal[0]=1;
    if (V(C0o_t_8)>=threshold) word[0]=word[0] | (1 << 8);
    if (V(C0o_t_9)<threshold && V(C0o_f_9)<threshold) valid_word[0]=0;
    if (V(C0o_t_9)>=threshold || V(C0o_f_9)>=threshold) spacer[0]=0;
    if (V(C0o_t_9)>=threshold && V(C0o_f_9)>=threshold) illegal[0]=1;
    if (V(C0o_t_9)>=threshold) word[0]=word[0] | (1 << 9);
    if (V(C0o_t_10)<threshold && V(C0o_f_10)<threshold) valid_word[0]=0;
    if (V(C0o_t_10)>=threshold || V(C0o_f_10)>=threshold) spacer[0]=0;
    if (V(C0o_t_10)>=threshold && V(C0o_f_10)>=threshold) illegal[0]=1;
    if (V(C0o_t_10)>=threshold) word[0]=word[0] | (1 << 10);
    if (V(C0o_t_11)<threshold && V(C0o_f_11)<threshold) valid_word[0]=0;
    if (V(C0o_t_11)>=threshold || V(C0o_f_11)>=threshold) spacer[0]=0;
    if (V(C0o_t_11)>=threshold && V(C0o_f_11)>=threshold) illegal[0]=1;
    if (V(C0o_t_11)>=threshold) word[0]=word[0] | (1 << 11);
    if (V(C0o_t_12)<threshold && V(C0o_f_12)<threshold) valid_word[0]=0;
    if (V(C0o_t_12)>=threshold || V(C0o_f_12)>=threshold) spacer[0]=0;
    if (V(C0o_t_12)>=threshold && V(C0o_f_12)>=threshold) illegal[0]=1;
    if (V(C0o_t_12)>=threshold) word[0]=word[0] | (1 << 12);
    if (V(C0o_t_13)<threshold && V(C0o_f_13)<threshold) valid_word[0]=0;
    if (V(C0o_t_13)>=threshold || V(C0o_f_13)>=threshold) spacer[0]=0;
    if (V(C0o_t_13)>=threshold && V(C0o_f_13)>=threshold) illegal[0]=1;
    if (V(C0o_t_13)>=threshold) word[0]=word[0] | (1 << 13);
    if (V(C0o_t_14)<threshold && V(C0o_f_14)<threshold) valid_word[0]=0;
    if (V(C0o_t_14)>=threshold || V(C0o_f_14)>=threshold) spacer[0]=0;
    if (V(C0o_t_14)>=threshold && V(C0o_f_14)>=threshold) illegal[0]=1;
    if (V(C0o_t_14)>=threshold) word[0]=word[0] | (1 << 14);
    if (V(C0o_t_15)<threshold && V(C0o_f_15)<threshold) valid_word[0]=0;
    if (V(C0o_t_15)>=threshold || V(C0o_f_15)>=threshold) spacer[0]=0;
    if (V(C0o_t_15)>=threshold && V(C0o_f_15)>=threshold) illegal[0]=1;
    if (V(C0o_t_15)>=threshold) word[0]=word[0] | (1 << 15);
    if (V(C0o_t_16)<threshold && V(C0o_f_16)<threshold) valid_word[0]=0;
    if (V(C0o_t_16)>=threshold || V(C0o_f_16)>=threshold) spacer[0]=0;
    if (V(C0o_t_16)>=threshold && V(C0o_f_16)>=threshold) illegal[0]=1;
    if (V(C0o_t_16)>=threshold) word[0]=word[0] | (1 << 16);
    if (V(C0o_t_17)<threshold && V(C0o_f_17)<threshold) valid_word[0]=0;
    if (V(C0o_t_17)>=threshold || V(C0o_f_17)>=threshold) spacer[0]=0;
    if (V(C0o_t_17)>=threshold && V(C0o_f_17)>=threshold) illegal[0]=1;
    if (V(C0o_t_17)>=threshold) word[0]=word[0] | (1 << 17);
    if (V(C0o_t_18)<threshold && V(C0o_f_18)<threshold) valid_word[0]=0;
    if (V(C0o_t_18)>=threshold || V(C0o_f_18)>=threshold) spacer[0]=0;
    if (V(C0o_t_18)>=threshold && V(C0o_f_18)>=threshold) illegal[0]=1;
    if (V(C0o_t_18)>=threshold) word[0]=word[0] | (1 << 18);
    if (V(C0o_t_19)<threshold && V(C0o_f_19)<threshold) valid_word[0]=0;
    if (V(C0o_t_19)>=threshold || V(C0o_f_19)>=threshold) spacer[0]=0;
    if (V(C0o_t_19)>=threshold && V(C0o_f_19)>=threshold) illegal[0]=1;
    if (V(C0o_t_19)>=threshold) word[0]=word[0] | (1 << 19);
    if (V(C0o_t_20)<threshold && V(C0o_f_20)<threshold) valid_word[0]=0;
    if (V(C0o_t_20)>=threshold || V(C0o_f_20)>=threshold) spacer[0]=0;
    if (V(C0o_t_20)>=threshold && V(C0o_f_20)>=threshold) illegal[0]=1;
    if (V(C0o_t_20)>=threshold) word[0]=word[0] | (1 << 20);
    if (V(C0o_t_21)<threshold && V(C0o_f_21)<threshold) valid_word[0]=0;
    if (V(C0o_t_21)>=threshold || V(C0o_f_21)>=threshold) spacer[0]=0;
    if (V(C0o_t_21)>=threshold && V(C0o_f_21)>=threshold) illegal[0]=1;
    if (V(C0o_t_21)>=threshold) word[0]=word[0] | (1 << 21);
    if (V(C0o_t_22)<threshold && V(C0o_f_22)<threshold) valid_word[0]=0;
    if (V(C0o_t_22)>=threshold || V(C0o_f_22)>=threshold) spacer[0]=0;
    if (V(C0o_t_22)>=threshold && V(C0o_f_22)>=threshold) illegal[0]=1;
    if (V(C0o_t_22)>=threshold) word[0]=word[0] | (1 << 22);
    if (V(C0o_t_23)<threshold && V(C0o_f_23)<threshold) valid_word[0]=0;
    if (V(C0o_t_23)>=threshold || V(C0o_f_23)>=threshold) spacer[0]=0;
    if (V(C0o_t_23)>=threshold && V(C0o_f_23)>=threshold) illegal[0]=1;
    if (V(C0o_t_23)>=threshold) word[0]=word[0] | (1 << 23);
    if (V(C0o_t_24)<threshold && V(C0o_f_24)<threshold) valid_word[0]=0;
    if (V(C0o_t_24)>=threshold || V(C0o_f_24)>=threshold) spacer[0]=0;
    if (V(C0o_t_24)>=threshold && V(C0o_f_24)>=threshold) illegal[0]=1;
    if (V(C0o_t_24)>=threshold) word[0]=word[0] | (1 << 24);
    if (V(C0o_t_25)<threshold && V(C0o_f_25)<threshold) valid_word[0]=0;
    if (V(C0o_t_25)>=threshold || V(C0o_f_25)>=threshold) spacer[0]=0;
    if (V(C0o_t_25)>=threshold && V(C0o_f_25)>=threshold) illegal[0]=1;
    if (V(C0o_t_25)>=threshold) word[0]=word[0] | (1 << 25);
    if (V(C0o_t_26)<threshold && V(C0o_f_26)<threshold) valid_word[0]=0;
    if (V(C0o_t_26)>=threshold || V(C0o_f_26)>=threshold) spacer[0]=0;
    if (V(C0o_t_26)>=threshold && V(C0o_f_26)>=threshold) illegal[0]=1;
    if (V(C0o_t_26)>=threshold) word[0]=word[0] | (1 << 26);
    if (V(C0o_t_27)<threshold && V(C0o_f_27)<threshold) valid_word[0]=0;
    if (V(C0o_t_27)>=threshold || V(C0o_f_27)>=threshold) spacer[0]=0;
    if (V(C0o_t_27)>=threshold && V(C0o_f_27)>=threshold) illegal[0]=1;
    if (V(C0o_t_27)>=threshold) word[0]=word[0] | (1 << 27);
    if (V(C0o_t_28)<threshold && V(C0o_f_28)<threshold) valid_word[0]=0;
    if (V(C0o_t_28)>=threshold || V(C0o_f_28)>=threshold) spacer[0]=0;
    if (V(C0o_t_28)>=threshold && V(C0o_f_28)>=threshold) illegal[0]=1;
    if (V(C0o_t_28)>=threshold) word[0]=word[0] | (1 << 28);
    if (V(C0o_t_29)<threshold && V(C0o_f_29)<threshold) valid_word[0]=0;
    if (V(C0o_t_29)>=threshold || V(C0o_f_29)>=threshold) spacer[0]=0;
    if (V(C0o_t_29)>=threshold && V(C0o_f_29)>=threshold) illegal[0]=1;
    if (V(C0o_t_29)>=threshold) word[0]=word[0] | (1 << 29);
    if (V(C0o_t_30)<threshold && V(C0o_f_30)<threshold) valid_word[0]=0;
    if (V(C0o_t_30)>=threshold || V(C0o_f_30)>=threshold) spacer[0]=0;
    if (V(C0o_t_30)>=threshold && V(C0o_f_30)>=threshold) illegal[0]=1;
    if (V(C0o_t_30)>=threshold) word[0]=word[0] | (1 << 30);
    if (V(C0o_t_31)<threshold && V(C0o_f_31)<threshold) valid_word[0]=0;
    if (V(C0o_t_31)>=threshold || V(C0o_f_31)>=threshold) spacer[0]=0;
    if (V(C0o_t_31)>=threshold && V(C0o_f_31)>=threshold) illegal[0]=1;
    if (V(C0o_t_31)>=threshold) word[0]=word[0] | (1 << 31);
    valid_word[1]=1; spacer[1]=1; illegal[1]=0; word[1]=0;
    if (V(C1o_t_0)<threshold && V(C1o_f_0)<threshold) valid_word[1]=0;
    if (V(C1o_t_0)>=threshold || V(C1o_f_0)>=threshold) spacer[1]=0;
    if (V(C1o_t_0)>=threshold && V(C1o_f_0)>=threshold) illegal[1]=1;
    if (V(C1o_t_0)>=threshold) word[1]=word[1] | (1 << 0);
    if (V(C1o_t_1)<threshold && V(C1o_f_1)<threshold) valid_word[1]=0;
    if (V(C1o_t_1)>=threshold || V(C1o_f_1)>=threshold) spacer[1]=0;
    if (V(C1o_t_1)>=threshold && V(C1o_f_1)>=threshold) illegal[1]=1;
    if (V(C1o_t_1)>=threshold) word[1]=word[1] | (1 << 1);
    if (V(C1o_t_2)<threshold && V(C1o_f_2)<threshold) valid_word[1]=0;
    if (V(C1o_t_2)>=threshold || V(C1o_f_2)>=threshold) spacer[1]=0;
    if (V(C1o_t_2)>=threshold && V(C1o_f_2)>=threshold) illegal[1]=1;
    if (V(C1o_t_2)>=threshold) word[1]=word[1] | (1 << 2);
    if (V(C1o_t_3)<threshold && V(C1o_f_3)<threshold) valid_word[1]=0;
    if (V(C1o_t_3)>=threshold || V(C1o_f_3)>=threshold) spacer[1]=0;
    if (V(C1o_t_3)>=threshold && V(C1o_f_3)>=threshold) illegal[1]=1;
    if (V(C1o_t_3)>=threshold) word[1]=word[1] | (1 << 3);
    if (V(C1o_t_4)<threshold && V(C1o_f_4)<threshold) valid_word[1]=0;
    if (V(C1o_t_4)>=threshold || V(C1o_f_4)>=threshold) spacer[1]=0;
    if (V(C1o_t_4)>=threshold && V(C1o_f_4)>=threshold) illegal[1]=1;
    if (V(C1o_t_4)>=threshold) word[1]=word[1] | (1 << 4);
    if (V(C1o_t_5)<threshold && V(C1o_f_5)<threshold) valid_word[1]=0;
    if (V(C1o_t_5)>=threshold || V(C1o_f_5)>=threshold) spacer[1]=0;
    if (V(C1o_t_5)>=threshold && V(C1o_f_5)>=threshold) illegal[1]=1;
    if (V(C1o_t_5)>=threshold) word[1]=word[1] | (1 << 5);
    if (V(C1o_t_6)<threshold && V(C1o_f_6)<threshold) valid_word[1]=0;
    if (V(C1o_t_6)>=threshold || V(C1o_f_6)>=threshold) spacer[1]=0;
    if (V(C1o_t_6)>=threshold && V(C1o_f_6)>=threshold) illegal[1]=1;
    if (V(C1o_t_6)>=threshold) word[1]=word[1] | (1 << 6);
    if (V(C1o_t_7)<threshold && V(C1o_f_7)<threshold) valid_word[1]=0;
    if (V(C1o_t_7)>=threshold || V(C1o_f_7)>=threshold) spacer[1]=0;
    if (V(C1o_t_7)>=threshold && V(C1o_f_7)>=threshold) illegal[1]=1;
    if (V(C1o_t_7)>=threshold) word[1]=word[1] | (1 << 7);
    if (V(C1o_t_8)<threshold && V(C1o_f_8)<threshold) valid_word[1]=0;
    if (V(C1o_t_8)>=threshold || V(C1o_f_8)>=threshold) spacer[1]=0;
    if (V(C1o_t_8)>=threshold && V(C1o_f_8)>=threshold) illegal[1]=1;
    if (V(C1o_t_8)>=threshold) word[1]=word[1] | (1 << 8);
    if (V(C1o_t_9)<threshold && V(C1o_f_9)<threshold) valid_word[1]=0;
    if (V(C1o_t_9)>=threshold || V(C1o_f_9)>=threshold) spacer[1]=0;
    if (V(C1o_t_9)>=threshold && V(C1o_f_9)>=threshold) illegal[1]=1;
    if (V(C1o_t_9)>=threshold) word[1]=word[1] | (1 << 9);
    if (V(C1o_t_10)<threshold && V(C1o_f_10)<threshold) valid_word[1]=0;
    if (V(C1o_t_10)>=threshold || V(C1o_f_10)>=threshold) spacer[1]=0;
    if (V(C1o_t_10)>=threshold && V(C1o_f_10)>=threshold) illegal[1]=1;
    if (V(C1o_t_10)>=threshold) word[1]=word[1] | (1 << 10);
    if (V(C1o_t_11)<threshold && V(C1o_f_11)<threshold) valid_word[1]=0;
    if (V(C1o_t_11)>=threshold || V(C1o_f_11)>=threshold) spacer[1]=0;
    if (V(C1o_t_11)>=threshold && V(C1o_f_11)>=threshold) illegal[1]=1;
    if (V(C1o_t_11)>=threshold) word[1]=word[1] | (1 << 11);
    if (V(C1o_t_12)<threshold && V(C1o_f_12)<threshold) valid_word[1]=0;
    if (V(C1o_t_12)>=threshold || V(C1o_f_12)>=threshold) spacer[1]=0;
    if (V(C1o_t_12)>=threshold && V(C1o_f_12)>=threshold) illegal[1]=1;
    if (V(C1o_t_12)>=threshold) word[1]=word[1] | (1 << 12);
    if (V(C1o_t_13)<threshold && V(C1o_f_13)<threshold) valid_word[1]=0;
    if (V(C1o_t_13)>=threshold || V(C1o_f_13)>=threshold) spacer[1]=0;
    if (V(C1o_t_13)>=threshold && V(C1o_f_13)>=threshold) illegal[1]=1;
    if (V(C1o_t_13)>=threshold) word[1]=word[1] | (1 << 13);
    if (V(C1o_t_14)<threshold && V(C1o_f_14)<threshold) valid_word[1]=0;
    if (V(C1o_t_14)>=threshold || V(C1o_f_14)>=threshold) spacer[1]=0;
    if (V(C1o_t_14)>=threshold && V(C1o_f_14)>=threshold) illegal[1]=1;
    if (V(C1o_t_14)>=threshold) word[1]=word[1] | (1 << 14);
    if (V(C1o_t_15)<threshold && V(C1o_f_15)<threshold) valid_word[1]=0;
    if (V(C1o_t_15)>=threshold || V(C1o_f_15)>=threshold) spacer[1]=0;
    if (V(C1o_t_15)>=threshold && V(C1o_f_15)>=threshold) illegal[1]=1;
    if (V(C1o_t_15)>=threshold) word[1]=word[1] | (1 << 15);
    if (V(C1o_t_16)<threshold && V(C1o_f_16)<threshold) valid_word[1]=0;
    if (V(C1o_t_16)>=threshold || V(C1o_f_16)>=threshold) spacer[1]=0;
    if (V(C1o_t_16)>=threshold && V(C1o_f_16)>=threshold) illegal[1]=1;
    if (V(C1o_t_16)>=threshold) word[1]=word[1] | (1 << 16);
    if (V(C1o_t_17)<threshold && V(C1o_f_17)<threshold) valid_word[1]=0;
    if (V(C1o_t_17)>=threshold || V(C1o_f_17)>=threshold) spacer[1]=0;
    if (V(C1o_t_17)>=threshold && V(C1o_f_17)>=threshold) illegal[1]=1;
    if (V(C1o_t_17)>=threshold) word[1]=word[1] | (1 << 17);
    if (V(C1o_t_18)<threshold && V(C1o_f_18)<threshold) valid_word[1]=0;
    if (V(C1o_t_18)>=threshold || V(C1o_f_18)>=threshold) spacer[1]=0;
    if (V(C1o_t_18)>=threshold && V(C1o_f_18)>=threshold) illegal[1]=1;
    if (V(C1o_t_18)>=threshold) word[1]=word[1] | (1 << 18);
    if (V(C1o_t_19)<threshold && V(C1o_f_19)<threshold) valid_word[1]=0;
    if (V(C1o_t_19)>=threshold || V(C1o_f_19)>=threshold) spacer[1]=0;
    if (V(C1o_t_19)>=threshold && V(C1o_f_19)>=threshold) illegal[1]=1;
    if (V(C1o_t_19)>=threshold) word[1]=word[1] | (1 << 19);
    if (V(C1o_t_20)<threshold && V(C1o_f_20)<threshold) valid_word[1]=0;
    if (V(C1o_t_20)>=threshold || V(C1o_f_20)>=threshold) spacer[1]=0;
    if (V(C1o_t_20)>=threshold && V(C1o_f_20)>=threshold) illegal[1]=1;
    if (V(C1o_t_20)>=threshold) word[1]=word[1] | (1 << 20);
    if (V(C1o_t_21)<threshold && V(C1o_f_21)<threshold) valid_word[1]=0;
    if (V(C1o_t_21)>=threshold || V(C1o_f_21)>=threshold) spacer[1]=0;
    if (V(C1o_t_21)>=threshold && V(C1o_f_21)>=threshold) illegal[1]=1;
    if (V(C1o_t_21)>=threshold) word[1]=word[1] | (1 << 21);
    if (V(C1o_t_22)<threshold && V(C1o_f_22)<threshold) valid_word[1]=0;
    if (V(C1o_t_22)>=threshold || V(C1o_f_22)>=threshold) spacer[1]=0;
    if (V(C1o_t_22)>=threshold && V(C1o_f_22)>=threshold) illegal[1]=1;
    if (V(C1o_t_22)>=threshold) word[1]=word[1] | (1 << 22);
    if (V(C1o_t_23)<threshold && V(C1o_f_23)<threshold) valid_word[1]=0;
    if (V(C1o_t_23)>=threshold || V(C1o_f_23)>=threshold) spacer[1]=0;
    if (V(C1o_t_23)>=threshold && V(C1o_f_23)>=threshold) illegal[1]=1;
    if (V(C1o_t_23)>=threshold) word[1]=word[1] | (1 << 23);
    if (V(C1o_t_24)<threshold && V(C1o_f_24)<threshold) valid_word[1]=0;
    if (V(C1o_t_24)>=threshold || V(C1o_f_24)>=threshold) spacer[1]=0;
    if (V(C1o_t_24)>=threshold && V(C1o_f_24)>=threshold) illegal[1]=1;
    if (V(C1o_t_24)>=threshold) word[1]=word[1] | (1 << 24);
    if (V(C1o_t_25)<threshold && V(C1o_f_25)<threshold) valid_word[1]=0;
    if (V(C1o_t_25)>=threshold || V(C1o_f_25)>=threshold) spacer[1]=0;
    if (V(C1o_t_25)>=threshold && V(C1o_f_25)>=threshold) illegal[1]=1;
    if (V(C1o_t_25)>=threshold) word[1]=word[1] | (1 << 25);
    if (V(C1o_t_26)<threshold && V(C1o_f_26)<threshold) valid_word[1]=0;
    if (V(C1o_t_26)>=threshold || V(C1o_f_26)>=threshold) spacer[1]=0;
    if (V(C1o_t_26)>=threshold && V(C1o_f_26)>=threshold) illegal[1]=1;
    if (V(C1o_t_26)>=threshold) word[1]=word[1] | (1 << 26);
    if (V(C1o_t_27)<threshold && V(C1o_f_27)<threshold) valid_word[1]=0;
    if (V(C1o_t_27)>=threshold || V(C1o_f_27)>=threshold) spacer[1]=0;
    if (V(C1o_t_27)>=threshold && V(C1o_f_27)>=threshold) illegal[1]=1;
    if (V(C1o_t_27)>=threshold) word[1]=word[1] | (1 << 27);
    if (V(C1o_t_28)<threshold && V(C1o_f_28)<threshold) valid_word[1]=0;
    if (V(C1o_t_28)>=threshold || V(C1o_f_28)>=threshold) spacer[1]=0;
    if (V(C1o_t_28)>=threshold && V(C1o_f_28)>=threshold) illegal[1]=1;
    if (V(C1o_t_28)>=threshold) word[1]=word[1] | (1 << 28);
    if (V(C1o_t_29)<threshold && V(C1o_f_29)<threshold) valid_word[1]=0;
    if (V(C1o_t_29)>=threshold || V(C1o_f_29)>=threshold) spacer[1]=0;
    if (V(C1o_t_29)>=threshold && V(C1o_f_29)>=threshold) illegal[1]=1;
    if (V(C1o_t_29)>=threshold) word[1]=word[1] | (1 << 29);
    if (V(C1o_t_30)<threshold && V(C1o_f_30)<threshold) valid_word[1]=0;
    if (V(C1o_t_30)>=threshold || V(C1o_f_30)>=threshold) spacer[1]=0;
    if (V(C1o_t_30)>=threshold && V(C1o_f_30)>=threshold) illegal[1]=1;
    if (V(C1o_t_30)>=threshold) word[1]=word[1] | (1 << 30);
    if (V(C1o_t_31)<threshold && V(C1o_f_31)<threshold) valid_word[1]=0;
    if (V(C1o_t_31)>=threshold || V(C1o_f_31)>=threshold) spacer[1]=0;
    if (V(C1o_t_31)>=threshold && V(C1o_f_31)>=threshold) illegal[1]=1;
    if (V(C1o_t_31)>=threshold) word[1]=word[1] | (1 << 31);
    valid_word[2]=1; spacer[2]=1; illegal[2]=0; word[2]=0;
    if (V(C2o_t_0)<threshold && V(C2o_f_0)<threshold) valid_word[2]=0;
    if (V(C2o_t_0)>=threshold || V(C2o_f_0)>=threshold) spacer[2]=0;
    if (V(C2o_t_0)>=threshold && V(C2o_f_0)>=threshold) illegal[2]=1;
    if (V(C2o_t_0)>=threshold) word[2]=word[2] | (1 << 0);
    if (V(C2o_t_1)<threshold && V(C2o_f_1)<threshold) valid_word[2]=0;
    if (V(C2o_t_1)>=threshold || V(C2o_f_1)>=threshold) spacer[2]=0;
    if (V(C2o_t_1)>=threshold && V(C2o_f_1)>=threshold) illegal[2]=1;
    if (V(C2o_t_1)>=threshold) word[2]=word[2] | (1 << 1);
    if (V(C2o_t_2)<threshold && V(C2o_f_2)<threshold) valid_word[2]=0;
    if (V(C2o_t_2)>=threshold || V(C2o_f_2)>=threshold) spacer[2]=0;
    if (V(C2o_t_2)>=threshold && V(C2o_f_2)>=threshold) illegal[2]=1;
    if (V(C2o_t_2)>=threshold) word[2]=word[2] | (1 << 2);
    if (V(C2o_t_3)<threshold && V(C2o_f_3)<threshold) valid_word[2]=0;
    if (V(C2o_t_3)>=threshold || V(C2o_f_3)>=threshold) spacer[2]=0;
    if (V(C2o_t_3)>=threshold && V(C2o_f_3)>=threshold) illegal[2]=1;
    if (V(C2o_t_3)>=threshold) word[2]=word[2] | (1 << 3);
    if (V(C2o_t_4)<threshold && V(C2o_f_4)<threshold) valid_word[2]=0;
    if (V(C2o_t_4)>=threshold || V(C2o_f_4)>=threshold) spacer[2]=0;
    if (V(C2o_t_4)>=threshold && V(C2o_f_4)>=threshold) illegal[2]=1;
    if (V(C2o_t_4)>=threshold) word[2]=word[2] | (1 << 4);
    if (V(C2o_t_5)<threshold && V(C2o_f_5)<threshold) valid_word[2]=0;
    if (V(C2o_t_5)>=threshold || V(C2o_f_5)>=threshold) spacer[2]=0;
    if (V(C2o_t_5)>=threshold && V(C2o_f_5)>=threshold) illegal[2]=1;
    if (V(C2o_t_5)>=threshold) word[2]=word[2] | (1 << 5);
    if (V(C2o_t_6)<threshold && V(C2o_f_6)<threshold) valid_word[2]=0;
    if (V(C2o_t_6)>=threshold || V(C2o_f_6)>=threshold) spacer[2]=0;
    if (V(C2o_t_6)>=threshold && V(C2o_f_6)>=threshold) illegal[2]=1;
    if (V(C2o_t_6)>=threshold) word[2]=word[2] | (1 << 6);
    if (V(C2o_t_7)<threshold && V(C2o_f_7)<threshold) valid_word[2]=0;
    if (V(C2o_t_7)>=threshold || V(C2o_f_7)>=threshold) spacer[2]=0;
    if (V(C2o_t_7)>=threshold && V(C2o_f_7)>=threshold) illegal[2]=1;
    if (V(C2o_t_7)>=threshold) word[2]=word[2] | (1 << 7);
    if (V(C2o_t_8)<threshold && V(C2o_f_8)<threshold) valid_word[2]=0;
    if (V(C2o_t_8)>=threshold || V(C2o_f_8)>=threshold) spacer[2]=0;
    if (V(C2o_t_8)>=threshold && V(C2o_f_8)>=threshold) illegal[2]=1;
    if (V(C2o_t_8)>=threshold) word[2]=word[2] | (1 << 8);
    if (V(C2o_t_9)<threshold && V(C2o_f_9)<threshold) valid_word[2]=0;
    if (V(C2o_t_9)>=threshold || V(C2o_f_9)>=threshold) spacer[2]=0;
    if (V(C2o_t_9)>=threshold && V(C2o_f_9)>=threshold) illegal[2]=1;
    if (V(C2o_t_9)>=threshold) word[2]=word[2] | (1 << 9);
    if (V(C2o_t_10)<threshold && V(C2o_f_10)<threshold) valid_word[2]=0;
    if (V(C2o_t_10)>=threshold || V(C2o_f_10)>=threshold) spacer[2]=0;
    if (V(C2o_t_10)>=threshold && V(C2o_f_10)>=threshold) illegal[2]=1;
    if (V(C2o_t_10)>=threshold) word[2]=word[2] | (1 << 10);
    if (V(C2o_t_11)<threshold && V(C2o_f_11)<threshold) valid_word[2]=0;
    if (V(C2o_t_11)>=threshold || V(C2o_f_11)>=threshold) spacer[2]=0;
    if (V(C2o_t_11)>=threshold && V(C2o_f_11)>=threshold) illegal[2]=1;
    if (V(C2o_t_11)>=threshold) word[2]=word[2] | (1 << 11);
    if (V(C2o_t_12)<threshold && V(C2o_f_12)<threshold) valid_word[2]=0;
    if (V(C2o_t_12)>=threshold || V(C2o_f_12)>=threshold) spacer[2]=0;
    if (V(C2o_t_12)>=threshold && V(C2o_f_12)>=threshold) illegal[2]=1;
    if (V(C2o_t_12)>=threshold) word[2]=word[2] | (1 << 12);
    if (V(C2o_t_13)<threshold && V(C2o_f_13)<threshold) valid_word[2]=0;
    if (V(C2o_t_13)>=threshold || V(C2o_f_13)>=threshold) spacer[2]=0;
    if (V(C2o_t_13)>=threshold && V(C2o_f_13)>=threshold) illegal[2]=1;
    if (V(C2o_t_13)>=threshold) word[2]=word[2] | (1 << 13);
    if (V(C2o_t_14)<threshold && V(C2o_f_14)<threshold) valid_word[2]=0;
    if (V(C2o_t_14)>=threshold || V(C2o_f_14)>=threshold) spacer[2]=0;
    if (V(C2o_t_14)>=threshold && V(C2o_f_14)>=threshold) illegal[2]=1;
    if (V(C2o_t_14)>=threshold) word[2]=word[2] | (1 << 14);
    if (V(C2o_t_15)<threshold && V(C2o_f_15)<threshold) valid_word[2]=0;
    if (V(C2o_t_15)>=threshold || V(C2o_f_15)>=threshold) spacer[2]=0;
    if (V(C2o_t_15)>=threshold && V(C2o_f_15)>=threshold) illegal[2]=1;
    if (V(C2o_t_15)>=threshold) word[2]=word[2] | (1 << 15);
    if (V(C2o_t_16)<threshold && V(C2o_f_16)<threshold) valid_word[2]=0;
    if (V(C2o_t_16)>=threshold || V(C2o_f_16)>=threshold) spacer[2]=0;
    if (V(C2o_t_16)>=threshold && V(C2o_f_16)>=threshold) illegal[2]=1;
    if (V(C2o_t_16)>=threshold) word[2]=word[2] | (1 << 16);
    if (V(C2o_t_17)<threshold && V(C2o_f_17)<threshold) valid_word[2]=0;
    if (V(C2o_t_17)>=threshold || V(C2o_f_17)>=threshold) spacer[2]=0;
    if (V(C2o_t_17)>=threshold && V(C2o_f_17)>=threshold) illegal[2]=1;
    if (V(C2o_t_17)>=threshold) word[2]=word[2] | (1 << 17);
    if (V(C2o_t_18)<threshold && V(C2o_f_18)<threshold) valid_word[2]=0;
    if (V(C2o_t_18)>=threshold || V(C2o_f_18)>=threshold) spacer[2]=0;
    if (V(C2o_t_18)>=threshold && V(C2o_f_18)>=threshold) illegal[2]=1;
    if (V(C2o_t_18)>=threshold) word[2]=word[2] | (1 << 18);
    if (V(C2o_t_19)<threshold && V(C2o_f_19)<threshold) valid_word[2]=0;
    if (V(C2o_t_19)>=threshold || V(C2o_f_19)>=threshold) spacer[2]=0;
    if (V(C2o_t_19)>=threshold && V(C2o_f_19)>=threshold) illegal[2]=1;
    if (V(C2o_t_19)>=threshold) word[2]=word[2] | (1 << 19);
    if (V(C2o_t_20)<threshold && V(C2o_f_20)<threshold) valid_word[2]=0;
    if (V(C2o_t_20)>=threshold || V(C2o_f_20)>=threshold) spacer[2]=0;
    if (V(C2o_t_20)>=threshold && V(C2o_f_20)>=threshold) illegal[2]=1;
    if (V(C2o_t_20)>=threshold) word[2]=word[2] | (1 << 20);
    if (V(C2o_t_21)<threshold && V(C2o_f_21)<threshold) valid_word[2]=0;
    if (V(C2o_t_21)>=threshold || V(C2o_f_21)>=threshold) spacer[2]=0;
    if (V(C2o_t_21)>=threshold && V(C2o_f_21)>=threshold) illegal[2]=1;
    if (V(C2o_t_21)>=threshold) word[2]=word[2] | (1 << 21);
    if (V(C2o_t_22)<threshold && V(C2o_f_22)<threshold) valid_word[2]=0;
    if (V(C2o_t_22)>=threshold || V(C2o_f_22)>=threshold) spacer[2]=0;
    if (V(C2o_t_22)>=threshold && V(C2o_f_22)>=threshold) illegal[2]=1;
    if (V(C2o_t_22)>=threshold) word[2]=word[2] | (1 << 22);
    if (V(C2o_t_23)<threshold && V(C2o_f_23)<threshold) valid_word[2]=0;
    if (V(C2o_t_23)>=threshold || V(C2o_f_23)>=threshold) spacer[2]=0;
    if (V(C2o_t_23)>=threshold && V(C2o_f_23)>=threshold) illegal[2]=1;
    if (V(C2o_t_23)>=threshold) word[2]=word[2] | (1 << 23);
    if (V(C2o_t_24)<threshold && V(C2o_f_24)<threshold) valid_word[2]=0;
    if (V(C2o_t_24)>=threshold || V(C2o_f_24)>=threshold) spacer[2]=0;
    if (V(C2o_t_24)>=threshold && V(C2o_f_24)>=threshold) illegal[2]=1;
    if (V(C2o_t_24)>=threshold) word[2]=word[2] | (1 << 24);
    if (V(C2o_t_25)<threshold && V(C2o_f_25)<threshold) valid_word[2]=0;
    if (V(C2o_t_25)>=threshold || V(C2o_f_25)>=threshold) spacer[2]=0;
    if (V(C2o_t_25)>=threshold && V(C2o_f_25)>=threshold) illegal[2]=1;
    if (V(C2o_t_25)>=threshold) word[2]=word[2] | (1 << 25);
    if (V(C2o_t_26)<threshold && V(C2o_f_26)<threshold) valid_word[2]=0;
    if (V(C2o_t_26)>=threshold || V(C2o_f_26)>=threshold) spacer[2]=0;
    if (V(C2o_t_26)>=threshold && V(C2o_f_26)>=threshold) illegal[2]=1;
    if (V(C2o_t_26)>=threshold) word[2]=word[2] | (1 << 26);
    if (V(C2o_t_27)<threshold && V(C2o_f_27)<threshold) valid_word[2]=0;
    if (V(C2o_t_27)>=threshold || V(C2o_f_27)>=threshold) spacer[2]=0;
    if (V(C2o_t_27)>=threshold && V(C2o_f_27)>=threshold) illegal[2]=1;
    if (V(C2o_t_27)>=threshold) word[2]=word[2] | (1 << 27);
    if (V(C2o_t_28)<threshold && V(C2o_f_28)<threshold) valid_word[2]=0;
    if (V(C2o_t_28)>=threshold || V(C2o_f_28)>=threshold) spacer[2]=0;
    if (V(C2o_t_28)>=threshold && V(C2o_f_28)>=threshold) illegal[2]=1;
    if (V(C2o_t_28)>=threshold) word[2]=word[2] | (1 << 28);
    if (V(C2o_t_29)<threshold && V(C2o_f_29)<threshold) valid_word[2]=0;
    if (V(C2o_t_29)>=threshold || V(C2o_f_29)>=threshold) spacer[2]=0;
    if (V(C2o_t_29)>=threshold && V(C2o_f_29)>=threshold) illegal[2]=1;
    if (V(C2o_t_29)>=threshold) word[2]=word[2] | (1 << 29);
    if (V(C2o_t_30)<threshold && V(C2o_f_30)<threshold) valid_word[2]=0;
    if (V(C2o_t_30)>=threshold || V(C2o_f_30)>=threshold) spacer[2]=0;
    if (V(C2o_t_30)>=threshold && V(C2o_f_30)>=threshold) illegal[2]=1;
    if (V(C2o_t_30)>=threshold) word[2]=word[2] | (1 << 30);
    if (V(C2o_t_31)<threshold && V(C2o_f_31)<threshold) valid_word[2]=0;
    if (V(C2o_t_31)>=threshold || V(C2o_f_31)>=threshold) spacer[2]=0;
    if (V(C2o_t_31)>=threshold && V(C2o_f_31)>=threshold) illegal[2]=1;
    if (V(C2o_t_31)>=threshold) word[2]=word[2] | (1 << 31);
    valid_word[3]=1; spacer[3]=1; illegal[3]=0; word[3]=0;
    if (V(C3o_t_0)<threshold && V(C3o_f_0)<threshold) valid_word[3]=0;
    if (V(C3o_t_0)>=threshold || V(C3o_f_0)>=threshold) spacer[3]=0;
    if (V(C3o_t_0)>=threshold && V(C3o_f_0)>=threshold) illegal[3]=1;
    if (V(C3o_t_0)>=threshold) word[3]=word[3] | (1 << 0);
    if (V(C3o_t_1)<threshold && V(C3o_f_1)<threshold) valid_word[3]=0;
    if (V(C3o_t_1)>=threshold || V(C3o_f_1)>=threshold) spacer[3]=0;
    if (V(C3o_t_1)>=threshold && V(C3o_f_1)>=threshold) illegal[3]=1;
    if (V(C3o_t_1)>=threshold) word[3]=word[3] | (1 << 1);
    if (V(C3o_t_2)<threshold && V(C3o_f_2)<threshold) valid_word[3]=0;
    if (V(C3o_t_2)>=threshold || V(C3o_f_2)>=threshold) spacer[3]=0;
    if (V(C3o_t_2)>=threshold && V(C3o_f_2)>=threshold) illegal[3]=1;
    if (V(C3o_t_2)>=threshold) word[3]=word[3] | (1 << 2);
    if (V(C3o_t_3)<threshold && V(C3o_f_3)<threshold) valid_word[3]=0;
    if (V(C3o_t_3)>=threshold || V(C3o_f_3)>=threshold) spacer[3]=0;
    if (V(C3o_t_3)>=threshold && V(C3o_f_3)>=threshold) illegal[3]=1;
    if (V(C3o_t_3)>=threshold) word[3]=word[3] | (1 << 3);
    if (V(C3o_t_4)<threshold && V(C3o_f_4)<threshold) valid_word[3]=0;
    if (V(C3o_t_4)>=threshold || V(C3o_f_4)>=threshold) spacer[3]=0;
    if (V(C3o_t_4)>=threshold && V(C3o_f_4)>=threshold) illegal[3]=1;
    if (V(C3o_t_4)>=threshold) word[3]=word[3] | (1 << 4);
    if (V(C3o_t_5)<threshold && V(C3o_f_5)<threshold) valid_word[3]=0;
    if (V(C3o_t_5)>=threshold || V(C3o_f_5)>=threshold) spacer[3]=0;
    if (V(C3o_t_5)>=threshold && V(C3o_f_5)>=threshold) illegal[3]=1;
    if (V(C3o_t_5)>=threshold) word[3]=word[3] | (1 << 5);
    if (V(C3o_t_6)<threshold && V(C3o_f_6)<threshold) valid_word[3]=0;
    if (V(C3o_t_6)>=threshold || V(C3o_f_6)>=threshold) spacer[3]=0;
    if (V(C3o_t_6)>=threshold && V(C3o_f_6)>=threshold) illegal[3]=1;
    if (V(C3o_t_6)>=threshold) word[3]=word[3] | (1 << 6);
    if (V(C3o_t_7)<threshold && V(C3o_f_7)<threshold) valid_word[3]=0;
    if (V(C3o_t_7)>=threshold || V(C3o_f_7)>=threshold) spacer[3]=0;
    if (V(C3o_t_7)>=threshold && V(C3o_f_7)>=threshold) illegal[3]=1;
    if (V(C3o_t_7)>=threshold) word[3]=word[3] | (1 << 7);
    if (V(C3o_t_8)<threshold && V(C3o_f_8)<threshold) valid_word[3]=0;
    if (V(C3o_t_8)>=threshold || V(C3o_f_8)>=threshold) spacer[3]=0;
    if (V(C3o_t_8)>=threshold && V(C3o_f_8)>=threshold) illegal[3]=1;
    if (V(C3o_t_8)>=threshold) word[3]=word[3] | (1 << 8);
    if (V(C3o_t_9)<threshold && V(C3o_f_9)<threshold) valid_word[3]=0;
    if (V(C3o_t_9)>=threshold || V(C3o_f_9)>=threshold) spacer[3]=0;
    if (V(C3o_t_9)>=threshold && V(C3o_f_9)>=threshold) illegal[3]=1;
    if (V(C3o_t_9)>=threshold) word[3]=word[3] | (1 << 9);
    if (V(C3o_t_10)<threshold && V(C3o_f_10)<threshold) valid_word[3]=0;
    if (V(C3o_t_10)>=threshold || V(C3o_f_10)>=threshold) spacer[3]=0;
    if (V(C3o_t_10)>=threshold && V(C3o_f_10)>=threshold) illegal[3]=1;
    if (V(C3o_t_10)>=threshold) word[3]=word[3] | (1 << 10);
    if (V(C3o_t_11)<threshold && V(C3o_f_11)<threshold) valid_word[3]=0;
    if (V(C3o_t_11)>=threshold || V(C3o_f_11)>=threshold) spacer[3]=0;
    if (V(C3o_t_11)>=threshold && V(C3o_f_11)>=threshold) illegal[3]=1;
    if (V(C3o_t_11)>=threshold) word[3]=word[3] | (1 << 11);
    if (V(C3o_t_12)<threshold && V(C3o_f_12)<threshold) valid_word[3]=0;
    if (V(C3o_t_12)>=threshold || V(C3o_f_12)>=threshold) spacer[3]=0;
    if (V(C3o_t_12)>=threshold && V(C3o_f_12)>=threshold) illegal[3]=1;
    if (V(C3o_t_12)>=threshold) word[3]=word[3] | (1 << 12);
    if (V(C3o_t_13)<threshold && V(C3o_f_13)<threshold) valid_word[3]=0;
    if (V(C3o_t_13)>=threshold || V(C3o_f_13)>=threshold) spacer[3]=0;
    if (V(C3o_t_13)>=threshold && V(C3o_f_13)>=threshold) illegal[3]=1;
    if (V(C3o_t_13)>=threshold) word[3]=word[3] | (1 << 13);
    if (V(C3o_t_14)<threshold && V(C3o_f_14)<threshold) valid_word[3]=0;
    if (V(C3o_t_14)>=threshold || V(C3o_f_14)>=threshold) spacer[3]=0;
    if (V(C3o_t_14)>=threshold && V(C3o_f_14)>=threshold) illegal[3]=1;
    if (V(C3o_t_14)>=threshold) word[3]=word[3] | (1 << 14);
    if (V(C3o_t_15)<threshold && V(C3o_f_15)<threshold) valid_word[3]=0;
    if (V(C3o_t_15)>=threshold || V(C3o_f_15)>=threshold) spacer[3]=0;
    if (V(C3o_t_15)>=threshold && V(C3o_f_15)>=threshold) illegal[3]=1;
    if (V(C3o_t_15)>=threshold) word[3]=word[3] | (1 << 15);
    if (V(C3o_t_16)<threshold && V(C3o_f_16)<threshold) valid_word[3]=0;
    if (V(C3o_t_16)>=threshold || V(C3o_f_16)>=threshold) spacer[3]=0;
    if (V(C3o_t_16)>=threshold && V(C3o_f_16)>=threshold) illegal[3]=1;
    if (V(C3o_t_16)>=threshold) word[3]=word[3] | (1 << 16);
    if (V(C3o_t_17)<threshold && V(C3o_f_17)<threshold) valid_word[3]=0;
    if (V(C3o_t_17)>=threshold || V(C3o_f_17)>=threshold) spacer[3]=0;
    if (V(C3o_t_17)>=threshold && V(C3o_f_17)>=threshold) illegal[3]=1;
    if (V(C3o_t_17)>=threshold) word[3]=word[3] | (1 << 17);
    if (V(C3o_t_18)<threshold && V(C3o_f_18)<threshold) valid_word[3]=0;
    if (V(C3o_t_18)>=threshold || V(C3o_f_18)>=threshold) spacer[3]=0;
    if (V(C3o_t_18)>=threshold && V(C3o_f_18)>=threshold) illegal[3]=1;
    if (V(C3o_t_18)>=threshold) word[3]=word[3] | (1 << 18);
    if (V(C3o_t_19)<threshold && V(C3o_f_19)<threshold) valid_word[3]=0;
    if (V(C3o_t_19)>=threshold || V(C3o_f_19)>=threshold) spacer[3]=0;
    if (V(C3o_t_19)>=threshold && V(C3o_f_19)>=threshold) illegal[3]=1;
    if (V(C3o_t_19)>=threshold) word[3]=word[3] | (1 << 19);
    if (V(C3o_t_20)<threshold && V(C3o_f_20)<threshold) valid_word[3]=0;
    if (V(C3o_t_20)>=threshold || V(C3o_f_20)>=threshold) spacer[3]=0;
    if (V(C3o_t_20)>=threshold && V(C3o_f_20)>=threshold) illegal[3]=1;
    if (V(C3o_t_20)>=threshold) word[3]=word[3] | (1 << 20);
    if (V(C3o_t_21)<threshold && V(C3o_f_21)<threshold) valid_word[3]=0;
    if (V(C3o_t_21)>=threshold || V(C3o_f_21)>=threshold) spacer[3]=0;
    if (V(C3o_t_21)>=threshold && V(C3o_f_21)>=threshold) illegal[3]=1;
    if (V(C3o_t_21)>=threshold) word[3]=word[3] | (1 << 21);
    if (V(C3o_t_22)<threshold && V(C3o_f_22)<threshold) valid_word[3]=0;
    if (V(C3o_t_22)>=threshold || V(C3o_f_22)>=threshold) spacer[3]=0;
    if (V(C3o_t_22)>=threshold && V(C3o_f_22)>=threshold) illegal[3]=1;
    if (V(C3o_t_22)>=threshold) word[3]=word[3] | (1 << 22);
    if (V(C3o_t_23)<threshold && V(C3o_f_23)<threshold) valid_word[3]=0;
    if (V(C3o_t_23)>=threshold || V(C3o_f_23)>=threshold) spacer[3]=0;
    if (V(C3o_t_23)>=threshold && V(C3o_f_23)>=threshold) illegal[3]=1;
    if (V(C3o_t_23)>=threshold) word[3]=word[3] | (1 << 23);
    if (V(C3o_t_24)<threshold && V(C3o_f_24)<threshold) valid_word[3]=0;
    if (V(C3o_t_24)>=threshold || V(C3o_f_24)>=threshold) spacer[3]=0;
    if (V(C3o_t_24)>=threshold && V(C3o_f_24)>=threshold) illegal[3]=1;
    if (V(C3o_t_24)>=threshold) word[3]=word[3] | (1 << 24);
    if (V(C3o_t_25)<threshold && V(C3o_f_25)<threshold) valid_word[3]=0;
    if (V(C3o_t_25)>=threshold || V(C3o_f_25)>=threshold) spacer[3]=0;
    if (V(C3o_t_25)>=threshold && V(C3o_f_25)>=threshold) illegal[3]=1;
    if (V(C3o_t_25)>=threshold) word[3]=word[3] | (1 << 25);
    if (V(C3o_t_26)<threshold && V(C3o_f_26)<threshold) valid_word[3]=0;
    if (V(C3o_t_26)>=threshold || V(C3o_f_26)>=threshold) spacer[3]=0;
    if (V(C3o_t_26)>=threshold && V(C3o_f_26)>=threshold) illegal[3]=1;
    if (V(C3o_t_26)>=threshold) word[3]=word[3] | (1 << 26);
    if (V(C3o_t_27)<threshold && V(C3o_f_27)<threshold) valid_word[3]=0;
    if (V(C3o_t_27)>=threshold || V(C3o_f_27)>=threshold) spacer[3]=0;
    if (V(C3o_t_27)>=threshold && V(C3o_f_27)>=threshold) illegal[3]=1;
    if (V(C3o_t_27)>=threshold) word[3]=word[3] | (1 << 27);
    if (V(C3o_t_28)<threshold && V(C3o_f_28)<threshold) valid_word[3]=0;
    if (V(C3o_t_28)>=threshold || V(C3o_f_28)>=threshold) spacer[3]=0;
    if (V(C3o_t_28)>=threshold && V(C3o_f_28)>=threshold) illegal[3]=1;
    if (V(C3o_t_28)>=threshold) word[3]=word[3] | (1 << 28);
    if (V(C3o_t_29)<threshold && V(C3o_f_29)<threshold) valid_word[3]=0;
    if (V(C3o_t_29)>=threshold || V(C3o_f_29)>=threshold) spacer[3]=0;
    if (V(C3o_t_29)>=threshold && V(C3o_f_29)>=threshold) illegal[3]=1;
    if (V(C3o_t_29)>=threshold) word[3]=word[3] | (1 << 29);
    if (V(C3o_t_30)<threshold && V(C3o_f_30)<threshold) valid_word[3]=0;
    if (V(C3o_t_30)>=threshold || V(C3o_f_30)>=threshold) spacer[3]=0;
    if (V(C3o_t_30)>=threshold && V(C3o_f_30)>=threshold) illegal[3]=1;
    if (V(C3o_t_30)>=threshold) word[3]=word[3] | (1 << 30);
    if (V(C3o_t_31)<threshold && V(C3o_f_31)<threshold) valid_word[3]=0;
    if (V(C3o_t_31)>=threshold || V(C3o_f_31)>=threshold) spacer[3]=0;
    if (V(C3o_t_31)>=threshold && V(C3o_f_31)>=threshold) illegal[3]=1;
    if (V(C3o_t_31)>=threshold) word[3]=word[3] | (1 << 31);
    valid_word[4]=1; spacer[4]=1; illegal[4]=0; word[4]=0;
    if (V(Po_t_0)<threshold && V(Po_f_0)<threshold) valid_word[4]=0;
    if (V(Po_t_0)>=threshold || V(Po_f_0)>=threshold) spacer[4]=0;
    if (V(Po_t_0)>=threshold && V(Po_f_0)>=threshold) illegal[4]=1;
    if (V(Po_t_0)>=threshold) word[4]=word[4] | (1 << 0);
    if (V(Po_t_1)<threshold && V(Po_f_1)<threshold) valid_word[4]=0;
    if (V(Po_t_1)>=threshold || V(Po_f_1)>=threshold) spacer[4]=0;
    if (V(Po_t_1)>=threshold && V(Po_f_1)>=threshold) illegal[4]=1;
    if (V(Po_t_1)>=threshold) word[4]=word[4] | (1 << 1);
    if (V(Po_t_2)<threshold && V(Po_f_2)<threshold) valid_word[4]=0;
    if (V(Po_t_2)>=threshold || V(Po_f_2)>=threshold) spacer[4]=0;
    if (V(Po_t_2)>=threshold && V(Po_f_2)>=threshold) illegal[4]=1;
    if (V(Po_t_2)>=threshold) word[4]=word[4] | (1 << 2);
    if (V(Po_t_3)<threshold && V(Po_f_3)<threshold) valid_word[4]=0;
    if (V(Po_t_3)>=threshold || V(Po_f_3)>=threshold) spacer[4]=0;
    if (V(Po_t_3)>=threshold && V(Po_f_3)>=threshold) illegal[4]=1;
    if (V(Po_t_3)>=threshold) word[4]=word[4] | (1 << 3);
    if (V(Po_t_4)<threshold && V(Po_f_4)<threshold) valid_word[4]=0;
    if (V(Po_t_4)>=threshold || V(Po_f_4)>=threshold) spacer[4]=0;
    if (V(Po_t_4)>=threshold && V(Po_f_4)>=threshold) illegal[4]=1;
    if (V(Po_t_4)>=threshold) word[4]=word[4] | (1 << 4);
    if (V(Po_t_5)<threshold && V(Po_f_5)<threshold) valid_word[4]=0;
    if (V(Po_t_5)>=threshold || V(Po_f_5)>=threshold) spacer[4]=0;
    if (V(Po_t_5)>=threshold && V(Po_f_5)>=threshold) illegal[4]=1;
    if (V(Po_t_5)>=threshold) word[4]=word[4] | (1 << 5);
    if (V(Po_t_6)<threshold && V(Po_f_6)<threshold) valid_word[4]=0;
    if (V(Po_t_6)>=threshold || V(Po_f_6)>=threshold) spacer[4]=0;
    if (V(Po_t_6)>=threshold && V(Po_f_6)>=threshold) illegal[4]=1;
    if (V(Po_t_6)>=threshold) word[4]=word[4] | (1 << 6);
    if (V(Po_t_7)<threshold && V(Po_f_7)<threshold) valid_word[4]=0;
    if (V(Po_t_7)>=threshold || V(Po_f_7)>=threshold) spacer[4]=0;
    if (V(Po_t_7)>=threshold && V(Po_f_7)>=threshold) illegal[4]=1;
    if (V(Po_t_7)>=threshold) word[4]=word[4] | (1 << 7);
    if (V(Po_t_8)<threshold && V(Po_f_8)<threshold) valid_word[4]=0;
    if (V(Po_t_8)>=threshold || V(Po_f_8)>=threshold) spacer[4]=0;
    if (V(Po_t_8)>=threshold && V(Po_f_8)>=threshold) illegal[4]=1;
    if (V(Po_t_8)>=threshold) word[4]=word[4] | (1 << 8);
    if (V(Po_t_9)<threshold && V(Po_f_9)<threshold) valid_word[4]=0;
    if (V(Po_t_9)>=threshold || V(Po_f_9)>=threshold) spacer[4]=0;
    if (V(Po_t_9)>=threshold && V(Po_f_9)>=threshold) illegal[4]=1;
    if (V(Po_t_9)>=threshold) word[4]=word[4] | (1 << 9);
    if (V(Po_t_10)<threshold && V(Po_f_10)<threshold) valid_word[4]=0;
    if (V(Po_t_10)>=threshold || V(Po_f_10)>=threshold) spacer[4]=0;
    if (V(Po_t_10)>=threshold && V(Po_f_10)>=threshold) illegal[4]=1;
    if (V(Po_t_10)>=threshold) word[4]=word[4] | (1 << 10);
    if (V(Po_t_11)<threshold && V(Po_f_11)<threshold) valid_word[4]=0;
    if (V(Po_t_11)>=threshold || V(Po_f_11)>=threshold) spacer[4]=0;
    if (V(Po_t_11)>=threshold && V(Po_f_11)>=threshold) illegal[4]=1;
    if (V(Po_t_11)>=threshold) word[4]=word[4] | (1 << 11);
    if (V(Po_t_12)<threshold && V(Po_f_12)<threshold) valid_word[4]=0;
    if (V(Po_t_12)>=threshold || V(Po_f_12)>=threshold) spacer[4]=0;
    if (V(Po_t_12)>=threshold && V(Po_f_12)>=threshold) illegal[4]=1;
    if (V(Po_t_12)>=threshold) word[4]=word[4] | (1 << 12);
    if (V(Po_t_13)<threshold && V(Po_f_13)<threshold) valid_word[4]=0;
    if (V(Po_t_13)>=threshold || V(Po_f_13)>=threshold) spacer[4]=0;
    if (V(Po_t_13)>=threshold && V(Po_f_13)>=threshold) illegal[4]=1;
    if (V(Po_t_13)>=threshold) word[4]=word[4] | (1 << 13);
    if (V(Po_t_14)<threshold && V(Po_f_14)<threshold) valid_word[4]=0;
    if (V(Po_t_14)>=threshold || V(Po_f_14)>=threshold) spacer[4]=0;
    if (V(Po_t_14)>=threshold && V(Po_f_14)>=threshold) illegal[4]=1;
    if (V(Po_t_14)>=threshold) word[4]=word[4] | (1 << 14);
    if (V(Po_t_15)<threshold && V(Po_f_15)<threshold) valid_word[4]=0;
    if (V(Po_t_15)>=threshold || V(Po_f_15)>=threshold) spacer[4]=0;
    if (V(Po_t_15)>=threshold && V(Po_f_15)>=threshold) illegal[4]=1;
    if (V(Po_t_15)>=threshold) word[4]=word[4] | (1 << 15);
    if (V(Po_t_16)<threshold && V(Po_f_16)<threshold) valid_word[4]=0;
    if (V(Po_t_16)>=threshold || V(Po_f_16)>=threshold) spacer[4]=0;
    if (V(Po_t_16)>=threshold && V(Po_f_16)>=threshold) illegal[4]=1;
    if (V(Po_t_16)>=threshold) word[4]=word[4] | (1 << 16);
    if (V(Po_t_17)<threshold && V(Po_f_17)<threshold) valid_word[4]=0;
    if (V(Po_t_17)>=threshold || V(Po_f_17)>=threshold) spacer[4]=0;
    if (V(Po_t_17)>=threshold && V(Po_f_17)>=threshold) illegal[4]=1;
    if (V(Po_t_17)>=threshold) word[4]=word[4] | (1 << 17);
    if (V(Po_t_18)<threshold && V(Po_f_18)<threshold) valid_word[4]=0;
    if (V(Po_t_18)>=threshold || V(Po_f_18)>=threshold) spacer[4]=0;
    if (V(Po_t_18)>=threshold && V(Po_f_18)>=threshold) illegal[4]=1;
    if (V(Po_t_18)>=threshold) word[4]=word[4] | (1 << 18);
    if (V(Po_t_19)<threshold && V(Po_f_19)<threshold) valid_word[4]=0;
    if (V(Po_t_19)>=threshold || V(Po_f_19)>=threshold) spacer[4]=0;
    if (V(Po_t_19)>=threshold && V(Po_f_19)>=threshold) illegal[4]=1;
    if (V(Po_t_19)>=threshold) word[4]=word[4] | (1 << 19);
    if (V(Po_t_20)<threshold && V(Po_f_20)<threshold) valid_word[4]=0;
    if (V(Po_t_20)>=threshold || V(Po_f_20)>=threshold) spacer[4]=0;
    if (V(Po_t_20)>=threshold && V(Po_f_20)>=threshold) illegal[4]=1;
    if (V(Po_t_20)>=threshold) word[4]=word[4] | (1 << 20);
    if (V(Po_t_21)<threshold && V(Po_f_21)<threshold) valid_word[4]=0;
    if (V(Po_t_21)>=threshold || V(Po_f_21)>=threshold) spacer[4]=0;
    if (V(Po_t_21)>=threshold && V(Po_f_21)>=threshold) illegal[4]=1;
    if (V(Po_t_21)>=threshold) word[4]=word[4] | (1 << 21);
    if (V(Po_t_22)<threshold && V(Po_f_22)<threshold) valid_word[4]=0;
    if (V(Po_t_22)>=threshold || V(Po_f_22)>=threshold) spacer[4]=0;
    if (V(Po_t_22)>=threshold && V(Po_f_22)>=threshold) illegal[4]=1;
    if (V(Po_t_22)>=threshold) word[4]=word[4] | (1 << 22);
    if (V(Po_t_23)<threshold && V(Po_f_23)<threshold) valid_word[4]=0;
    if (V(Po_t_23)>=threshold || V(Po_f_23)>=threshold) spacer[4]=0;
    if (V(Po_t_23)>=threshold && V(Po_f_23)>=threshold) illegal[4]=1;
    if (V(Po_t_23)>=threshold) word[4]=word[4] | (1 << 23);
    if (V(Po_t_24)<threshold && V(Po_f_24)<threshold) valid_word[4]=0;
    if (V(Po_t_24)>=threshold || V(Po_f_24)>=threshold) spacer[4]=0;
    if (V(Po_t_24)>=threshold && V(Po_f_24)>=threshold) illegal[4]=1;
    if (V(Po_t_24)>=threshold) word[4]=word[4] | (1 << 24);
    if (V(Po_t_25)<threshold && V(Po_f_25)<threshold) valid_word[4]=0;
    if (V(Po_t_25)>=threshold || V(Po_f_25)>=threshold) spacer[4]=0;
    if (V(Po_t_25)>=threshold && V(Po_f_25)>=threshold) illegal[4]=1;
    if (V(Po_t_25)>=threshold) word[4]=word[4] | (1 << 25);
    if (V(Po_t_26)<threshold && V(Po_f_26)<threshold) valid_word[4]=0;
    if (V(Po_t_26)>=threshold || V(Po_f_26)>=threshold) spacer[4]=0;
    if (V(Po_t_26)>=threshold && V(Po_f_26)>=threshold) illegal[4]=1;
    if (V(Po_t_26)>=threshold) word[4]=word[4] | (1 << 26);
    if (V(Po_t_27)<threshold && V(Po_f_27)<threshold) valid_word[4]=0;
    if (V(Po_t_27)>=threshold || V(Po_f_27)>=threshold) spacer[4]=0;
    if (V(Po_t_27)>=threshold && V(Po_f_27)>=threshold) illegal[4]=1;
    if (V(Po_t_27)>=threshold) word[4]=word[4] | (1 << 27);
    if (V(Po_t_28)<threshold && V(Po_f_28)<threshold) valid_word[4]=0;
    if (V(Po_t_28)>=threshold || V(Po_f_28)>=threshold) spacer[4]=0;
    if (V(Po_t_28)>=threshold && V(Po_f_28)>=threshold) illegal[4]=1;
    if (V(Po_t_28)>=threshold) word[4]=word[4] | (1 << 28);
    if (V(Po_t_29)<threshold && V(Po_f_29)<threshold) valid_word[4]=0;
    if (V(Po_t_29)>=threshold || V(Po_f_29)>=threshold) spacer[4]=0;
    if (V(Po_t_29)>=threshold && V(Po_f_29)>=threshold) illegal[4]=1;
    if (V(Po_t_29)>=threshold) word[4]=word[4] | (1 << 29);
    if (V(Po_t_30)<threshold && V(Po_f_30)<threshold) valid_word[4]=0;
    if (V(Po_t_30)>=threshold || V(Po_f_30)>=threshold) spacer[4]=0;
    if (V(Po_t_30)>=threshold && V(Po_f_30)>=threshold) illegal[4]=1;
    if (V(Po_t_30)>=threshold) word[4]=word[4] | (1 << 30);
    if (V(Po_t_31)<threshold && V(Po_f_31)<threshold) valid_word[4]=0;
    if (V(Po_t_31)>=threshold || V(Po_f_31)>=threshold) spacer[4]=0;
    if (V(Po_t_31)>=threshold && V(Po_f_31)>=threshold) illegal[4]=1;
    if (V(Po_t_31)>=threshold) word[4]=word[4] | (1 << 31);
    if (!active && !finished && !failure && V(reset)<threshold) begin
      active=1; release_time=$abstime; $display("SIM_RESET t=%e",$abstime);
    end
    if (active && !failure) begin
      if (illegal[0]) begin failure=1; $display("SIM_ERROR t=%e reason=illegal_dual_rail channel=C0o",$abstime); end
      if (!failure && rx_phase[0]==0 && valid_word[0]) begin
        held[0]=word[0];
        if (length[0]>=16) begin failure=1; $display("SIM_ERROR t=%e reason=packet_overflow channel=C0o",$abstime); end
        else begin
          packet[0*16+length[0]]=word[0]; length[0]=length[0]+1;
          $display("SIM_WORD t=%e channel=C0o index=%d actual=%h",$abstime,rx_index[0],word[0]);
          if ((word[0] & 1)!=0) begin
            candidate=-1;
            for (j=0;j<100;j=j+1) begin
              same=(gold_port(0,j)==0 && gold_len(0,j)==length[0] && hits[j]<issued[gold_case(0,j)]);
              if (same) begin
// HSPICE pVA requires an explicit block here to preserve the following if scope.
                for (k=0;k<length[0];k=k+1) begin
                  if (packet[0*16+k]!=gold_word(0,j*16+k)) same=0;
                end
                if (same && candidate<0) candidate=j;
              end
            end
            if (candidate<0) begin
              failure=1; $display("SIM_ERROR t=%e reason=packet_golden_mismatch channel=C0o length=%d",$abstime,length[0]);
              for (k=0;k<length[0];k=k+1) $display("SIM_RECEIVED channel=C0o index=%d word=%h",k,packet[0*16+k]);
            end else begin
              hits[candidate]=hits[candidate]+1;
              $display("SIM_MATCH t=%e channel=C0o entry=%d case=%d length=%d",$abstime,candidate,gold_case(0,candidate),length[0]);
              for (k=0;k<length[0];k=k+1) $display("SIM_RX t=%e channel=C0o packet=%d index=%d expected=%h actual=%h PASS",$abstime,candidate,k,gold_word(0,candidate*16+k),packet[0*16+k]);
              length[0]=0;
            end
          end
        end
        if (!failure) begin ack[0]=1; rx_phase[0]=1; end
      end else if (!failure && rx_phase[0]==1) begin
        if (valid_word[0] && word[0]!=held[0]) begin failure=1; $display("SIM_ERROR t=%e reason=word_changed_without_spacer channel=C0o",$abstime); end
        else if (!valid_word[0] && V(C0o_a)<threshold) begin failure=1; $display("SIM_ERROR t=%e reason=data_withdrawn_before_ack channel=C0o",$abstime); end
        else if (spacer[0] && V(C0o_a)>=threshold) begin
          ack[0]=0; rx_phase[0]=2; $display("SIM_SPACER t=%e channel=C0o index=%d",$abstime,rx_index[0]);
        end
      end else if (!failure && rx_phase[0]==2) begin
        if (!spacer[0]) begin failure=1; $display("SIM_ERROR t=%e reason=data_before_ack_low channel=C0o",$abstime); end
        else if (V(C0o_a)<threshold) begin
          $display("SIM_ACK_LOW t=%e channel=C0o index=%d",$abstime,rx_index[0]);
          rx_index[0]=rx_index[0]+1; rx_phase[0]=0;
        end
      end
      if (illegal[1]) begin failure=1; $display("SIM_ERROR t=%e reason=illegal_dual_rail channel=C1o",$abstime); end
      if (!failure && rx_phase[1]==0 && valid_word[1]) begin
        held[1]=word[1];
        if (length[1]>=16) begin failure=1; $display("SIM_ERROR t=%e reason=packet_overflow channel=C1o",$abstime); end
        else begin
          packet[1*16+length[1]]=word[1]; length[1]=length[1]+1;
          $display("SIM_WORD t=%e channel=C1o index=%d actual=%h",$abstime,rx_index[1],word[1]);
          if ((word[1] & 1)!=0) begin
            candidate=-1;
            for (j=0;j<100;j=j+1) begin
              same=(gold_port(0,j)==1 && gold_len(0,j)==length[1] && hits[j]<issued[gold_case(0,j)]);
              if (same) begin
// HSPICE pVA requires an explicit block here to preserve the following if scope.
                for (k=0;k<length[1];k=k+1) begin
                  if (packet[1*16+k]!=gold_word(0,j*16+k)) same=0;
                end
                if (same && candidate<0) candidate=j;
              end
            end
            if (candidate<0) begin
              failure=1; $display("SIM_ERROR t=%e reason=packet_golden_mismatch channel=C1o length=%d",$abstime,length[1]);
              for (k=0;k<length[1];k=k+1) $display("SIM_RECEIVED channel=C1o index=%d word=%h",k,packet[1*16+k]);
            end else begin
              hits[candidate]=hits[candidate]+1;
              $display("SIM_MATCH t=%e channel=C1o entry=%d case=%d length=%d",$abstime,candidate,gold_case(0,candidate),length[1]);
              for (k=0;k<length[1];k=k+1) $display("SIM_RX t=%e channel=C1o packet=%d index=%d expected=%h actual=%h PASS",$abstime,candidate,k,gold_word(0,candidate*16+k),packet[1*16+k]);
              length[1]=0;
            end
          end
        end
        if (!failure) begin ack[1]=1; rx_phase[1]=1; end
      end else if (!failure && rx_phase[1]==1) begin
        if (valid_word[1] && word[1]!=held[1]) begin failure=1; $display("SIM_ERROR t=%e reason=word_changed_without_spacer channel=C1o",$abstime); end
        else if (!valid_word[1] && V(C1o_a)<threshold) begin failure=1; $display("SIM_ERROR t=%e reason=data_withdrawn_before_ack channel=C1o",$abstime); end
        else if (spacer[1] && V(C1o_a)>=threshold) begin
          ack[1]=0; rx_phase[1]=2; $display("SIM_SPACER t=%e channel=C1o index=%d",$abstime,rx_index[1]);
        end
      end else if (!failure && rx_phase[1]==2) begin
        if (!spacer[1]) begin failure=1; $display("SIM_ERROR t=%e reason=data_before_ack_low channel=C1o",$abstime); end
        else if (V(C1o_a)<threshold) begin
          $display("SIM_ACK_LOW t=%e channel=C1o index=%d",$abstime,rx_index[1]);
          rx_index[1]=rx_index[1]+1; rx_phase[1]=0;
        end
      end
      if (illegal[2]) begin failure=1; $display("SIM_ERROR t=%e reason=illegal_dual_rail channel=C2o",$abstime); end
      if (!failure && rx_phase[2]==0 && valid_word[2]) begin
        held[2]=word[2];
        if (length[2]>=16) begin failure=1; $display("SIM_ERROR t=%e reason=packet_overflow channel=C2o",$abstime); end
        else begin
          packet[2*16+length[2]]=word[2]; length[2]=length[2]+1;
          $display("SIM_WORD t=%e channel=C2o index=%d actual=%h",$abstime,rx_index[2],word[2]);
          if ((word[2] & 1)!=0) begin
            candidate=-1;
            for (j=0;j<100;j=j+1) begin
              same=(gold_port(0,j)==2 && gold_len(0,j)==length[2] && hits[j]<issued[gold_case(0,j)]);
              if (same) begin
// HSPICE pVA requires an explicit block here to preserve the following if scope.
                for (k=0;k<length[2];k=k+1) begin
                  if (packet[2*16+k]!=gold_word(0,j*16+k)) same=0;
                end
                if (same && candidate<0) candidate=j;
              end
            end
            if (candidate<0) begin
              failure=1; $display("SIM_ERROR t=%e reason=packet_golden_mismatch channel=C2o length=%d",$abstime,length[2]);
              for (k=0;k<length[2];k=k+1) $display("SIM_RECEIVED channel=C2o index=%d word=%h",k,packet[2*16+k]);
            end else begin
              hits[candidate]=hits[candidate]+1;
              $display("SIM_MATCH t=%e channel=C2o entry=%d case=%d length=%d",$abstime,candidate,gold_case(0,candidate),length[2]);
              for (k=0;k<length[2];k=k+1) $display("SIM_RX t=%e channel=C2o packet=%d index=%d expected=%h actual=%h PASS",$abstime,candidate,k,gold_word(0,candidate*16+k),packet[2*16+k]);
              length[2]=0;
            end
          end
        end
        if (!failure) begin ack[2]=1; rx_phase[2]=1; end
      end else if (!failure && rx_phase[2]==1) begin
        if (valid_word[2] && word[2]!=held[2]) begin failure=1; $display("SIM_ERROR t=%e reason=word_changed_without_spacer channel=C2o",$abstime); end
        else if (!valid_word[2] && V(C2o_a)<threshold) begin failure=1; $display("SIM_ERROR t=%e reason=data_withdrawn_before_ack channel=C2o",$abstime); end
        else if (spacer[2] && V(C2o_a)>=threshold) begin
          ack[2]=0; rx_phase[2]=2; $display("SIM_SPACER t=%e channel=C2o index=%d",$abstime,rx_index[2]);
        end
      end else if (!failure && rx_phase[2]==2) begin
        if (!spacer[2]) begin failure=1; $display("SIM_ERROR t=%e reason=data_before_ack_low channel=C2o",$abstime); end
        else if (V(C2o_a)<threshold) begin
          $display("SIM_ACK_LOW t=%e channel=C2o index=%d",$abstime,rx_index[2]);
          rx_index[2]=rx_index[2]+1; rx_phase[2]=0;
        end
      end
      if (illegal[3]) begin failure=1; $display("SIM_ERROR t=%e reason=illegal_dual_rail channel=C3o",$abstime); end
      if (!failure && rx_phase[3]==0 && valid_word[3]) begin
        held[3]=word[3];
        if (length[3]>=16) begin failure=1; $display("SIM_ERROR t=%e reason=packet_overflow channel=C3o",$abstime); end
        else begin
          packet[3*16+length[3]]=word[3]; length[3]=length[3]+1;
          $display("SIM_WORD t=%e channel=C3o index=%d actual=%h",$abstime,rx_index[3],word[3]);
          if ((word[3] & 1)!=0) begin
            candidate=-1;
            for (j=0;j<100;j=j+1) begin
              same=(gold_port(0,j)==3 && gold_len(0,j)==length[3] && hits[j]<issued[gold_case(0,j)]);
              if (same) begin
// HSPICE pVA requires an explicit block here to preserve the following if scope.
                for (k=0;k<length[3];k=k+1) begin
                  if (packet[3*16+k]!=gold_word(0,j*16+k)) same=0;
                end
                if (same && candidate<0) candidate=j;
              end
            end
            if (candidate<0) begin
              failure=1; $display("SIM_ERROR t=%e reason=packet_golden_mismatch channel=C3o length=%d",$abstime,length[3]);
              for (k=0;k<length[3];k=k+1) $display("SIM_RECEIVED channel=C3o index=%d word=%h",k,packet[3*16+k]);
            end else begin
              hits[candidate]=hits[candidate]+1;
              $display("SIM_MATCH t=%e channel=C3o entry=%d case=%d length=%d",$abstime,candidate,gold_case(0,candidate),length[3]);
              for (k=0;k<length[3];k=k+1) $display("SIM_RX t=%e channel=C3o packet=%d index=%d expected=%h actual=%h PASS",$abstime,candidate,k,gold_word(0,candidate*16+k),packet[3*16+k]);
              length[3]=0;
            end
          end
        end
        if (!failure) begin ack[3]=1; rx_phase[3]=1; end
      end else if (!failure && rx_phase[3]==1) begin
        if (valid_word[3] && word[3]!=held[3]) begin failure=1; $display("SIM_ERROR t=%e reason=word_changed_without_spacer channel=C3o",$abstime); end
        else if (!valid_word[3] && V(C3o_a)<threshold) begin failure=1; $display("SIM_ERROR t=%e reason=data_withdrawn_before_ack channel=C3o",$abstime); end
        else if (spacer[3] && V(C3o_a)>=threshold) begin
          ack[3]=0; rx_phase[3]=2; $display("SIM_SPACER t=%e channel=C3o index=%d",$abstime,rx_index[3]);
        end
      end else if (!failure && rx_phase[3]==2) begin
        if (!spacer[3]) begin failure=1; $display("SIM_ERROR t=%e reason=data_before_ack_low channel=C3o",$abstime); end
        else if (V(C3o_a)<threshold) begin
          $display("SIM_ACK_LOW t=%e channel=C3o index=%d",$abstime,rx_index[3]);
          rx_index[3]=rx_index[3]+1; rx_phase[3]=0;
        end
      end
      if (illegal[4]) begin failure=1; $display("SIM_ERROR t=%e reason=illegal_dual_rail channel=Po",$abstime); end
      if (!failure && rx_phase[4]==0 && valid_word[4]) begin
        held[4]=word[4];
        if (length[4]>=16) begin failure=1; $display("SIM_ERROR t=%e reason=packet_overflow channel=Po",$abstime); end
        else begin
          packet[4*16+length[4]]=word[4]; length[4]=length[4]+1;
          $display("SIM_WORD t=%e channel=Po index=%d actual=%h",$abstime,rx_index[4],word[4]);
          if ((word[4] & 1)!=0) begin
            candidate=-1;
            for (j=0;j<100;j=j+1) begin
              same=(gold_port(0,j)==4 && gold_len(0,j)==length[4] && hits[j]<issued[gold_case(0,j)]);
              if (same) begin
// HSPICE pVA requires an explicit block here to preserve the following if scope.
                for (k=0;k<length[4];k=k+1) begin
                  if (packet[4*16+k]!=gold_word(0,j*16+k)) same=0;
                end
                if (same && candidate<0) candidate=j;
              end
            end
            if (candidate<0) begin
              failure=1; $display("SIM_ERROR t=%e reason=packet_golden_mismatch channel=Po length=%d",$abstime,length[4]);
              for (k=0;k<length[4];k=k+1) $display("SIM_RECEIVED channel=Po index=%d word=%h",k,packet[4*16+k]);
            end else begin
              hits[candidate]=hits[candidate]+1;
              $display("SIM_MATCH t=%e channel=Po entry=%d case=%d length=%d",$abstime,candidate,gold_case(0,candidate),length[4]);
              for (k=0;k<length[4];k=k+1) $display("SIM_RX t=%e channel=Po packet=%d index=%d expected=%h actual=%h PASS",$abstime,candidate,k,gold_word(0,candidate*16+k),packet[4*16+k]);
              length[4]=0;
            end
          end
        end
        if (!failure) begin ack[4]=1; rx_phase[4]=1; end
      end else if (!failure && rx_phase[4]==1) begin
        if (valid_word[4] && word[4]!=held[4]) begin failure=1; $display("SIM_ERROR t=%e reason=word_changed_without_spacer channel=Po",$abstime); end
        else if (!valid_word[4] && V(Po_a)<threshold) begin failure=1; $display("SIM_ERROR t=%e reason=data_withdrawn_before_ack channel=Po",$abstime); end
        else if (spacer[4] && V(Po_a)>=threshold) begin
          ack[4]=0; rx_phase[4]=2; $display("SIM_SPACER t=%e channel=Po index=%d",$abstime,rx_index[4]);
        end
      end else if (!failure && rx_phase[4]==2) begin
        if (!spacer[4]) begin failure=1; $display("SIM_ERROR t=%e reason=data_before_ack_low channel=Po",$abstime); end
        else if (V(Po_a)<threshold) begin
          $display("SIM_ACK_LOW t=%e channel=Po index=%d",$abstime,rx_index[4]);
          rx_index[4]=rx_index[4]+1; rx_phase[4]=0;
        end
      end
      if (!failure && tx_phase[0]==1 && V(C0i_a)>=threshold) begin
        tx_valid[0]=0; tx_phase[0]=2;
        $display("SIM_IACK_HIGH t=%e channel=C0i index=%d",$abstime,tx_index[0]);
      end else if (!failure && tx_phase[0]==2 && V(C0i_a)<threshold && input_spacer[0]) begin
        $display("SIM_IACK_LOW t=%e channel=C0i index=%d",$abstime,tx_index[0]);
        tx_index[0]=tx_index[0]+1; tx_phase[0]=0;
      end
      if (!failure && tx_phase[0]==0 && tx_index[0]<30 && V(C0i_a)<threshold && input_spacer[0] && $abstime>=release_time+0*TICK) begin
        tx_word[0]=stimulus(0,tx_index[0]); tx_valid[0]=1; tx_phase[0]=1;
        if (case_start(0,tx_index[0])) issued[case_id(0,tx_index[0])]=1;
        $display("SIM_TX t=%e channel=C0i index=%d word=%h",$abstime,tx_index[0],tx_word[0]);
      end
      if (!failure && tx_phase[1]==1 && V(C1i_a)>=threshold) begin
        tx_valid[1]=0; tx_phase[1]=2;
        $display("SIM_IACK_HIGH t=%e channel=C1i index=%d",$abstime,tx_index[1]);
      end else if (!failure && tx_phase[1]==2 && V(C1i_a)<threshold && input_spacer[1]) begin
        $display("SIM_IACK_LOW t=%e channel=C1i index=%d",$abstime,tx_index[1]);
        tx_index[1]=tx_index[1]+1; tx_phase[1]=0;
      end
      if (!failure && tx_phase[1]==0 && tx_index[1]<30 && V(C1i_a)<threshold && input_spacer[1] && $abstime>=release_time+2*TICK) begin
        tx_word[1]=stimulus(1,tx_index[1]); tx_valid[1]=1; tx_phase[1]=1;
        if (case_start(1,tx_index[1])) issued[case_id(1,tx_index[1])]=1;
        $display("SIM_TX t=%e channel=C1i index=%d word=%h",$abstime,tx_index[1],tx_word[1]);
      end
      if (!failure && tx_phase[2]==1 && V(C2i_a)>=threshold) begin
        tx_valid[2]=0; tx_phase[2]=2;
        $display("SIM_IACK_HIGH t=%e channel=C2i index=%d",$abstime,tx_index[2]);
      end else if (!failure && tx_phase[2]==2 && V(C2i_a)<threshold && input_spacer[2]) begin
        $display("SIM_IACK_LOW t=%e channel=C2i index=%d",$abstime,tx_index[2]);
        tx_index[2]=tx_index[2]+1; tx_phase[2]=0;
      end
      if (!failure && tx_phase[2]==0 && tx_index[2]<30 && V(C2i_a)<threshold && input_spacer[2] && $abstime>=release_time+4*TICK) begin
        tx_word[2]=stimulus(2,tx_index[2]); tx_valid[2]=1; tx_phase[2]=1;
        if (case_start(2,tx_index[2])) issued[case_id(2,tx_index[2])]=1;
        $display("SIM_TX t=%e channel=C2i index=%d word=%h",$abstime,tx_index[2],tx_word[2]);
      end
      if (!failure && tx_phase[3]==1 && V(C3i_a)>=threshold) begin
        tx_valid[3]=0; tx_phase[3]=2;
        $display("SIM_IACK_HIGH t=%e channel=C3i index=%d",$abstime,tx_index[3]);
      end else if (!failure && tx_phase[3]==2 && V(C3i_a)<threshold && input_spacer[3]) begin
        $display("SIM_IACK_LOW t=%e channel=C3i index=%d",$abstime,tx_index[3]);
        tx_index[3]=tx_index[3]+1; tx_phase[3]=0;
      end
      if (!failure && tx_phase[3]==0 && tx_index[3]<30 && V(C3i_a)<threshold && input_spacer[3] && $abstime>=release_time+6*TICK) begin
        tx_word[3]=stimulus(3,tx_index[3]); tx_valid[3]=1; tx_phase[3]=1;
        if (case_start(3,tx_index[3])) issued[case_id(3,tx_index[3])]=1;
        $display("SIM_TX t=%e channel=C3i index=%d word=%h",$abstime,tx_index[3],tx_word[3]);
      end
      if (!failure && tx_phase[4]==1 && V(Pi_a)>=threshold) begin
        tx_valid[4]=0; tx_phase[4]=2;
        $display("SIM_IACK_HIGH t=%e channel=Pi index=%d",$abstime,tx_index[4]);
      end else if (!failure && tx_phase[4]==2 && V(Pi_a)<threshold && input_spacer[4]) begin
        $display("SIM_IACK_LOW t=%e channel=Pi index=%d",$abstime,tx_index[4]);
        tx_index[4]=tx_index[4]+1; tx_phase[4]=0;
      end
      if (!failure && tx_phase[4]==0 && tx_index[4]<46 && V(Pi_a)<threshold && input_spacer[4] && $abstime>=release_time+8*TICK) begin
        tx_word[4]=stimulus(4,tx_index[4]); tx_valid[4]=1; tx_phase[4]=1;
        if (case_start(4,tx_index[4])) issued[case_id(4,tx_index[4])]=1;
        $display("SIM_TX t=%e channel=Pi index=%d word=%h",$abstime,tx_index[4],tx_word[4]);
      end
    end
    all_complete=1; quiescent=1;
    if (tx_index[0]!=30 || tx_phase[0]!=0) all_complete=0;
    if (!input_spacer[0] || V(C0i_a)>=threshold) quiescent=0;
    if (tx_index[1]!=30 || tx_phase[1]!=0) all_complete=0;
    if (!input_spacer[1] || V(C1i_a)>=threshold) quiescent=0;
    if (tx_index[2]!=30 || tx_phase[2]!=0) all_complete=0;
    if (!input_spacer[2] || V(C2i_a)>=threshold) quiescent=0;
    if (tx_index[3]!=30 || tx_phase[3]!=0) all_complete=0;
    if (!input_spacer[3] || V(C3i_a)>=threshold) quiescent=0;
    if (tx_index[4]!=46 || tx_phase[4]!=0) all_complete=0;
    if (!input_spacer[4] || V(Pi_a)>=threshold) quiescent=0;
    if (rx_index[0]!=22 || rx_phase[0]!=0) all_complete=0;
    if (!spacer[0] || V(C0o_a)>=threshold) quiescent=0;
    if (rx_index[1]!=22 || rx_phase[1]!=0) all_complete=0;
    if (!spacer[1] || V(C1o_a)>=threshold) quiescent=0;
    if (rx_index[2]!=80 || rx_phase[2]!=0) all_complete=0;
    if (!spacer[2] || V(C2o_a)>=threshold) quiescent=0;
    if (rx_index[3]!=80 || rx_phase[3]!=0) all_complete=0;
    if (!spacer[3] || V(C3o_a)>=threshold) quiescent=0;
    if (rx_index[4]!=12 || rx_phase[4]!=0) all_complete=0;
    if (!spacer[4] || V(Po_a)>=threshold) quiescent=0;
    for (j=0;j<100;j=j+1) if (hits[j]!=1) all_complete=0;
    for (j=0;j<56;j=j+1) if (issued[j]!=1) all_complete=0;
    for (j=0;j<5;j=j+1) if (length[j]!=0) all_complete=0;
    if (active && !failure && all_complete && quiescent) begin
      finished=1; active=0; $display("SIM_ROUND t=%e inputs=166 outputs=216 packets=100 cases=56",$abstime);
    end
    if (finished && !quiescent && !failure) begin failure=1; $display("SIM_ERROR t=%e reason=nonquiescent_completion",$abstime); end
    if (finished && !failure && idle_start < 0) idle_start=$abstime+IDLE_SETTLE;
    if (finished && !failure && !idle_started && $abstime>=idle_start) begin
      idle_started=1;
      $display("SIM_IDLE_BEGIN t=%e reset=%e",$abstime,V(reset));
    end
    if (idle_started && !failure && !idle_completed && $abstime>=idle_start+IDLE_WINDOW) begin
      idle_completed=1;
      $display("SIM_IDLE_END t=%e reset=%e",$abstime,V(reset));
    end
    if (failure && (stop_after<0 || stop_after>$abstime+TD+2*EDGE)) stop_after=$abstime+TD+2*EDGE;
    else if (finished && stop_after<0) stop_after=$abstime+IDLE_SETTLE+IDLE_WINDOW+IDLE_MARGIN;
    if (!reported && stop_after>0 && $abstime>=stop_after) begin
      reported=1;
      if (failure) $display("SIM_FAIL t=%e reason=see_SIM_ERROR",$abstime);
      else $display("SIM_PASS t=%e rounds=1 inputs=166 outputs=216 packets=100 cases=56",$abstime);
      $finish(0);
    end
  end
  @(timer(STOP_TIME-4*TD-4*EDGE)) begin
    if (!finished && !failure) begin
      failure=1; $display("SIM_ERROR t=%e reason=timeout",$abstime);
      $display("SIM_STATE channel=C0i sent=%d phase=%d ack=%e",tx_index[0],tx_phase[0],V(C0i_a));
      $display("SIM_STATE channel=C1i sent=%d phase=%d ack=%e",tx_index[1],tx_phase[1],V(C1i_a));
      $display("SIM_STATE channel=C2i sent=%d phase=%d ack=%e",tx_index[2],tx_phase[2],V(C2i_a));
      $display("SIM_STATE channel=C3i sent=%d phase=%d ack=%e",tx_index[3],tx_phase[3],V(C3i_a));
      $display("SIM_STATE channel=Pi sent=%d phase=%d ack=%e",tx_index[4],tx_phase[4],V(Pi_a));
      $display("SIM_STATE channel=C0o received=%d phase=%d ack=%e",rx_index[0],rx_phase[0],V(C0o_a));
      $display("SIM_STATE channel=C1o received=%d phase=%d ack=%e",rx_index[1],rx_phase[1],V(C1o_a));
      $display("SIM_STATE channel=C2o received=%d phase=%d ack=%e",rx_index[2],rx_phase[2],V(C2o_a));
      $display("SIM_STATE channel=C3o received=%d phase=%d ack=%e",rx_index[3],rx_phase[3],V(C3o_a));
      $display("SIM_STATE channel=Po received=%d phase=%d ack=%e",rx_index[4],rx_phase[4],V(Po_a));
    end
  end
  V(C0i_t_0) <+ transition(SUPPLY*tx_valid[0]*((tx_word[0] >> 0) & 1),TD,EDGE,EDGE);
  V(C0i_f_0) <+ transition(SUPPLY*tx_valid[0]*(1-((tx_word[0] >> 0) & 1)),TD,EDGE,EDGE);
  V(C0i_t_1) <+ transition(SUPPLY*tx_valid[0]*((tx_word[0] >> 1) & 1),TD,EDGE,EDGE);
  V(C0i_f_1) <+ transition(SUPPLY*tx_valid[0]*(1-((tx_word[0] >> 1) & 1)),TD,EDGE,EDGE);
  V(C0i_t_2) <+ transition(SUPPLY*tx_valid[0]*((tx_word[0] >> 2) & 1),TD,EDGE,EDGE);
  V(C0i_f_2) <+ transition(SUPPLY*tx_valid[0]*(1-((tx_word[0] >> 2) & 1)),TD,EDGE,EDGE);
  V(C0i_t_3) <+ transition(SUPPLY*tx_valid[0]*((tx_word[0] >> 3) & 1),TD,EDGE,EDGE);
  V(C0i_f_3) <+ transition(SUPPLY*tx_valid[0]*(1-((tx_word[0] >> 3) & 1)),TD,EDGE,EDGE);
  V(C0i_t_4) <+ transition(SUPPLY*tx_valid[0]*((tx_word[0] >> 4) & 1),TD,EDGE,EDGE);
  V(C0i_f_4) <+ transition(SUPPLY*tx_valid[0]*(1-((tx_word[0] >> 4) & 1)),TD,EDGE,EDGE);
  V(C0i_t_5) <+ transition(SUPPLY*tx_valid[0]*((tx_word[0] >> 5) & 1),TD,EDGE,EDGE);
  V(C0i_f_5) <+ transition(SUPPLY*tx_valid[0]*(1-((tx_word[0] >> 5) & 1)),TD,EDGE,EDGE);
  V(C0i_t_6) <+ transition(SUPPLY*tx_valid[0]*((tx_word[0] >> 6) & 1),TD,EDGE,EDGE);
  V(C0i_f_6) <+ transition(SUPPLY*tx_valid[0]*(1-((tx_word[0] >> 6) & 1)),TD,EDGE,EDGE);
  V(C0i_t_7) <+ transition(SUPPLY*tx_valid[0]*((tx_word[0] >> 7) & 1),TD,EDGE,EDGE);
  V(C0i_f_7) <+ transition(SUPPLY*tx_valid[0]*(1-((tx_word[0] >> 7) & 1)),TD,EDGE,EDGE);
  V(C0i_t_8) <+ transition(SUPPLY*tx_valid[0]*((tx_word[0] >> 8) & 1),TD,EDGE,EDGE);
  V(C0i_f_8) <+ transition(SUPPLY*tx_valid[0]*(1-((tx_word[0] >> 8) & 1)),TD,EDGE,EDGE);
  V(C0i_t_9) <+ transition(SUPPLY*tx_valid[0]*((tx_word[0] >> 9) & 1),TD,EDGE,EDGE);
  V(C0i_f_9) <+ transition(SUPPLY*tx_valid[0]*(1-((tx_word[0] >> 9) & 1)),TD,EDGE,EDGE);
  V(C0i_t_10) <+ transition(SUPPLY*tx_valid[0]*((tx_word[0] >> 10) & 1),TD,EDGE,EDGE);
  V(C0i_f_10) <+ transition(SUPPLY*tx_valid[0]*(1-((tx_word[0] >> 10) & 1)),TD,EDGE,EDGE);
  V(C0i_t_11) <+ transition(SUPPLY*tx_valid[0]*((tx_word[0] >> 11) & 1),TD,EDGE,EDGE);
  V(C0i_f_11) <+ transition(SUPPLY*tx_valid[0]*(1-((tx_word[0] >> 11) & 1)),TD,EDGE,EDGE);
  V(C0i_t_12) <+ transition(SUPPLY*tx_valid[0]*((tx_word[0] >> 12) & 1),TD,EDGE,EDGE);
  V(C0i_f_12) <+ transition(SUPPLY*tx_valid[0]*(1-((tx_word[0] >> 12) & 1)),TD,EDGE,EDGE);
  V(C0i_t_13) <+ transition(SUPPLY*tx_valid[0]*((tx_word[0] >> 13) & 1),TD,EDGE,EDGE);
  V(C0i_f_13) <+ transition(SUPPLY*tx_valid[0]*(1-((tx_word[0] >> 13) & 1)),TD,EDGE,EDGE);
  V(C0i_t_14) <+ transition(SUPPLY*tx_valid[0]*((tx_word[0] >> 14) & 1),TD,EDGE,EDGE);
  V(C0i_f_14) <+ transition(SUPPLY*tx_valid[0]*(1-((tx_word[0] >> 14) & 1)),TD,EDGE,EDGE);
  V(C0i_t_15) <+ transition(SUPPLY*tx_valid[0]*((tx_word[0] >> 15) & 1),TD,EDGE,EDGE);
  V(C0i_f_15) <+ transition(SUPPLY*tx_valid[0]*(1-((tx_word[0] >> 15) & 1)),TD,EDGE,EDGE);
  V(C0i_t_16) <+ transition(SUPPLY*tx_valid[0]*((tx_word[0] >> 16) & 1),TD,EDGE,EDGE);
  V(C0i_f_16) <+ transition(SUPPLY*tx_valid[0]*(1-((tx_word[0] >> 16) & 1)),TD,EDGE,EDGE);
  V(C0i_t_17) <+ transition(SUPPLY*tx_valid[0]*((tx_word[0] >> 17) & 1),TD,EDGE,EDGE);
  V(C0i_f_17) <+ transition(SUPPLY*tx_valid[0]*(1-((tx_word[0] >> 17) & 1)),TD,EDGE,EDGE);
  V(C0i_t_18) <+ transition(SUPPLY*tx_valid[0]*((tx_word[0] >> 18) & 1),TD,EDGE,EDGE);
  V(C0i_f_18) <+ transition(SUPPLY*tx_valid[0]*(1-((tx_word[0] >> 18) & 1)),TD,EDGE,EDGE);
  V(C0i_t_19) <+ transition(SUPPLY*tx_valid[0]*((tx_word[0] >> 19) & 1),TD,EDGE,EDGE);
  V(C0i_f_19) <+ transition(SUPPLY*tx_valid[0]*(1-((tx_word[0] >> 19) & 1)),TD,EDGE,EDGE);
  V(C0i_t_20) <+ transition(SUPPLY*tx_valid[0]*((tx_word[0] >> 20) & 1),TD,EDGE,EDGE);
  V(C0i_f_20) <+ transition(SUPPLY*tx_valid[0]*(1-((tx_word[0] >> 20) & 1)),TD,EDGE,EDGE);
  V(C0i_t_21) <+ transition(SUPPLY*tx_valid[0]*((tx_word[0] >> 21) & 1),TD,EDGE,EDGE);
  V(C0i_f_21) <+ transition(SUPPLY*tx_valid[0]*(1-((tx_word[0] >> 21) & 1)),TD,EDGE,EDGE);
  V(C0i_t_22) <+ transition(SUPPLY*tx_valid[0]*((tx_word[0] >> 22) & 1),TD,EDGE,EDGE);
  V(C0i_f_22) <+ transition(SUPPLY*tx_valid[0]*(1-((tx_word[0] >> 22) & 1)),TD,EDGE,EDGE);
  V(C0i_t_23) <+ transition(SUPPLY*tx_valid[0]*((tx_word[0] >> 23) & 1),TD,EDGE,EDGE);
  V(C0i_f_23) <+ transition(SUPPLY*tx_valid[0]*(1-((tx_word[0] >> 23) & 1)),TD,EDGE,EDGE);
  V(C0i_t_24) <+ transition(SUPPLY*tx_valid[0]*((tx_word[0] >> 24) & 1),TD,EDGE,EDGE);
  V(C0i_f_24) <+ transition(SUPPLY*tx_valid[0]*(1-((tx_word[0] >> 24) & 1)),TD,EDGE,EDGE);
  V(C0i_t_25) <+ transition(SUPPLY*tx_valid[0]*((tx_word[0] >> 25) & 1),TD,EDGE,EDGE);
  V(C0i_f_25) <+ transition(SUPPLY*tx_valid[0]*(1-((tx_word[0] >> 25) & 1)),TD,EDGE,EDGE);
  V(C0i_t_26) <+ transition(SUPPLY*tx_valid[0]*((tx_word[0] >> 26) & 1),TD,EDGE,EDGE);
  V(C0i_f_26) <+ transition(SUPPLY*tx_valid[0]*(1-((tx_word[0] >> 26) & 1)),TD,EDGE,EDGE);
  V(C0i_t_27) <+ transition(SUPPLY*tx_valid[0]*((tx_word[0] >> 27) & 1),TD,EDGE,EDGE);
  V(C0i_f_27) <+ transition(SUPPLY*tx_valid[0]*(1-((tx_word[0] >> 27) & 1)),TD,EDGE,EDGE);
  V(C0i_t_28) <+ transition(SUPPLY*tx_valid[0]*((tx_word[0] >> 28) & 1),TD,EDGE,EDGE);
  V(C0i_f_28) <+ transition(SUPPLY*tx_valid[0]*(1-((tx_word[0] >> 28) & 1)),TD,EDGE,EDGE);
  V(C0i_t_29) <+ transition(SUPPLY*tx_valid[0]*((tx_word[0] >> 29) & 1),TD,EDGE,EDGE);
  V(C0i_f_29) <+ transition(SUPPLY*tx_valid[0]*(1-((tx_word[0] >> 29) & 1)),TD,EDGE,EDGE);
  V(C0i_t_30) <+ transition(SUPPLY*tx_valid[0]*((tx_word[0] >> 30) & 1),TD,EDGE,EDGE);
  V(C0i_f_30) <+ transition(SUPPLY*tx_valid[0]*(1-((tx_word[0] >> 30) & 1)),TD,EDGE,EDGE);
  V(C0i_t_31) <+ transition(SUPPLY*tx_valid[0]*((tx_word[0] >> 31) & 1),TD,EDGE,EDGE);
  V(C0i_f_31) <+ transition(SUPPLY*tx_valid[0]*(1-((tx_word[0] >> 31) & 1)),TD,EDGE,EDGE);
  V(C1i_t_0) <+ transition(SUPPLY*tx_valid[1]*((tx_word[1] >> 0) & 1),TD,EDGE,EDGE);
  V(C1i_f_0) <+ transition(SUPPLY*tx_valid[1]*(1-((tx_word[1] >> 0) & 1)),TD,EDGE,EDGE);
  V(C1i_t_1) <+ transition(SUPPLY*tx_valid[1]*((tx_word[1] >> 1) & 1),TD,EDGE,EDGE);
  V(C1i_f_1) <+ transition(SUPPLY*tx_valid[1]*(1-((tx_word[1] >> 1) & 1)),TD,EDGE,EDGE);
  V(C1i_t_2) <+ transition(SUPPLY*tx_valid[1]*((tx_word[1] >> 2) & 1),TD,EDGE,EDGE);
  V(C1i_f_2) <+ transition(SUPPLY*tx_valid[1]*(1-((tx_word[1] >> 2) & 1)),TD,EDGE,EDGE);
  V(C1i_t_3) <+ transition(SUPPLY*tx_valid[1]*((tx_word[1] >> 3) & 1),TD,EDGE,EDGE);
  V(C1i_f_3) <+ transition(SUPPLY*tx_valid[1]*(1-((tx_word[1] >> 3) & 1)),TD,EDGE,EDGE);
  V(C1i_t_4) <+ transition(SUPPLY*tx_valid[1]*((tx_word[1] >> 4) & 1),TD,EDGE,EDGE);
  V(C1i_f_4) <+ transition(SUPPLY*tx_valid[1]*(1-((tx_word[1] >> 4) & 1)),TD,EDGE,EDGE);
  V(C1i_t_5) <+ transition(SUPPLY*tx_valid[1]*((tx_word[1] >> 5) & 1),TD,EDGE,EDGE);
  V(C1i_f_5) <+ transition(SUPPLY*tx_valid[1]*(1-((tx_word[1] >> 5) & 1)),TD,EDGE,EDGE);
  V(C1i_t_6) <+ transition(SUPPLY*tx_valid[1]*((tx_word[1] >> 6) & 1),TD,EDGE,EDGE);
  V(C1i_f_6) <+ transition(SUPPLY*tx_valid[1]*(1-((tx_word[1] >> 6) & 1)),TD,EDGE,EDGE);
  V(C1i_t_7) <+ transition(SUPPLY*tx_valid[1]*((tx_word[1] >> 7) & 1),TD,EDGE,EDGE);
  V(C1i_f_7) <+ transition(SUPPLY*tx_valid[1]*(1-((tx_word[1] >> 7) & 1)),TD,EDGE,EDGE);
  V(C1i_t_8) <+ transition(SUPPLY*tx_valid[1]*((tx_word[1] >> 8) & 1),TD,EDGE,EDGE);
  V(C1i_f_8) <+ transition(SUPPLY*tx_valid[1]*(1-((tx_word[1] >> 8) & 1)),TD,EDGE,EDGE);
  V(C1i_t_9) <+ transition(SUPPLY*tx_valid[1]*((tx_word[1] >> 9) & 1),TD,EDGE,EDGE);
  V(C1i_f_9) <+ transition(SUPPLY*tx_valid[1]*(1-((tx_word[1] >> 9) & 1)),TD,EDGE,EDGE);
  V(C1i_t_10) <+ transition(SUPPLY*tx_valid[1]*((tx_word[1] >> 10) & 1),TD,EDGE,EDGE);
  V(C1i_f_10) <+ transition(SUPPLY*tx_valid[1]*(1-((tx_word[1] >> 10) & 1)),TD,EDGE,EDGE);
  V(C1i_t_11) <+ transition(SUPPLY*tx_valid[1]*((tx_word[1] >> 11) & 1),TD,EDGE,EDGE);
  V(C1i_f_11) <+ transition(SUPPLY*tx_valid[1]*(1-((tx_word[1] >> 11) & 1)),TD,EDGE,EDGE);
  V(C1i_t_12) <+ transition(SUPPLY*tx_valid[1]*((tx_word[1] >> 12) & 1),TD,EDGE,EDGE);
  V(C1i_f_12) <+ transition(SUPPLY*tx_valid[1]*(1-((tx_word[1] >> 12) & 1)),TD,EDGE,EDGE);
  V(C1i_t_13) <+ transition(SUPPLY*tx_valid[1]*((tx_word[1] >> 13) & 1),TD,EDGE,EDGE);
  V(C1i_f_13) <+ transition(SUPPLY*tx_valid[1]*(1-((tx_word[1] >> 13) & 1)),TD,EDGE,EDGE);
  V(C1i_t_14) <+ transition(SUPPLY*tx_valid[1]*((tx_word[1] >> 14) & 1),TD,EDGE,EDGE);
  V(C1i_f_14) <+ transition(SUPPLY*tx_valid[1]*(1-((tx_word[1] >> 14) & 1)),TD,EDGE,EDGE);
  V(C1i_t_15) <+ transition(SUPPLY*tx_valid[1]*((tx_word[1] >> 15) & 1),TD,EDGE,EDGE);
  V(C1i_f_15) <+ transition(SUPPLY*tx_valid[1]*(1-((tx_word[1] >> 15) & 1)),TD,EDGE,EDGE);
  V(C1i_t_16) <+ transition(SUPPLY*tx_valid[1]*((tx_word[1] >> 16) & 1),TD,EDGE,EDGE);
  V(C1i_f_16) <+ transition(SUPPLY*tx_valid[1]*(1-((tx_word[1] >> 16) & 1)),TD,EDGE,EDGE);
  V(C1i_t_17) <+ transition(SUPPLY*tx_valid[1]*((tx_word[1] >> 17) & 1),TD,EDGE,EDGE);
  V(C1i_f_17) <+ transition(SUPPLY*tx_valid[1]*(1-((tx_word[1] >> 17) & 1)),TD,EDGE,EDGE);
  V(C1i_t_18) <+ transition(SUPPLY*tx_valid[1]*((tx_word[1] >> 18) & 1),TD,EDGE,EDGE);
  V(C1i_f_18) <+ transition(SUPPLY*tx_valid[1]*(1-((tx_word[1] >> 18) & 1)),TD,EDGE,EDGE);
  V(C1i_t_19) <+ transition(SUPPLY*tx_valid[1]*((tx_word[1] >> 19) & 1),TD,EDGE,EDGE);
  V(C1i_f_19) <+ transition(SUPPLY*tx_valid[1]*(1-((tx_word[1] >> 19) & 1)),TD,EDGE,EDGE);
  V(C1i_t_20) <+ transition(SUPPLY*tx_valid[1]*((tx_word[1] >> 20) & 1),TD,EDGE,EDGE);
  V(C1i_f_20) <+ transition(SUPPLY*tx_valid[1]*(1-((tx_word[1] >> 20) & 1)),TD,EDGE,EDGE);
  V(C1i_t_21) <+ transition(SUPPLY*tx_valid[1]*((tx_word[1] >> 21) & 1),TD,EDGE,EDGE);
  V(C1i_f_21) <+ transition(SUPPLY*tx_valid[1]*(1-((tx_word[1] >> 21) & 1)),TD,EDGE,EDGE);
  V(C1i_t_22) <+ transition(SUPPLY*tx_valid[1]*((tx_word[1] >> 22) & 1),TD,EDGE,EDGE);
  V(C1i_f_22) <+ transition(SUPPLY*tx_valid[1]*(1-((tx_word[1] >> 22) & 1)),TD,EDGE,EDGE);
  V(C1i_t_23) <+ transition(SUPPLY*tx_valid[1]*((tx_word[1] >> 23) & 1),TD,EDGE,EDGE);
  V(C1i_f_23) <+ transition(SUPPLY*tx_valid[1]*(1-((tx_word[1] >> 23) & 1)),TD,EDGE,EDGE);
  V(C1i_t_24) <+ transition(SUPPLY*tx_valid[1]*((tx_word[1] >> 24) & 1),TD,EDGE,EDGE);
  V(C1i_f_24) <+ transition(SUPPLY*tx_valid[1]*(1-((tx_word[1] >> 24) & 1)),TD,EDGE,EDGE);
  V(C1i_t_25) <+ transition(SUPPLY*tx_valid[1]*((tx_word[1] >> 25) & 1),TD,EDGE,EDGE);
  V(C1i_f_25) <+ transition(SUPPLY*tx_valid[1]*(1-((tx_word[1] >> 25) & 1)),TD,EDGE,EDGE);
  V(C1i_t_26) <+ transition(SUPPLY*tx_valid[1]*((tx_word[1] >> 26) & 1),TD,EDGE,EDGE);
  V(C1i_f_26) <+ transition(SUPPLY*tx_valid[1]*(1-((tx_word[1] >> 26) & 1)),TD,EDGE,EDGE);
  V(C1i_t_27) <+ transition(SUPPLY*tx_valid[1]*((tx_word[1] >> 27) & 1),TD,EDGE,EDGE);
  V(C1i_f_27) <+ transition(SUPPLY*tx_valid[1]*(1-((tx_word[1] >> 27) & 1)),TD,EDGE,EDGE);
  V(C1i_t_28) <+ transition(SUPPLY*tx_valid[1]*((tx_word[1] >> 28) & 1),TD,EDGE,EDGE);
  V(C1i_f_28) <+ transition(SUPPLY*tx_valid[1]*(1-((tx_word[1] >> 28) & 1)),TD,EDGE,EDGE);
  V(C1i_t_29) <+ transition(SUPPLY*tx_valid[1]*((tx_word[1] >> 29) & 1),TD,EDGE,EDGE);
  V(C1i_f_29) <+ transition(SUPPLY*tx_valid[1]*(1-((tx_word[1] >> 29) & 1)),TD,EDGE,EDGE);
  V(C1i_t_30) <+ transition(SUPPLY*tx_valid[1]*((tx_word[1] >> 30) & 1),TD,EDGE,EDGE);
  V(C1i_f_30) <+ transition(SUPPLY*tx_valid[1]*(1-((tx_word[1] >> 30) & 1)),TD,EDGE,EDGE);
  V(C1i_t_31) <+ transition(SUPPLY*tx_valid[1]*((tx_word[1] >> 31) & 1),TD,EDGE,EDGE);
  V(C1i_f_31) <+ transition(SUPPLY*tx_valid[1]*(1-((tx_word[1] >> 31) & 1)),TD,EDGE,EDGE);
  V(C2i_t_0) <+ transition(SUPPLY*tx_valid[2]*((tx_word[2] >> 0) & 1),TD,EDGE,EDGE);
  V(C2i_f_0) <+ transition(SUPPLY*tx_valid[2]*(1-((tx_word[2] >> 0) & 1)),TD,EDGE,EDGE);
  V(C2i_t_1) <+ transition(SUPPLY*tx_valid[2]*((tx_word[2] >> 1) & 1),TD,EDGE,EDGE);
  V(C2i_f_1) <+ transition(SUPPLY*tx_valid[2]*(1-((tx_word[2] >> 1) & 1)),TD,EDGE,EDGE);
  V(C2i_t_2) <+ transition(SUPPLY*tx_valid[2]*((tx_word[2] >> 2) & 1),TD,EDGE,EDGE);
  V(C2i_f_2) <+ transition(SUPPLY*tx_valid[2]*(1-((tx_word[2] >> 2) & 1)),TD,EDGE,EDGE);
  V(C2i_t_3) <+ transition(SUPPLY*tx_valid[2]*((tx_word[2] >> 3) & 1),TD,EDGE,EDGE);
  V(C2i_f_3) <+ transition(SUPPLY*tx_valid[2]*(1-((tx_word[2] >> 3) & 1)),TD,EDGE,EDGE);
  V(C2i_t_4) <+ transition(SUPPLY*tx_valid[2]*((tx_word[2] >> 4) & 1),TD,EDGE,EDGE);
  V(C2i_f_4) <+ transition(SUPPLY*tx_valid[2]*(1-((tx_word[2] >> 4) & 1)),TD,EDGE,EDGE);
  V(C2i_t_5) <+ transition(SUPPLY*tx_valid[2]*((tx_word[2] >> 5) & 1),TD,EDGE,EDGE);
  V(C2i_f_5) <+ transition(SUPPLY*tx_valid[2]*(1-((tx_word[2] >> 5) & 1)),TD,EDGE,EDGE);
  V(C2i_t_6) <+ transition(SUPPLY*tx_valid[2]*((tx_word[2] >> 6) & 1),TD,EDGE,EDGE);
  V(C2i_f_6) <+ transition(SUPPLY*tx_valid[2]*(1-((tx_word[2] >> 6) & 1)),TD,EDGE,EDGE);
  V(C2i_t_7) <+ transition(SUPPLY*tx_valid[2]*((tx_word[2] >> 7) & 1),TD,EDGE,EDGE);
  V(C2i_f_7) <+ transition(SUPPLY*tx_valid[2]*(1-((tx_word[2] >> 7) & 1)),TD,EDGE,EDGE);
  V(C2i_t_8) <+ transition(SUPPLY*tx_valid[2]*((tx_word[2] >> 8) & 1),TD,EDGE,EDGE);
  V(C2i_f_8) <+ transition(SUPPLY*tx_valid[2]*(1-((tx_word[2] >> 8) & 1)),TD,EDGE,EDGE);
  V(C2i_t_9) <+ transition(SUPPLY*tx_valid[2]*((tx_word[2] >> 9) & 1),TD,EDGE,EDGE);
  V(C2i_f_9) <+ transition(SUPPLY*tx_valid[2]*(1-((tx_word[2] >> 9) & 1)),TD,EDGE,EDGE);
  V(C2i_t_10) <+ transition(SUPPLY*tx_valid[2]*((tx_word[2] >> 10) & 1),TD,EDGE,EDGE);
  V(C2i_f_10) <+ transition(SUPPLY*tx_valid[2]*(1-((tx_word[2] >> 10) & 1)),TD,EDGE,EDGE);
  V(C2i_t_11) <+ transition(SUPPLY*tx_valid[2]*((tx_word[2] >> 11) & 1),TD,EDGE,EDGE);
  V(C2i_f_11) <+ transition(SUPPLY*tx_valid[2]*(1-((tx_word[2] >> 11) & 1)),TD,EDGE,EDGE);
  V(C2i_t_12) <+ transition(SUPPLY*tx_valid[2]*((tx_word[2] >> 12) & 1),TD,EDGE,EDGE);
  V(C2i_f_12) <+ transition(SUPPLY*tx_valid[2]*(1-((tx_word[2] >> 12) & 1)),TD,EDGE,EDGE);
  V(C2i_t_13) <+ transition(SUPPLY*tx_valid[2]*((tx_word[2] >> 13) & 1),TD,EDGE,EDGE);
  V(C2i_f_13) <+ transition(SUPPLY*tx_valid[2]*(1-((tx_word[2] >> 13) & 1)),TD,EDGE,EDGE);
  V(C2i_t_14) <+ transition(SUPPLY*tx_valid[2]*((tx_word[2] >> 14) & 1),TD,EDGE,EDGE);
  V(C2i_f_14) <+ transition(SUPPLY*tx_valid[2]*(1-((tx_word[2] >> 14) & 1)),TD,EDGE,EDGE);
  V(C2i_t_15) <+ transition(SUPPLY*tx_valid[2]*((tx_word[2] >> 15) & 1),TD,EDGE,EDGE);
  V(C2i_f_15) <+ transition(SUPPLY*tx_valid[2]*(1-((tx_word[2] >> 15) & 1)),TD,EDGE,EDGE);
  V(C2i_t_16) <+ transition(SUPPLY*tx_valid[2]*((tx_word[2] >> 16) & 1),TD,EDGE,EDGE);
  V(C2i_f_16) <+ transition(SUPPLY*tx_valid[2]*(1-((tx_word[2] >> 16) & 1)),TD,EDGE,EDGE);
  V(C2i_t_17) <+ transition(SUPPLY*tx_valid[2]*((tx_word[2] >> 17) & 1),TD,EDGE,EDGE);
  V(C2i_f_17) <+ transition(SUPPLY*tx_valid[2]*(1-((tx_word[2] >> 17) & 1)),TD,EDGE,EDGE);
  V(C2i_t_18) <+ transition(SUPPLY*tx_valid[2]*((tx_word[2] >> 18) & 1),TD,EDGE,EDGE);
  V(C2i_f_18) <+ transition(SUPPLY*tx_valid[2]*(1-((tx_word[2] >> 18) & 1)),TD,EDGE,EDGE);
  V(C2i_t_19) <+ transition(SUPPLY*tx_valid[2]*((tx_word[2] >> 19) & 1),TD,EDGE,EDGE);
  V(C2i_f_19) <+ transition(SUPPLY*tx_valid[2]*(1-((tx_word[2] >> 19) & 1)),TD,EDGE,EDGE);
  V(C2i_t_20) <+ transition(SUPPLY*tx_valid[2]*((tx_word[2] >> 20) & 1),TD,EDGE,EDGE);
  V(C2i_f_20) <+ transition(SUPPLY*tx_valid[2]*(1-((tx_word[2] >> 20) & 1)),TD,EDGE,EDGE);
  V(C2i_t_21) <+ transition(SUPPLY*tx_valid[2]*((tx_word[2] >> 21) & 1),TD,EDGE,EDGE);
  V(C2i_f_21) <+ transition(SUPPLY*tx_valid[2]*(1-((tx_word[2] >> 21) & 1)),TD,EDGE,EDGE);
  V(C2i_t_22) <+ transition(SUPPLY*tx_valid[2]*((tx_word[2] >> 22) & 1),TD,EDGE,EDGE);
  V(C2i_f_22) <+ transition(SUPPLY*tx_valid[2]*(1-((tx_word[2] >> 22) & 1)),TD,EDGE,EDGE);
  V(C2i_t_23) <+ transition(SUPPLY*tx_valid[2]*((tx_word[2] >> 23) & 1),TD,EDGE,EDGE);
  V(C2i_f_23) <+ transition(SUPPLY*tx_valid[2]*(1-((tx_word[2] >> 23) & 1)),TD,EDGE,EDGE);
  V(C2i_t_24) <+ transition(SUPPLY*tx_valid[2]*((tx_word[2] >> 24) & 1),TD,EDGE,EDGE);
  V(C2i_f_24) <+ transition(SUPPLY*tx_valid[2]*(1-((tx_word[2] >> 24) & 1)),TD,EDGE,EDGE);
  V(C2i_t_25) <+ transition(SUPPLY*tx_valid[2]*((tx_word[2] >> 25) & 1),TD,EDGE,EDGE);
  V(C2i_f_25) <+ transition(SUPPLY*tx_valid[2]*(1-((tx_word[2] >> 25) & 1)),TD,EDGE,EDGE);
  V(C2i_t_26) <+ transition(SUPPLY*tx_valid[2]*((tx_word[2] >> 26) & 1),TD,EDGE,EDGE);
  V(C2i_f_26) <+ transition(SUPPLY*tx_valid[2]*(1-((tx_word[2] >> 26) & 1)),TD,EDGE,EDGE);
  V(C2i_t_27) <+ transition(SUPPLY*tx_valid[2]*((tx_word[2] >> 27) & 1),TD,EDGE,EDGE);
  V(C2i_f_27) <+ transition(SUPPLY*tx_valid[2]*(1-((tx_word[2] >> 27) & 1)),TD,EDGE,EDGE);
  V(C2i_t_28) <+ transition(SUPPLY*tx_valid[2]*((tx_word[2] >> 28) & 1),TD,EDGE,EDGE);
  V(C2i_f_28) <+ transition(SUPPLY*tx_valid[2]*(1-((tx_word[2] >> 28) & 1)),TD,EDGE,EDGE);
  V(C2i_t_29) <+ transition(SUPPLY*tx_valid[2]*((tx_word[2] >> 29) & 1),TD,EDGE,EDGE);
  V(C2i_f_29) <+ transition(SUPPLY*tx_valid[2]*(1-((tx_word[2] >> 29) & 1)),TD,EDGE,EDGE);
  V(C2i_t_30) <+ transition(SUPPLY*tx_valid[2]*((tx_word[2] >> 30) & 1),TD,EDGE,EDGE);
  V(C2i_f_30) <+ transition(SUPPLY*tx_valid[2]*(1-((tx_word[2] >> 30) & 1)),TD,EDGE,EDGE);
  V(C2i_t_31) <+ transition(SUPPLY*tx_valid[2]*((tx_word[2] >> 31) & 1),TD,EDGE,EDGE);
  V(C2i_f_31) <+ transition(SUPPLY*tx_valid[2]*(1-((tx_word[2] >> 31) & 1)),TD,EDGE,EDGE);
  V(C3i_t_0) <+ transition(SUPPLY*tx_valid[3]*((tx_word[3] >> 0) & 1),TD,EDGE,EDGE);
  V(C3i_f_0) <+ transition(SUPPLY*tx_valid[3]*(1-((tx_word[3] >> 0) & 1)),TD,EDGE,EDGE);
  V(C3i_t_1) <+ transition(SUPPLY*tx_valid[3]*((tx_word[3] >> 1) & 1),TD,EDGE,EDGE);
  V(C3i_f_1) <+ transition(SUPPLY*tx_valid[3]*(1-((tx_word[3] >> 1) & 1)),TD,EDGE,EDGE);
  V(C3i_t_2) <+ transition(SUPPLY*tx_valid[3]*((tx_word[3] >> 2) & 1),TD,EDGE,EDGE);
  V(C3i_f_2) <+ transition(SUPPLY*tx_valid[3]*(1-((tx_word[3] >> 2) & 1)),TD,EDGE,EDGE);
  V(C3i_t_3) <+ transition(SUPPLY*tx_valid[3]*((tx_word[3] >> 3) & 1),TD,EDGE,EDGE);
  V(C3i_f_3) <+ transition(SUPPLY*tx_valid[3]*(1-((tx_word[3] >> 3) & 1)),TD,EDGE,EDGE);
  V(C3i_t_4) <+ transition(SUPPLY*tx_valid[3]*((tx_word[3] >> 4) & 1),TD,EDGE,EDGE);
  V(C3i_f_4) <+ transition(SUPPLY*tx_valid[3]*(1-((tx_word[3] >> 4) & 1)),TD,EDGE,EDGE);
  V(C3i_t_5) <+ transition(SUPPLY*tx_valid[3]*((tx_word[3] >> 5) & 1),TD,EDGE,EDGE);
  V(C3i_f_5) <+ transition(SUPPLY*tx_valid[3]*(1-((tx_word[3] >> 5) & 1)),TD,EDGE,EDGE);
  V(C3i_t_6) <+ transition(SUPPLY*tx_valid[3]*((tx_word[3] >> 6) & 1),TD,EDGE,EDGE);
  V(C3i_f_6) <+ transition(SUPPLY*tx_valid[3]*(1-((tx_word[3] >> 6) & 1)),TD,EDGE,EDGE);
  V(C3i_t_7) <+ transition(SUPPLY*tx_valid[3]*((tx_word[3] >> 7) & 1),TD,EDGE,EDGE);
  V(C3i_f_7) <+ transition(SUPPLY*tx_valid[3]*(1-((tx_word[3] >> 7) & 1)),TD,EDGE,EDGE);
  V(C3i_t_8) <+ transition(SUPPLY*tx_valid[3]*((tx_word[3] >> 8) & 1),TD,EDGE,EDGE);
  V(C3i_f_8) <+ transition(SUPPLY*tx_valid[3]*(1-((tx_word[3] >> 8) & 1)),TD,EDGE,EDGE);
  V(C3i_t_9) <+ transition(SUPPLY*tx_valid[3]*((tx_word[3] >> 9) & 1),TD,EDGE,EDGE);
  V(C3i_f_9) <+ transition(SUPPLY*tx_valid[3]*(1-((tx_word[3] >> 9) & 1)),TD,EDGE,EDGE);
  V(C3i_t_10) <+ transition(SUPPLY*tx_valid[3]*((tx_word[3] >> 10) & 1),TD,EDGE,EDGE);
  V(C3i_f_10) <+ transition(SUPPLY*tx_valid[3]*(1-((tx_word[3] >> 10) & 1)),TD,EDGE,EDGE);
  V(C3i_t_11) <+ transition(SUPPLY*tx_valid[3]*((tx_word[3] >> 11) & 1),TD,EDGE,EDGE);
  V(C3i_f_11) <+ transition(SUPPLY*tx_valid[3]*(1-((tx_word[3] >> 11) & 1)),TD,EDGE,EDGE);
  V(C3i_t_12) <+ transition(SUPPLY*tx_valid[3]*((tx_word[3] >> 12) & 1),TD,EDGE,EDGE);
  V(C3i_f_12) <+ transition(SUPPLY*tx_valid[3]*(1-((tx_word[3] >> 12) & 1)),TD,EDGE,EDGE);
  V(C3i_t_13) <+ transition(SUPPLY*tx_valid[3]*((tx_word[3] >> 13) & 1),TD,EDGE,EDGE);
  V(C3i_f_13) <+ transition(SUPPLY*tx_valid[3]*(1-((tx_word[3] >> 13) & 1)),TD,EDGE,EDGE);
  V(C3i_t_14) <+ transition(SUPPLY*tx_valid[3]*((tx_word[3] >> 14) & 1),TD,EDGE,EDGE);
  V(C3i_f_14) <+ transition(SUPPLY*tx_valid[3]*(1-((tx_word[3] >> 14) & 1)),TD,EDGE,EDGE);
  V(C3i_t_15) <+ transition(SUPPLY*tx_valid[3]*((tx_word[3] >> 15) & 1),TD,EDGE,EDGE);
  V(C3i_f_15) <+ transition(SUPPLY*tx_valid[3]*(1-((tx_word[3] >> 15) & 1)),TD,EDGE,EDGE);
  V(C3i_t_16) <+ transition(SUPPLY*tx_valid[3]*((tx_word[3] >> 16) & 1),TD,EDGE,EDGE);
  V(C3i_f_16) <+ transition(SUPPLY*tx_valid[3]*(1-((tx_word[3] >> 16) & 1)),TD,EDGE,EDGE);
  V(C3i_t_17) <+ transition(SUPPLY*tx_valid[3]*((tx_word[3] >> 17) & 1),TD,EDGE,EDGE);
  V(C3i_f_17) <+ transition(SUPPLY*tx_valid[3]*(1-((tx_word[3] >> 17) & 1)),TD,EDGE,EDGE);
  V(C3i_t_18) <+ transition(SUPPLY*tx_valid[3]*((tx_word[3] >> 18) & 1),TD,EDGE,EDGE);
  V(C3i_f_18) <+ transition(SUPPLY*tx_valid[3]*(1-((tx_word[3] >> 18) & 1)),TD,EDGE,EDGE);
  V(C3i_t_19) <+ transition(SUPPLY*tx_valid[3]*((tx_word[3] >> 19) & 1),TD,EDGE,EDGE);
  V(C3i_f_19) <+ transition(SUPPLY*tx_valid[3]*(1-((tx_word[3] >> 19) & 1)),TD,EDGE,EDGE);
  V(C3i_t_20) <+ transition(SUPPLY*tx_valid[3]*((tx_word[3] >> 20) & 1),TD,EDGE,EDGE);
  V(C3i_f_20) <+ transition(SUPPLY*tx_valid[3]*(1-((tx_word[3] >> 20) & 1)),TD,EDGE,EDGE);
  V(C3i_t_21) <+ transition(SUPPLY*tx_valid[3]*((tx_word[3] >> 21) & 1),TD,EDGE,EDGE);
  V(C3i_f_21) <+ transition(SUPPLY*tx_valid[3]*(1-((tx_word[3] >> 21) & 1)),TD,EDGE,EDGE);
  V(C3i_t_22) <+ transition(SUPPLY*tx_valid[3]*((tx_word[3] >> 22) & 1),TD,EDGE,EDGE);
  V(C3i_f_22) <+ transition(SUPPLY*tx_valid[3]*(1-((tx_word[3] >> 22) & 1)),TD,EDGE,EDGE);
  V(C3i_t_23) <+ transition(SUPPLY*tx_valid[3]*((tx_word[3] >> 23) & 1),TD,EDGE,EDGE);
  V(C3i_f_23) <+ transition(SUPPLY*tx_valid[3]*(1-((tx_word[3] >> 23) & 1)),TD,EDGE,EDGE);
  V(C3i_t_24) <+ transition(SUPPLY*tx_valid[3]*((tx_word[3] >> 24) & 1),TD,EDGE,EDGE);
  V(C3i_f_24) <+ transition(SUPPLY*tx_valid[3]*(1-((tx_word[3] >> 24) & 1)),TD,EDGE,EDGE);
  V(C3i_t_25) <+ transition(SUPPLY*tx_valid[3]*((tx_word[3] >> 25) & 1),TD,EDGE,EDGE);
  V(C3i_f_25) <+ transition(SUPPLY*tx_valid[3]*(1-((tx_word[3] >> 25) & 1)),TD,EDGE,EDGE);
  V(C3i_t_26) <+ transition(SUPPLY*tx_valid[3]*((tx_word[3] >> 26) & 1),TD,EDGE,EDGE);
  V(C3i_f_26) <+ transition(SUPPLY*tx_valid[3]*(1-((tx_word[3] >> 26) & 1)),TD,EDGE,EDGE);
  V(C3i_t_27) <+ transition(SUPPLY*tx_valid[3]*((tx_word[3] >> 27) & 1),TD,EDGE,EDGE);
  V(C3i_f_27) <+ transition(SUPPLY*tx_valid[3]*(1-((tx_word[3] >> 27) & 1)),TD,EDGE,EDGE);
  V(C3i_t_28) <+ transition(SUPPLY*tx_valid[3]*((tx_word[3] >> 28) & 1),TD,EDGE,EDGE);
  V(C3i_f_28) <+ transition(SUPPLY*tx_valid[3]*(1-((tx_word[3] >> 28) & 1)),TD,EDGE,EDGE);
  V(C3i_t_29) <+ transition(SUPPLY*tx_valid[3]*((tx_word[3] >> 29) & 1),TD,EDGE,EDGE);
  V(C3i_f_29) <+ transition(SUPPLY*tx_valid[3]*(1-((tx_word[3] >> 29) & 1)),TD,EDGE,EDGE);
  V(C3i_t_30) <+ transition(SUPPLY*tx_valid[3]*((tx_word[3] >> 30) & 1),TD,EDGE,EDGE);
  V(C3i_f_30) <+ transition(SUPPLY*tx_valid[3]*(1-((tx_word[3] >> 30) & 1)),TD,EDGE,EDGE);
  V(C3i_t_31) <+ transition(SUPPLY*tx_valid[3]*((tx_word[3] >> 31) & 1),TD,EDGE,EDGE);
  V(C3i_f_31) <+ transition(SUPPLY*tx_valid[3]*(1-((tx_word[3] >> 31) & 1)),TD,EDGE,EDGE);
  V(Pi_t_0) <+ transition(SUPPLY*tx_valid[4]*((tx_word[4] >> 0) & 1),TD,EDGE,EDGE);
  V(Pi_f_0) <+ transition(SUPPLY*tx_valid[4]*(1-((tx_word[4] >> 0) & 1)),TD,EDGE,EDGE);
  V(Pi_t_1) <+ transition(SUPPLY*tx_valid[4]*((tx_word[4] >> 1) & 1),TD,EDGE,EDGE);
  V(Pi_f_1) <+ transition(SUPPLY*tx_valid[4]*(1-((tx_word[4] >> 1) & 1)),TD,EDGE,EDGE);
  V(Pi_t_2) <+ transition(SUPPLY*tx_valid[4]*((tx_word[4] >> 2) & 1),TD,EDGE,EDGE);
  V(Pi_f_2) <+ transition(SUPPLY*tx_valid[4]*(1-((tx_word[4] >> 2) & 1)),TD,EDGE,EDGE);
  V(Pi_t_3) <+ transition(SUPPLY*tx_valid[4]*((tx_word[4] >> 3) & 1),TD,EDGE,EDGE);
  V(Pi_f_3) <+ transition(SUPPLY*tx_valid[4]*(1-((tx_word[4] >> 3) & 1)),TD,EDGE,EDGE);
  V(Pi_t_4) <+ transition(SUPPLY*tx_valid[4]*((tx_word[4] >> 4) & 1),TD,EDGE,EDGE);
  V(Pi_f_4) <+ transition(SUPPLY*tx_valid[4]*(1-((tx_word[4] >> 4) & 1)),TD,EDGE,EDGE);
  V(Pi_t_5) <+ transition(SUPPLY*tx_valid[4]*((tx_word[4] >> 5) & 1),TD,EDGE,EDGE);
  V(Pi_f_5) <+ transition(SUPPLY*tx_valid[4]*(1-((tx_word[4] >> 5) & 1)),TD,EDGE,EDGE);
  V(Pi_t_6) <+ transition(SUPPLY*tx_valid[4]*((tx_word[4] >> 6) & 1),TD,EDGE,EDGE);
  V(Pi_f_6) <+ transition(SUPPLY*tx_valid[4]*(1-((tx_word[4] >> 6) & 1)),TD,EDGE,EDGE);
  V(Pi_t_7) <+ transition(SUPPLY*tx_valid[4]*((tx_word[4] >> 7) & 1),TD,EDGE,EDGE);
  V(Pi_f_7) <+ transition(SUPPLY*tx_valid[4]*(1-((tx_word[4] >> 7) & 1)),TD,EDGE,EDGE);
  V(Pi_t_8) <+ transition(SUPPLY*tx_valid[4]*((tx_word[4] >> 8) & 1),TD,EDGE,EDGE);
  V(Pi_f_8) <+ transition(SUPPLY*tx_valid[4]*(1-((tx_word[4] >> 8) & 1)),TD,EDGE,EDGE);
  V(Pi_t_9) <+ transition(SUPPLY*tx_valid[4]*((tx_word[4] >> 9) & 1),TD,EDGE,EDGE);
  V(Pi_f_9) <+ transition(SUPPLY*tx_valid[4]*(1-((tx_word[4] >> 9) & 1)),TD,EDGE,EDGE);
  V(Pi_t_10) <+ transition(SUPPLY*tx_valid[4]*((tx_word[4] >> 10) & 1),TD,EDGE,EDGE);
  V(Pi_f_10) <+ transition(SUPPLY*tx_valid[4]*(1-((tx_word[4] >> 10) & 1)),TD,EDGE,EDGE);
  V(Pi_t_11) <+ transition(SUPPLY*tx_valid[4]*((tx_word[4] >> 11) & 1),TD,EDGE,EDGE);
  V(Pi_f_11) <+ transition(SUPPLY*tx_valid[4]*(1-((tx_word[4] >> 11) & 1)),TD,EDGE,EDGE);
  V(Pi_t_12) <+ transition(SUPPLY*tx_valid[4]*((tx_word[4] >> 12) & 1),TD,EDGE,EDGE);
  V(Pi_f_12) <+ transition(SUPPLY*tx_valid[4]*(1-((tx_word[4] >> 12) & 1)),TD,EDGE,EDGE);
  V(Pi_t_13) <+ transition(SUPPLY*tx_valid[4]*((tx_word[4] >> 13) & 1),TD,EDGE,EDGE);
  V(Pi_f_13) <+ transition(SUPPLY*tx_valid[4]*(1-((tx_word[4] >> 13) & 1)),TD,EDGE,EDGE);
  V(Pi_t_14) <+ transition(SUPPLY*tx_valid[4]*((tx_word[4] >> 14) & 1),TD,EDGE,EDGE);
  V(Pi_f_14) <+ transition(SUPPLY*tx_valid[4]*(1-((tx_word[4] >> 14) & 1)),TD,EDGE,EDGE);
  V(Pi_t_15) <+ transition(SUPPLY*tx_valid[4]*((tx_word[4] >> 15) & 1),TD,EDGE,EDGE);
  V(Pi_f_15) <+ transition(SUPPLY*tx_valid[4]*(1-((tx_word[4] >> 15) & 1)),TD,EDGE,EDGE);
  V(Pi_t_16) <+ transition(SUPPLY*tx_valid[4]*((tx_word[4] >> 16) & 1),TD,EDGE,EDGE);
  V(Pi_f_16) <+ transition(SUPPLY*tx_valid[4]*(1-((tx_word[4] >> 16) & 1)),TD,EDGE,EDGE);
  V(Pi_t_17) <+ transition(SUPPLY*tx_valid[4]*((tx_word[4] >> 17) & 1),TD,EDGE,EDGE);
  V(Pi_f_17) <+ transition(SUPPLY*tx_valid[4]*(1-((tx_word[4] >> 17) & 1)),TD,EDGE,EDGE);
  V(Pi_t_18) <+ transition(SUPPLY*tx_valid[4]*((tx_word[4] >> 18) & 1),TD,EDGE,EDGE);
  V(Pi_f_18) <+ transition(SUPPLY*tx_valid[4]*(1-((tx_word[4] >> 18) & 1)),TD,EDGE,EDGE);
  V(Pi_t_19) <+ transition(SUPPLY*tx_valid[4]*((tx_word[4] >> 19) & 1),TD,EDGE,EDGE);
  V(Pi_f_19) <+ transition(SUPPLY*tx_valid[4]*(1-((tx_word[4] >> 19) & 1)),TD,EDGE,EDGE);
  V(Pi_t_20) <+ transition(SUPPLY*tx_valid[4]*((tx_word[4] >> 20) & 1),TD,EDGE,EDGE);
  V(Pi_f_20) <+ transition(SUPPLY*tx_valid[4]*(1-((tx_word[4] >> 20) & 1)),TD,EDGE,EDGE);
  V(Pi_t_21) <+ transition(SUPPLY*tx_valid[4]*((tx_word[4] >> 21) & 1),TD,EDGE,EDGE);
  V(Pi_f_21) <+ transition(SUPPLY*tx_valid[4]*(1-((tx_word[4] >> 21) & 1)),TD,EDGE,EDGE);
  V(Pi_t_22) <+ transition(SUPPLY*tx_valid[4]*((tx_word[4] >> 22) & 1),TD,EDGE,EDGE);
  V(Pi_f_22) <+ transition(SUPPLY*tx_valid[4]*(1-((tx_word[4] >> 22) & 1)),TD,EDGE,EDGE);
  V(Pi_t_23) <+ transition(SUPPLY*tx_valid[4]*((tx_word[4] >> 23) & 1),TD,EDGE,EDGE);
  V(Pi_f_23) <+ transition(SUPPLY*tx_valid[4]*(1-((tx_word[4] >> 23) & 1)),TD,EDGE,EDGE);
  V(Pi_t_24) <+ transition(SUPPLY*tx_valid[4]*((tx_word[4] >> 24) & 1),TD,EDGE,EDGE);
  V(Pi_f_24) <+ transition(SUPPLY*tx_valid[4]*(1-((tx_word[4] >> 24) & 1)),TD,EDGE,EDGE);
  V(Pi_t_25) <+ transition(SUPPLY*tx_valid[4]*((tx_word[4] >> 25) & 1),TD,EDGE,EDGE);
  V(Pi_f_25) <+ transition(SUPPLY*tx_valid[4]*(1-((tx_word[4] >> 25) & 1)),TD,EDGE,EDGE);
  V(Pi_t_26) <+ transition(SUPPLY*tx_valid[4]*((tx_word[4] >> 26) & 1),TD,EDGE,EDGE);
  V(Pi_f_26) <+ transition(SUPPLY*tx_valid[4]*(1-((tx_word[4] >> 26) & 1)),TD,EDGE,EDGE);
  V(Pi_t_27) <+ transition(SUPPLY*tx_valid[4]*((tx_word[4] >> 27) & 1),TD,EDGE,EDGE);
  V(Pi_f_27) <+ transition(SUPPLY*tx_valid[4]*(1-((tx_word[4] >> 27) & 1)),TD,EDGE,EDGE);
  V(Pi_t_28) <+ transition(SUPPLY*tx_valid[4]*((tx_word[4] >> 28) & 1),TD,EDGE,EDGE);
  V(Pi_f_28) <+ transition(SUPPLY*tx_valid[4]*(1-((tx_word[4] >> 28) & 1)),TD,EDGE,EDGE);
  V(Pi_t_29) <+ transition(SUPPLY*tx_valid[4]*((tx_word[4] >> 29) & 1),TD,EDGE,EDGE);
  V(Pi_f_29) <+ transition(SUPPLY*tx_valid[4]*(1-((tx_word[4] >> 29) & 1)),TD,EDGE,EDGE);
  V(Pi_t_30) <+ transition(SUPPLY*tx_valid[4]*((tx_word[4] >> 30) & 1),TD,EDGE,EDGE);
  V(Pi_f_30) <+ transition(SUPPLY*tx_valid[4]*(1-((tx_word[4] >> 30) & 1)),TD,EDGE,EDGE);
  V(Pi_t_31) <+ transition(SUPPLY*tx_valid[4]*((tx_word[4] >> 31) & 1),TD,EDGE,EDGE);
  V(Pi_f_31) <+ transition(SUPPLY*tx_valid[4]*(1-((tx_word[4] >> 31) & 1)),TD,EDGE,EDGE);
  V(C0o_a) <+ transition(SUPPLY*ack[0],TD,EDGE,EDGE);
  V(C1o_a) <+ transition(SUPPLY*ack[1],TD,EDGE,EDGE);
  V(C2o_a) <+ transition(SUPPLY*ack[2],TD,EDGE,EDGE);
  V(C3o_a) <+ transition(SUPPLY*ack[3],TD,EDGE,EDGE);
  V(Po_a) <+ transition(SUPPLY*ack[4],TD,EDGE,EDGE);
  V(done) <+ transition(SUPPLY*finished,0,EDGE,EDGE);
  V(failed) <+ transition(SUPPLY*failure,0,EDGE,EDGE);
end
endmodule
