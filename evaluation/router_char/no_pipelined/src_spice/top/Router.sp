*
*---- act defproc: UpdownSel<> -----
* raw ports:  reset I.t[0] I.t[1] I.t[2] I.t[3] I.t[4] I.t[5] I.t[6] I.t[7] I.t[8] I.t[9] I.t[10] I.t[11] I.t[12] I.t[13] I.t[14] I.t[15] I.t[16] I.t[17] I.t[18] I.t[19] I.t[20] I.t[21] I.t[22] I.t[23] I.t[24] I.t[25] I.t[26] I.t[27] I.t[28] I.t[29] I.t[30] I.t[31] I.f[0] I.f[1] I.f[2] I.f[3] I.f[4] I.f[5] I.f[6] I.f[7] I.f[8] I.f[9] I.f[10] I.f[11] I.f[12] I.f[13] I.f[14] I.f[15] I.f[16] I.f[17] I.f[18] I.f[19] I.f[20] I.f[21] I.f[22] I.f[23] I.f[24] I.f[25] I.f[26] I.f[27] I.f[28] I.f[29] I.f[30] I.f[31] I.a O0.t[0] O0.t[1] O0.t[2] O0.t[3] O0.t[4] O0.t[5] O0.t[6] O0.t[7] O0.t[8] O0.t[9] O0.t[10] O0.t[11] O0.t[12] O0.t[13] O0.t[14] O0.t[15] O0.t[16] O0.t[17] O0.t[18] O0.t[19] O0.t[20] O0.t[21] O0.t[22] O0.t[23] O0.t[24] O0.t[25] O0.t[26] O0.t[27] O0.t[28] O0.t[29] O0.t[30] O0.t[31] O0.f[0] O0.f[1] O0.f[2] O0.f[3] O0.f[4] O0.f[5] O0.f[6] O0.f[7] O0.f[8] O0.f[9] O0.f[10] O0.f[11] O0.f[12] O0.f[13] O0.f[14] O0.f[15] O0.f[16] O0.f[17] O0.f[18] O0.f[19] O0.f[20] O0.f[21] O0.f[22] O0.f[23] O0.f[24] O0.f[25] O0.f[26] O0.f[27] O0.f[28] O0.f[29] O0.f[30] O0.f[31] O0.a O1.t[0] O1.t[1] O1.t[2] O1.t[3] O1.t[4] O1.t[5] O1.t[6] O1.t[7] O1.t[8] O1.t[9] O1.t[10] O1.t[11] O1.t[12] O1.t[13] O1.t[14] O1.t[15] O1.t[16] O1.t[17] O1.t[18] O1.t[19] O1.t[20] O1.t[21] O1.t[22] O1.t[23] O1.t[24] O1.t[25] O1.t[26] O1.t[27] O1.t[28] O1.t[29] O1.t[30] O1.t[31] O1.f[0] O1.f[1] O1.f[2] O1.f[3] O1.f[4] O1.f[5] O1.f[6] O1.f[7] O1.f[8] O1.f[9] O1.f[10] O1.f[11] O1.f[12] O1.f[13] O1.f[14] O1.f[15] O1.f[16] O1.f[17] O1.f[18] O1.f[19] O1.f[20] O1.f[21] O1.f[22] O1.f[23] O1.f[24] O1.f[25] O1.f[26] O1.f[27] O1.f[28] O1.f[29] O1.f[30] O1.f[31] O1.a
*
.subckt UpdownSel reset I_at_50_6 I_at_51_6 I_at_52_6 I_at_53_6 I_at_54_6 I_at_55_6 I_at_56_6 I_at_57_6 I_at_58_6 I_at_59_6 I_at_510_6 I_at_511_6 I_at_512_6 I_at_513_6 I_at_514_6 I_at_515_6 I_at_516_6 I_at_517_6 I_at_518_6 I_at_519_6 I_at_520_6 I_at_521_6 I_at_522_6 I_at_523_6 I_at_524_6 I_at_525_6 I_at_526_6 I_at_527_6 I_at_528_6 I_at_529_6 I_at_530_6 I_at_531_6 I_af_50_6 I_af_51_6 I_af_52_6 I_af_53_6 I_af_54_6 I_af_55_6 I_af_56_6 I_af_57_6 I_af_58_6 I_af_59_6 I_af_510_6 I_af_511_6 I_af_512_6 I_af_513_6 I_af_514_6 I_af_515_6 I_af_516_6 I_af_517_6 I_af_518_6 I_af_519_6 I_af_520_6 I_af_521_6 I_af_522_6 I_af_523_6 I_af_524_6 I_af_525_6 I_af_526_6 I_af_527_6 I_af_528_6 I_af_529_6 I_af_530_6 I_af_531_6 I_aa O0_at_50_6 O0_at_51_6 O0_at_52_6 O0_at_53_6 O0_at_54_6 O0_at_55_6 O0_at_56_6 O0_at_57_6 O0_at_58_6 O0_at_59_6 O0_at_510_6 O0_at_511_6 O0_at_512_6 O0_at_513_6 O0_at_514_6 O0_at_515_6 O0_at_516_6 O0_at_517_6 O0_at_518_6 O0_at_519_6 O0_at_520_6 O0_at_521_6 O0_at_522_6 O0_at_523_6 O0_at_524_6 O0_at_525_6 O0_at_526_6 O0_at_527_6 O0_at_528_6 O0_at_529_6 O0_at_530_6 O0_at_531_6 O0_af_50_6 O0_af_51_6 O0_af_52_6 O0_af_53_6 O0_af_54_6 O0_af_55_6 O0_af_56_6 O0_af_57_6 O0_af_58_6 O0_af_59_6 O0_af_510_6 O0_af_511_6 O0_af_512_6 O0_af_513_6 O0_af_514_6 O0_af_515_6 O0_af_516_6 O0_af_517_6 O0_af_518_6 O0_af_519_6 O0_af_520_6 O0_af_521_6 O0_af_522_6 O0_af_523_6 O0_af_524_6 O0_af_525_6 O0_af_526_6 O0_af_527_6 O0_af_528_6 O0_af_529_6 O0_af_530_6 O0_af_531_6 O0_aa O1_at_50_6 O1_at_51_6 O1_at_52_6 O1_at_53_6 O1_at_54_6 O1_at_55_6 O1_at_56_6 O1_at_57_6 O1_at_58_6 O1_at_59_6 O1_at_510_6 O1_at_511_6 O1_at_512_6 O1_at_513_6 O1_at_514_6 O1_at_515_6 O1_at_516_6 O1_at_517_6 O1_at_518_6 O1_at_519_6 O1_at_520_6 O1_at_521_6 O1_at_522_6 O1_at_523_6 O1_at_524_6 O1_at_525_6 O1_at_526_6 O1_at_527_6 O1_at_528_6 O1_at_529_6 O1_at_530_6 O1_at_531_6 O1_af_50_6 O1_af_51_6 O1_af_52_6 O1_af_53_6 O1_af_54_6 O1_af_55_6 O1_af_56_6 O1_af_57_6 O1_af_58_6 O1_af_59_6 O1_af_510_6 O1_af_511_6 O1_af_512_6 O1_af_513_6 O1_af_514_6 O1_af_515_6 O1_af_516_6 O1_af_517_6 O1_af_518_6 O1_af_519_6 O1_af_520_6 O1_af_521_6 O1_af_522_6 O1_af_523_6 O1_af_524_6 O1_af_525_6 O1_af_526_6 O1_af_527_6 O1_af_528_6 O1_af_529_6 O1_af_530_6 O1_af_531_6 O1_aa
*.PININFO reset:I I_at_50_6:I I_at_51_6:I I_at_52_6:I I_at_53_6:I I_at_54_6:I I_at_55_6:I I_at_56_6:I I_at_57_6:I I_at_58_6:I I_at_59_6:I I_at_510_6:I I_at_511_6:I I_at_512_6:I I_at_513_6:I I_at_514_6:I I_at_515_6:I I_at_516_6:I I_at_517_6:I I_at_518_6:I I_at_519_6:I I_at_520_6:I I_at_521_6:I I_at_522_6:I I_at_523_6:I I_at_524_6:I I_at_525_6:I I_at_526_6:I I_at_527_6:I I_at_528_6:I I_at_529_6:I I_at_530_6:I I_at_531_6:I I_af_50_6:I I_af_51_6:I I_af_52_6:I I_af_53_6:I I_af_54_6:I I_af_55_6:I I_af_56_6:I I_af_57_6:I I_af_58_6:I I_af_59_6:I I_af_510_6:I I_af_511_6:I I_af_512_6:I I_af_513_6:I I_af_514_6:I I_af_515_6:I I_af_516_6:I I_af_517_6:I I_af_518_6:I I_af_519_6:I I_af_520_6:I I_af_521_6:I I_af_522_6:I I_af_523_6:I I_af_524_6:I I_af_525_6:I I_af_526_6:I I_af_527_6:I I_af_528_6:I I_af_529_6:I I_af_530_6:I I_af_531_6:I I_aa:O O0_at_50_6:O O0_at_51_6:O O0_at_52_6:O O0_at_53_6:O O0_at_54_6:O O0_at_55_6:O O0_at_56_6:O O0_at_57_6:O O0_at_58_6:O O0_at_59_6:O O0_at_510_6:O O0_at_511_6:O O0_at_512_6:O O0_at_513_6:O O0_at_514_6:O O0_at_515_6:O O0_at_516_6:O O0_at_517_6:O O0_at_518_6:O O0_at_519_6:O O0_at_520_6:O O0_at_521_6:O O0_at_522_6:O O0_at_523_6:O O0_at_524_6:O O0_at_525_6:O O0_at_526_6:O O0_at_527_6:O O0_at_528_6:O O0_at_529_6:O O0_at_530_6:O O0_at_531_6:O O0_af_50_6:O O0_af_51_6:O O0_af_52_6:O O0_af_53_6:O O0_af_54_6:O O0_af_55_6:O O0_af_56_6:O O0_af_57_6:O O0_af_58_6:O O0_af_59_6:O O0_af_510_6:O O0_af_511_6:O O0_af_512_6:O O0_af_513_6:O O0_af_514_6:O O0_af_515_6:O O0_af_516_6:O O0_af_517_6:O O0_af_518_6:O O0_af_519_6:O O0_af_520_6:O O0_af_521_6:O O0_af_522_6:O O0_af_523_6:O O0_af_524_6:O O0_af_525_6:O O0_af_526_6:O O0_af_527_6:O O0_af_528_6:O O0_af_529_6:O O0_af_530_6:O O0_af_531_6:O O0_aa:I O1_at_50_6:O O1_at_51_6:O O1_at_52_6:O O1_at_53_6:O O1_at_54_6:O O1_at_55_6:O O1_at_56_6:O O1_at_57_6:O O1_at_58_6:O O1_at_59_6:O O1_at_510_6:O O1_at_511_6:O O1_at_512_6:O O1_at_513_6:O O1_at_514_6:O O1_at_515_6:O O1_at_516_6:O O1_at_517_6:O O1_at_518_6:O O1_at_519_6:O O1_at_520_6:O O1_at_521_6:O O1_at_522_6:O O1_at_523_6:O O1_at_524_6:O O1_at_525_6:O O1_at_526_6:O O1_at_527_6:O O1_at_528_6:O O1_at_529_6:O O1_at_530_6:O O1_at_531_6:O O1_af_50_6:O O1_af_51_6:O O1_af_52_6:O O1_af_53_6:O O1_af_54_6:O O1_af_55_6:O O1_af_56_6:O O1_af_57_6:O O1_af_58_6:O O1_af_59_6:O O1_af_510_6:O O1_af_511_6:O O1_af_512_6:O O1_af_513_6:O O1_af_514_6:O O1_af_515_6:O O1_af_516_6:O O1_af_517_6:O O1_af_518_6:O O1_af_519_6:O O1_af_520_6:O O1_af_521_6:O O1_af_522_6:O O1_af_523_6:O O1_af_524_6:O O1_af_525_6:O O1_af_526_6:O O1_af_527_6:O O1_af_528_6:O O1_af_529_6:O O1_af_530_6:O O1_af_531_6:O O1_aa:I
*.POWER VDD Vdd
*.POWER GND GND
*.POWER NSUB GND
*.POWER PSUB Vdd
*
* --- node flags ---
*
* p (state-holding): pup_reff=0.8; pdn_reff=1.33333
* inv__I__t31 (combinational)
* inv__s (combinational)
* inv__reset (combinational)
* s (state-holding): pup_reff=0.8; pdn_reff=1.33333
* w__0i (state-holding): pup_reff=1.2; pdn_reff=1.33333
* inv__p (combinational)
* inv__I__f31 (combinational)
* a (state-holding): pup_reff=2; pdn_reff=2.66667
* n__I__a (state-holding): pup_reff=2; pdn_reff=2.66667
* inv__w__0i (combinational)
* inv__w__0 (combinational)
* inv__w__1 (state-holding): pup_reff=0.8; pdn_reff=1.33333
* w__0 (state-holding): pup_reff=0.8; pdn_reff=1.33333
* inv__I__f0 (combinational)
* inv__a (combinational)
* w__1 (combinational)
* n__O0__t_514_6 (state-holding): pup_reff=0.8; pdn_reff=2.66667
* n__O0__f_514_6 (state-holding): pup_reff=0.8; pdn_reff=2.66667
* n__O1__t_514_6 (state-holding): pup_reff=0.8; pdn_reff=2.66667
* n__O1__f_514_6 (state-holding): pup_reff=0.8; pdn_reff=2.66667
* n__O0__t_515_6 (state-holding): pup_reff=0.8; pdn_reff=2.66667
* n__O0__f_515_6 (state-holding): pup_reff=0.8; pdn_reff=2.66667
* n__O1__t_515_6 (state-holding): pup_reff=0.8; pdn_reff=2.66667
* n__O1__f_515_6 (state-holding): pup_reff=0.8; pdn_reff=2.66667
* n__O0__t_516_6 (state-holding): pup_reff=0.8; pdn_reff=2.66667
* n__O0__f_516_6 (state-holding): pup_reff=0.8; pdn_reff=2.66667
* n__O1__t_516_6 (state-holding): pup_reff=0.8; pdn_reff=2.66667
* n__O1__f_516_6 (state-holding): pup_reff=0.8; pdn_reff=2.66667
* n__O0__t_517_6 (state-holding): pup_reff=0.8; pdn_reff=2.66667
* n__O0__f_517_6 (state-holding): pup_reff=0.8; pdn_reff=2.66667
* n__O1__t_517_6 (state-holding): pup_reff=0.8; pdn_reff=2.66667
* n__O1__f_517_6 (state-holding): pup_reff=0.8; pdn_reff=2.66667
* n__O0__t_518_6 (state-holding): pup_reff=0.8; pdn_reff=2.66667
* n__O0__f_518_6 (state-holding): pup_reff=0.8; pdn_reff=2.66667
* n__O1__t_518_6 (state-holding): pup_reff=0.8; pdn_reff=2.66667
* n__O1__f_518_6 (state-holding): pup_reff=0.8; pdn_reff=2.66667
* n__O0__t_519_6 (state-holding): pup_reff=0.8; pdn_reff=2.66667
* n__O0__f_519_6 (state-holding): pup_reff=0.8; pdn_reff=2.66667
* n__O1__t_519_6 (state-holding): pup_reff=0.8; pdn_reff=2.66667
* n__O1__f_519_6 (state-holding): pup_reff=0.8; pdn_reff=2.66667
* n__O0__t_520_6 (state-holding): pup_reff=0.8; pdn_reff=2.66667
* n__O0__f_520_6 (state-holding): pup_reff=0.8; pdn_reff=2.66667
* n__O1__t_520_6 (state-holding): pup_reff=0.8; pdn_reff=2.66667
* n__O1__f_520_6 (state-holding): pup_reff=0.8; pdn_reff=2.66667
* n__O0__t_521_6 (state-holding): pup_reff=0.8; pdn_reff=2.66667
* n__O0__f_521_6 (state-holding): pup_reff=0.8; pdn_reff=2.66667
* n__O1__t_521_6 (state-holding): pup_reff=0.8; pdn_reff=2.66667
* n__O1__f_521_6 (state-holding): pup_reff=0.8; pdn_reff=2.66667
* n__O0__t_522_6 (state-holding): pup_reff=0.8; pdn_reff=2.66667
* n__O0__f_522_6 (state-holding): pup_reff=0.8; pdn_reff=2.66667
* n__O1__t_522_6 (state-holding): pup_reff=0.8; pdn_reff=2.66667
* n__O1__f_522_6 (state-holding): pup_reff=0.8; pdn_reff=2.66667
* n__O0__t_523_6 (state-holding): pup_reff=0.8; pdn_reff=2.66667
* n__O0__f_523_6 (state-holding): pup_reff=0.8; pdn_reff=2.66667
* n__O1__t_523_6 (state-holding): pup_reff=0.8; pdn_reff=2.66667
* n__O1__f_523_6 (state-holding): pup_reff=0.8; pdn_reff=2.66667
* n__O0__t_524_6 (state-holding): pup_reff=0.8; pdn_reff=2.66667
* n__O0__f_524_6 (state-holding): pup_reff=0.8; pdn_reff=2.66667
* n__O1__t_524_6 (state-holding): pup_reff=0.8; pdn_reff=2.66667
* n__O1__f_524_6 (state-holding): pup_reff=0.8; pdn_reff=2.66667
* n__O0__t_525_6 (state-holding): pup_reff=0.8; pdn_reff=2.66667
* n__O0__f_525_6 (state-holding): pup_reff=0.8; pdn_reff=2.66667
* n__O1__t_525_6 (state-holding): pup_reff=0.8; pdn_reff=2.66667
* n__O1__f_525_6 (state-holding): pup_reff=0.8; pdn_reff=2.66667
* n__O0__t_526_6 (state-holding): pup_reff=0.8; pdn_reff=2.66667
* n__O0__f_526_6 (state-holding): pup_reff=0.8; pdn_reff=2.66667
* n__O1__t_526_6 (state-holding): pup_reff=0.8; pdn_reff=2.66667
* n__O1__f_526_6 (state-holding): pup_reff=0.8; pdn_reff=2.66667
* n__O0__t_527_6 (state-holding): pup_reff=0.8; pdn_reff=2.66667
* n__O0__f_527_6 (state-holding): pup_reff=0.8; pdn_reff=2.66667
* n__O1__t_527_6 (state-holding): pup_reff=0.8; pdn_reff=2.66667
* n__O1__f_527_6 (state-holding): pup_reff=0.8; pdn_reff=2.66667
* n__O0__t_528_6 (state-holding): pup_reff=0.8; pdn_reff=2.66667
* n__O0__f_528_6 (state-holding): pup_reff=0.8; pdn_reff=2.66667
* n__O1__t_528_6 (state-holding): pup_reff=0.8; pdn_reff=2.66667
* n__O1__f_528_6 (state-holding): pup_reff=0.8; pdn_reff=2.66667
* n__O0__t_529_6 (state-holding): pup_reff=0.8; pdn_reff=2.66667
* n__O0__f_529_6 (state-holding): pup_reff=0.8; pdn_reff=2.66667
* n__O1__t_529_6 (state-holding): pup_reff=0.8; pdn_reff=2.66667
* n__O1__f_529_6 (state-holding): pup_reff=0.8; pdn_reff=2.66667
* n__O0__t_530_6 (state-holding): pup_reff=0.8; pdn_reff=2.66667
* n__O0__f_530_6 (state-holding): pup_reff=0.8; pdn_reff=2.66667
* n__O1__t_530_6 (state-holding): pup_reff=0.8; pdn_reff=2.66667
* n__O1__f_530_6 (state-holding): pup_reff=0.8; pdn_reff=2.66667
* n__O0__t_531_6 (state-holding): pup_reff=0.8; pdn_reff=2.66667
* n__O0__f_531_6 (state-holding): pup_reff=0.8; pdn_reff=2.66667
* n__O1__t_531_6 (state-holding): pup_reff=0.8; pdn_reff=2.66667
* n__O1__f_531_6 (state-holding): pup_reff=0.8; pdn_reff=2.66667
* n__O0__t_513_6 (state-holding): pup_reff=0.8; pdn_reff=2
* n__O0__f_513_6 (state-holding): pup_reff=0.8; pdn_reff=2.66667
* n__O1__t_513_6 (state-holding): pup_reff=0.8; pdn_reff=2
* n__O1__f_513_6 (state-holding): pup_reff=0.8; pdn_reff=2.66667
* n__O0__t_50_6 (state-holding): pup_reff=0.4; pdn_reff=2.66667
* n__O0__f_50_6 (state-holding): pup_reff=0.4; pdn_reff=2.66667
* n__O1__t_50_6 (state-holding): pup_reff=0.4; pdn_reff=2.66667
* n__O1__f_50_6 (state-holding): pup_reff=0.4; pdn_reff=2.66667
* n__O0__t_51_6 (state-holding): pup_reff=0.4; pdn_reff=2.66667
* n__O0__f_51_6 (state-holding): pup_reff=0.4; pdn_reff=2.66667
* n__O1__t_51_6 (state-holding): pup_reff=0.4; pdn_reff=2.66667
* n__O1__f_51_6 (state-holding): pup_reff=0.4; pdn_reff=2.66667
* n__O0__t_52_6 (state-holding): pup_reff=0.4; pdn_reff=2.66667
* n__O0__f_52_6 (state-holding): pup_reff=0.4; pdn_reff=2.66667
* n__O1__t_52_6 (state-holding): pup_reff=0.4; pdn_reff=2.66667
* n__O1__f_52_6 (state-holding): pup_reff=0.4; pdn_reff=2.66667
* n__O0__t_53_6 (state-holding): pup_reff=0.4; pdn_reff=2.66667
* n__O0__f_53_6 (state-holding): pup_reff=0.4; pdn_reff=2.66667
* n__O1__t_53_6 (state-holding): pup_reff=0.4; pdn_reff=2.66667
* n__O1__f_53_6 (state-holding): pup_reff=0.4; pdn_reff=2.66667
* n__O0__t_54_6 (state-holding): pup_reff=0.4; pdn_reff=2.66667
* n__O0__f_54_6 (state-holding): pup_reff=0.4; pdn_reff=2.66667
* n__O1__t_54_6 (state-holding): pup_reff=0.4; pdn_reff=2.66667
* n__O1__f_54_6 (state-holding): pup_reff=0.4; pdn_reff=2.66667
* n__O0__t_55_6 (state-holding): pup_reff=0.4; pdn_reff=2.66667
* n__O0__f_55_6 (state-holding): pup_reff=0.4; pdn_reff=2.66667
* n__O1__t_55_6 (state-holding): pup_reff=0.4; pdn_reff=2.66667
* n__O1__f_55_6 (state-holding): pup_reff=0.4; pdn_reff=2.66667
* n__O0__t_56_6 (state-holding): pup_reff=0.4; pdn_reff=2.66667
* n__O0__f_56_6 (state-holding): pup_reff=0.4; pdn_reff=2.66667
* n__O1__t_56_6 (state-holding): pup_reff=0.4; pdn_reff=2.66667
* n__O1__f_56_6 (state-holding): pup_reff=0.4; pdn_reff=2.66667
* n__O0__t_57_6 (state-holding): pup_reff=0.4; pdn_reff=2.66667
* n__O0__f_57_6 (state-holding): pup_reff=0.4; pdn_reff=2.66667
* n__O1__t_57_6 (state-holding): pup_reff=0.4; pdn_reff=2.66667
* n__O1__f_57_6 (state-holding): pup_reff=0.4; pdn_reff=2.66667
* n__O0__t_58_6 (state-holding): pup_reff=0.4; pdn_reff=2.66667
* n__O0__f_58_6 (state-holding): pup_reff=0.4; pdn_reff=2.66667
* n__O1__t_58_6 (state-holding): pup_reff=0.4; pdn_reff=2.66667
* n__O1__f_58_6 (state-holding): pup_reff=0.4; pdn_reff=2.66667
* n__O0__t_59_6 (state-holding): pup_reff=0.4; pdn_reff=2.66667
* n__O0__f_59_6 (state-holding): pup_reff=0.4; pdn_reff=2.66667
* n__O1__t_59_6 (state-holding): pup_reff=0.4; pdn_reff=2.66667
* n__O1__f_59_6 (state-holding): pup_reff=0.4; pdn_reff=2.66667
* n__O0__t_510_6 (state-holding): pup_reff=0.4; pdn_reff=2.66667
* n__O0__f_510_6 (state-holding): pup_reff=0.4; pdn_reff=2.66667
* n__O1__t_510_6 (state-holding): pup_reff=0.4; pdn_reff=2.66667
* n__O1__f_510_6 (state-holding): pup_reff=0.4; pdn_reff=2.66667
* n__O0__t_511_6 (state-holding): pup_reff=0.4; pdn_reff=2.66667
* n__O0__f_511_6 (state-holding): pup_reff=0.4; pdn_reff=2.66667
* n__O1__t_511_6 (state-holding): pup_reff=0.4; pdn_reff=2.66667
* n__O1__f_511_6 (state-holding): pup_reff=0.4; pdn_reff=2.66667
* n__O0__t_512_6 (state-holding): pup_reff=0.4; pdn_reff=2.66667
* n__O0__f_512_6 (state-holding): pup_reff=0.4; pdn_reff=2.66667
* n__O1__t_512_6 (state-holding): pup_reff=0.4; pdn_reff=2.66667
* n__O1__f_512_6 (state-holding): pup_reff=0.4; pdn_reff=2.66667
* I_aa (combinational)
* O0_at_50_6 (combinational)
* O0_af_50_6 (combinational)
* O1_at_50_6 (combinational)
* O1_af_50_6 (combinational)
* O0_at_51_6 (combinational)
* O0_af_51_6 (combinational)
* O1_at_51_6 (combinational)
* O1_af_51_6 (combinational)
* O0_at_52_6 (combinational)
* O0_af_52_6 (combinational)
* O1_at_52_6 (combinational)
* O1_af_52_6 (combinational)
* O0_at_53_6 (combinational)
* O0_af_53_6 (combinational)
* O1_at_53_6 (combinational)
* O1_af_53_6 (combinational)
* O0_at_54_6 (combinational)
* O0_af_54_6 (combinational)
* O1_at_54_6 (combinational)
* O1_af_54_6 (combinational)
* O0_at_55_6 (combinational)
* O0_af_55_6 (combinational)
* O1_at_55_6 (combinational)
* O1_af_55_6 (combinational)
* O0_at_56_6 (combinational)
* O0_af_56_6 (combinational)
* O1_at_56_6 (combinational)
* O1_af_56_6 (combinational)
* O0_at_57_6 (combinational)
* O0_af_57_6 (combinational)
* O1_at_57_6 (combinational)
* O1_af_57_6 (combinational)
* O0_at_58_6 (combinational)
* O0_af_58_6 (combinational)
* O1_at_58_6 (combinational)
* O1_af_58_6 (combinational)
* O0_at_59_6 (combinational)
* O0_af_59_6 (combinational)
* O1_at_59_6 (combinational)
* O1_af_59_6 (combinational)
* O0_at_510_6 (combinational)
* O0_af_510_6 (combinational)
* O1_at_510_6 (combinational)
* O1_af_510_6 (combinational)
* O0_at_511_6 (combinational)
* O0_af_511_6 (combinational)
* O1_at_511_6 (combinational)
* O1_af_511_6 (combinational)
* O0_at_512_6 (combinational)
* O0_af_512_6 (combinational)
* O1_at_512_6 (combinational)
* O1_af_512_6 (combinational)
* O0_at_513_6 (combinational)
* O0_af_513_6 (combinational)
* O1_at_513_6 (combinational)
* O1_af_513_6 (combinational)
* O0_at_514_6 (combinational)
* O0_af_514_6 (combinational)
* O1_at_514_6 (combinational)
* O1_af_514_6 (combinational)
* O0_at_515_6 (combinational)
* O0_af_515_6 (combinational)
* O1_at_515_6 (combinational)
* O1_af_515_6 (combinational)
* O0_at_516_6 (combinational)
* O0_af_516_6 (combinational)
* O1_at_516_6 (combinational)
* O1_af_516_6 (combinational)
* O0_at_517_6 (combinational)
* O0_af_517_6 (combinational)
* O1_at_517_6 (combinational)
* O1_af_517_6 (combinational)
* O0_at_518_6 (combinational)
* O0_af_518_6 (combinational)
* O1_at_518_6 (combinational)
* O1_af_518_6 (combinational)
* O0_at_519_6 (combinational)
* O0_af_519_6 (combinational)
* O1_at_519_6 (combinational)
* O1_af_519_6 (combinational)
* O0_at_520_6 (combinational)
* O0_af_520_6 (combinational)
* O1_at_520_6 (combinational)
* O1_af_520_6 (combinational)
* O0_at_521_6 (combinational)
* O0_af_521_6 (combinational)
* O1_at_521_6 (combinational)
* O1_af_521_6 (combinational)
* O0_at_522_6 (combinational)
* O0_af_522_6 (combinational)
* O1_at_522_6 (combinational)
* O1_af_522_6 (combinational)
* O0_at_523_6 (combinational)
* O0_af_523_6 (combinational)
* O1_at_523_6 (combinational)
* O1_af_523_6 (combinational)
* O0_at_524_6 (combinational)
* O0_af_524_6 (combinational)
* O1_at_524_6 (combinational)
* O1_af_524_6 (combinational)
* O0_at_525_6 (combinational)
* O0_af_525_6 (combinational)
* O1_at_525_6 (combinational)
* O1_af_525_6 (combinational)
* O0_at_526_6 (combinational)
* O0_af_526_6 (combinational)
* O1_at_526_6 (combinational)
* O1_af_526_6 (combinational)
* O0_at_527_6 (combinational)
* O0_af_527_6 (combinational)
* O1_at_527_6 (combinational)
* O1_af_527_6 (combinational)
* O0_at_528_6 (combinational)
* O0_af_528_6 (combinational)
* O1_at_528_6 (combinational)
* O1_af_528_6 (combinational)
* O0_at_529_6 (combinational)
* O0_af_529_6 (combinational)
* O1_at_529_6 (combinational)
* O1_af_529_6 (combinational)
* O0_at_530_6 (combinational)
* O0_af_530_6 (combinational)
* O1_at_530_6 (combinational)
* O1_af_530_6 (combinational)
* O0_at_531_6 (combinational)
* O0_af_531_6 (combinational)
* O1_at_531_6 (combinational)
* O1_af_531_6 (combinational)
*
* --- end node flags ---
*
M0_ Vdd inv__I__t31 #3 Vdd pmos W=0.1625U L=0.065U
M1_ Vdd inv__reset p Vdd pmos W=0.1625U L=0.065U
M2_ Vdd inv__s #11 Vdd pmos W=0.1625U L=0.065U
M3_ Vdd n__I__a #22 Vdd pmos W=0.1625U L=0.065U
M4_ Vdd s #34 Vdd pmos W=0.1625U L=0.065U
M5_ Vdd inv__s #39 Vdd pmos W=0.1625U L=0.065U
M6_ Vdd inv__reset inv__w__1 Vdd pmos W=0.1625U L=0.065U
M7_ Vdd inv__w__1 #41 Vdd pmos W=0.1625U L=0.065U
M8_ Vdd inv__reset s Vdd pmos W=0.1625U L=0.065U
M9_ Vdd a #48 Vdd pmos W=0.1625U L=0.065U
M10_ Vdd inv__reset n__I__a Vdd pmos W=0.1625U L=0.065U
M11_ Vdd I_at_514_6 #58 Vdd pmos W=0.1625U L=0.065U
M12_ Vdd I_at_513_6 #59 Vdd pmos W=0.1625U L=0.065U
M13_ Vdd I_af_514_6 #67 Vdd pmos W=0.1625U L=0.065U
M14_ Vdd I_af_513_6 #68 Vdd pmos W=0.1625U L=0.065U
M15_ Vdd I_at_514_6 #74 Vdd pmos W=0.1625U L=0.065U
M16_ Vdd I_at_513_6 #75 Vdd pmos W=0.1625U L=0.065U
M17_ Vdd I_af_514_6 #81 Vdd pmos W=0.1625U L=0.065U
M18_ Vdd I_af_513_6 #82 Vdd pmos W=0.1625U L=0.065U
M19_ Vdd I_at_515_6 #89 Vdd pmos W=0.1625U L=0.065U
M20_ Vdd I_at_514_6 #90 Vdd pmos W=0.1625U L=0.065U
M21_ Vdd I_af_515_6 #97 Vdd pmos W=0.1625U L=0.065U
M22_ Vdd I_af_514_6 #98 Vdd pmos W=0.1625U L=0.065U
M23_ Vdd I_at_515_6 #104 Vdd pmos W=0.1625U L=0.065U
M24_ Vdd I_at_514_6 #105 Vdd pmos W=0.1625U L=0.065U
M25_ Vdd I_af_515_6 #111 Vdd pmos W=0.1625U L=0.065U
M26_ Vdd I_af_514_6 #112 Vdd pmos W=0.1625U L=0.065U
M27_ Vdd I_at_516_6 #119 Vdd pmos W=0.1625U L=0.065U
M28_ Vdd I_at_515_6 #120 Vdd pmos W=0.1625U L=0.065U
M29_ Vdd I_af_516_6 #127 Vdd pmos W=0.1625U L=0.065U
M30_ Vdd I_af_515_6 #128 Vdd pmos W=0.1625U L=0.065U
M31_ Vdd I_at_516_6 #134 Vdd pmos W=0.1625U L=0.065U
M32_ Vdd I_at_515_6 #135 Vdd pmos W=0.1625U L=0.065U
M33_ Vdd I_af_516_6 #141 Vdd pmos W=0.1625U L=0.065U
M34_ Vdd I_af_515_6 #142 Vdd pmos W=0.1625U L=0.065U
M35_ Vdd I_at_517_6 #149 Vdd pmos W=0.1625U L=0.065U
M36_ Vdd I_at_516_6 #150 Vdd pmos W=0.1625U L=0.065U
M37_ Vdd I_af_517_6 #157 Vdd pmos W=0.1625U L=0.065U
M38_ Vdd I_af_516_6 #158 Vdd pmos W=0.1625U L=0.065U
M39_ Vdd I_at_517_6 #164 Vdd pmos W=0.1625U L=0.065U
M40_ Vdd I_at_516_6 #165 Vdd pmos W=0.1625U L=0.065U
M41_ Vdd I_af_517_6 #171 Vdd pmos W=0.1625U L=0.065U
M42_ Vdd I_af_516_6 #172 Vdd pmos W=0.1625U L=0.065U
M43_ Vdd I_at_518_6 #179 Vdd pmos W=0.1625U L=0.065U
M44_ Vdd I_at_517_6 #180 Vdd pmos W=0.1625U L=0.065U
M45_ Vdd I_af_518_6 #187 Vdd pmos W=0.1625U L=0.065U
M46_ Vdd I_af_517_6 #188 Vdd pmos W=0.1625U L=0.065U
M47_ Vdd I_at_518_6 #194 Vdd pmos W=0.1625U L=0.065U
M48_ Vdd I_at_517_6 #195 Vdd pmos W=0.1625U L=0.065U
M49_ Vdd I_af_518_6 #201 Vdd pmos W=0.1625U L=0.065U
M50_ Vdd I_af_517_6 #202 Vdd pmos W=0.1625U L=0.065U
M51_ Vdd I_at_519_6 #209 Vdd pmos W=0.1625U L=0.065U
M52_ Vdd I_at_518_6 #210 Vdd pmos W=0.1625U L=0.065U
M53_ Vdd I_af_519_6 #217 Vdd pmos W=0.1625U L=0.065U
M54_ Vdd I_af_518_6 #218 Vdd pmos W=0.1625U L=0.065U
M55_ Vdd I_at_519_6 #224 Vdd pmos W=0.1625U L=0.065U
M56_ Vdd I_at_518_6 #225 Vdd pmos W=0.1625U L=0.065U
M57_ Vdd I_af_519_6 #231 Vdd pmos W=0.1625U L=0.065U
M58_ Vdd I_af_518_6 #232 Vdd pmos W=0.1625U L=0.065U
M59_ Vdd I_at_520_6 #239 Vdd pmos W=0.1625U L=0.065U
M60_ Vdd I_at_519_6 #240 Vdd pmos W=0.1625U L=0.065U
M61_ Vdd I_af_520_6 #247 Vdd pmos W=0.1625U L=0.065U
M62_ Vdd I_af_519_6 #248 Vdd pmos W=0.1625U L=0.065U
M63_ Vdd I_at_520_6 #254 Vdd pmos W=0.1625U L=0.065U
M64_ Vdd I_at_519_6 #255 Vdd pmos W=0.1625U L=0.065U
M65_ Vdd I_af_520_6 #261 Vdd pmos W=0.1625U L=0.065U
M66_ Vdd I_af_519_6 #262 Vdd pmos W=0.1625U L=0.065U
M67_ Vdd I_at_521_6 #269 Vdd pmos W=0.1625U L=0.065U
M68_ Vdd I_at_520_6 #270 Vdd pmos W=0.1625U L=0.065U
M69_ Vdd I_af_521_6 #277 Vdd pmos W=0.1625U L=0.065U
M70_ Vdd I_af_520_6 #278 Vdd pmos W=0.1625U L=0.065U
M71_ Vdd I_at_521_6 #284 Vdd pmos W=0.1625U L=0.065U
M72_ Vdd I_at_520_6 #285 Vdd pmos W=0.1625U L=0.065U
M73_ Vdd I_af_521_6 #291 Vdd pmos W=0.1625U L=0.065U
M74_ Vdd I_af_520_6 #292 Vdd pmos W=0.1625U L=0.065U
M75_ Vdd I_at_522_6 #299 Vdd pmos W=0.1625U L=0.065U
M76_ Vdd I_at_521_6 #300 Vdd pmos W=0.1625U L=0.065U
M77_ Vdd I_af_522_6 #307 Vdd pmos W=0.1625U L=0.065U
M78_ Vdd I_af_521_6 #308 Vdd pmos W=0.1625U L=0.065U
M79_ Vdd I_at_522_6 #314 Vdd pmos W=0.1625U L=0.065U
M80_ Vdd I_at_521_6 #315 Vdd pmos W=0.1625U L=0.065U
M81_ Vdd I_af_522_6 #321 Vdd pmos W=0.1625U L=0.065U
M82_ Vdd I_af_521_6 #322 Vdd pmos W=0.1625U L=0.065U
M83_ Vdd I_at_523_6 #329 Vdd pmos W=0.1625U L=0.065U
M84_ Vdd I_at_522_6 #330 Vdd pmos W=0.1625U L=0.065U
M85_ Vdd I_af_523_6 #337 Vdd pmos W=0.1625U L=0.065U
M86_ Vdd I_af_522_6 #338 Vdd pmos W=0.1625U L=0.065U
M87_ Vdd I_at_523_6 #344 Vdd pmos W=0.1625U L=0.065U
M88_ Vdd I_at_522_6 #345 Vdd pmos W=0.1625U L=0.065U
M89_ Vdd I_af_523_6 #351 Vdd pmos W=0.1625U L=0.065U
M90_ Vdd I_af_522_6 #352 Vdd pmos W=0.1625U L=0.065U
M91_ Vdd I_at_524_6 #359 Vdd pmos W=0.1625U L=0.065U
M92_ Vdd I_at_523_6 #360 Vdd pmos W=0.1625U L=0.065U
M93_ Vdd I_af_524_6 #367 Vdd pmos W=0.1625U L=0.065U
M94_ Vdd I_af_523_6 #368 Vdd pmos W=0.1625U L=0.065U
M95_ Vdd I_at_524_6 #374 Vdd pmos W=0.1625U L=0.065U
M96_ Vdd I_at_523_6 #375 Vdd pmos W=0.1625U L=0.065U
M97_ Vdd I_af_524_6 #381 Vdd pmos W=0.1625U L=0.065U
M98_ Vdd I_af_523_6 #382 Vdd pmos W=0.1625U L=0.065U
M99_ Vdd I_at_525_6 #389 Vdd pmos W=0.1625U L=0.065U
M100_ Vdd I_at_524_6 #390 Vdd pmos W=0.1625U L=0.065U
M101_ Vdd I_af_525_6 #397 Vdd pmos W=0.1625U L=0.065U
M102_ Vdd I_af_524_6 #398 Vdd pmos W=0.1625U L=0.065U
M103_ Vdd I_at_525_6 #404 Vdd pmos W=0.1625U L=0.065U
M104_ Vdd I_at_524_6 #405 Vdd pmos W=0.1625U L=0.065U
M105_ Vdd I_af_525_6 #411 Vdd pmos W=0.1625U L=0.065U
M106_ Vdd I_af_524_6 #412 Vdd pmos W=0.1625U L=0.065U
M107_ Vdd I_at_526_6 #419 Vdd pmos W=0.1625U L=0.065U
M108_ Vdd I_at_525_6 #420 Vdd pmos W=0.1625U L=0.065U
M109_ Vdd I_af_526_6 #427 Vdd pmos W=0.1625U L=0.065U
M110_ Vdd I_af_525_6 #428 Vdd pmos W=0.1625U L=0.065U
M111_ Vdd I_at_526_6 #434 Vdd pmos W=0.1625U L=0.065U
M112_ Vdd I_at_525_6 #435 Vdd pmos W=0.1625U L=0.065U
M113_ Vdd I_af_526_6 #441 Vdd pmos W=0.1625U L=0.065U
M114_ Vdd I_af_525_6 #442 Vdd pmos W=0.1625U L=0.065U
M115_ Vdd I_at_527_6 #449 Vdd pmos W=0.1625U L=0.065U
M116_ Vdd I_at_526_6 #450 Vdd pmos W=0.1625U L=0.065U
M117_ Vdd I_af_527_6 #457 Vdd pmos W=0.1625U L=0.065U
M118_ Vdd I_af_526_6 #458 Vdd pmos W=0.1625U L=0.065U
M119_ Vdd I_at_527_6 #464 Vdd pmos W=0.1625U L=0.065U
M120_ Vdd I_at_526_6 #465 Vdd pmos W=0.1625U L=0.065U
M121_ Vdd I_af_527_6 #471 Vdd pmos W=0.1625U L=0.065U
M122_ Vdd I_af_526_6 #472 Vdd pmos W=0.1625U L=0.065U
M123_ Vdd I_at_528_6 #479 Vdd pmos W=0.1625U L=0.065U
M124_ Vdd I_at_527_6 #480 Vdd pmos W=0.1625U L=0.065U
M125_ Vdd I_af_528_6 #487 Vdd pmos W=0.1625U L=0.065U
M126_ Vdd I_af_527_6 #488 Vdd pmos W=0.1625U L=0.065U
M127_ Vdd I_at_528_6 #494 Vdd pmos W=0.1625U L=0.065U
M128_ Vdd I_at_527_6 #495 Vdd pmos W=0.1625U L=0.065U
M129_ Vdd I_af_528_6 #501 Vdd pmos W=0.1625U L=0.065U
M130_ Vdd I_af_527_6 #502 Vdd pmos W=0.1625U L=0.065U
M131_ Vdd I_at_529_6 #509 Vdd pmos W=0.1625U L=0.065U
M132_ Vdd I_at_528_6 #510 Vdd pmos W=0.1625U L=0.065U
M133_ Vdd I_af_529_6 #517 Vdd pmos W=0.1625U L=0.065U
M134_ Vdd I_af_528_6 #518 Vdd pmos W=0.1625U L=0.065U
M135_ Vdd I_at_529_6 #524 Vdd pmos W=0.1625U L=0.065U
M136_ Vdd I_at_528_6 #525 Vdd pmos W=0.1625U L=0.065U
M137_ Vdd I_af_529_6 #531 Vdd pmos W=0.1625U L=0.065U
M138_ Vdd I_af_528_6 #532 Vdd pmos W=0.1625U L=0.065U
M139_ Vdd I_at_530_6 #539 Vdd pmos W=0.1625U L=0.065U
M140_ Vdd I_at_529_6 #540 Vdd pmos W=0.1625U L=0.065U
M141_ Vdd I_af_530_6 #547 Vdd pmos W=0.1625U L=0.065U
M142_ Vdd I_af_529_6 #548 Vdd pmos W=0.1625U L=0.065U
M143_ Vdd I_at_530_6 #554 Vdd pmos W=0.1625U L=0.065U
M144_ Vdd I_at_529_6 #555 Vdd pmos W=0.1625U L=0.065U
M145_ Vdd I_af_530_6 #561 Vdd pmos W=0.1625U L=0.065U
M146_ Vdd I_af_529_6 #562 Vdd pmos W=0.1625U L=0.065U
M147_ Vdd I_at_531_6 #569 Vdd pmos W=0.1625U L=0.065U
M148_ Vdd I_at_530_6 #570 Vdd pmos W=0.1625U L=0.065U
M149_ Vdd I_af_531_6 #576 Vdd pmos W=0.1625U L=0.065U
M150_ Vdd I_af_530_6 #577 Vdd pmos W=0.1625U L=0.065U
M151_ Vdd I_at_531_6 #583 Vdd pmos W=0.1625U L=0.065U
M152_ Vdd I_at_530_6 #584 Vdd pmos W=0.1625U L=0.065U
M153_ Vdd I_af_531_6 #590 Vdd pmos W=0.1625U L=0.065U
M154_ Vdd I_af_530_6 #591 Vdd pmos W=0.1625U L=0.065U
M155_ Vdd I_at_513_6 #595 Vdd pmos W=0.1625U L=0.065U
M156_ Vdd inv__reset n__O0__t_513_6 Vdd pmos W=0.1625U L=0.065U
M157_ Vdd I_af_513_6 #601 Vdd pmos W=0.1625U L=0.065U
M158_ Vdd n__I__a #602 Vdd pmos W=0.1625U L=0.065U
M159_ Vdd inv__reset n__O0__f_513_6 Vdd pmos W=0.1625U L=0.065U
M160_ Vdd I_at_513_6 #606 Vdd pmos W=0.1625U L=0.065U
M161_ Vdd inv__reset n__O1__t_513_6 Vdd pmos W=0.1625U L=0.065U
M162_ Vdd I_af_513_6 #612 Vdd pmos W=0.1625U L=0.065U
M163_ Vdd n__I__a #613 Vdd pmos W=0.1625U L=0.065U
M164_ Vdd inv__reset n__O1__f_513_6 Vdd pmos W=0.1625U L=0.065U
M165_ Vdd I_at_50_6 n__O0__t_50_6 Vdd pmos W=0.1625U L=0.065U
M166_ Vdd I_af_50_6 n__O0__f_50_6 Vdd pmos W=0.1625U L=0.065U
M167_ Vdd I_at_50_6 n__O1__t_50_6 Vdd pmos W=0.1625U L=0.065U
M168_ Vdd I_af_50_6 n__O1__f_50_6 Vdd pmos W=0.1625U L=0.065U
M169_ Vdd I_at_51_6 n__O0__t_51_6 Vdd pmos W=0.1625U L=0.065U
M170_ Vdd I_af_51_6 n__O0__f_51_6 Vdd pmos W=0.1625U L=0.065U
M171_ Vdd I_at_51_6 n__O1__t_51_6 Vdd pmos W=0.1625U L=0.065U
M172_ Vdd I_af_51_6 n__O1__f_51_6 Vdd pmos W=0.1625U L=0.065U
M173_ Vdd I_at_52_6 n__O0__t_52_6 Vdd pmos W=0.1625U L=0.065U
M174_ Vdd I_af_52_6 n__O0__f_52_6 Vdd pmos W=0.1625U L=0.065U
M175_ Vdd I_at_52_6 n__O1__t_52_6 Vdd pmos W=0.1625U L=0.065U
M176_ Vdd I_af_52_6 n__O1__f_52_6 Vdd pmos W=0.1625U L=0.065U
M177_ Vdd I_at_53_6 n__O0__t_53_6 Vdd pmos W=0.1625U L=0.065U
M178_ Vdd I_af_53_6 n__O0__f_53_6 Vdd pmos W=0.1625U L=0.065U
M179_ Vdd I_at_53_6 n__O1__t_53_6 Vdd pmos W=0.1625U L=0.065U
M180_ Vdd I_af_53_6 n__O1__f_53_6 Vdd pmos W=0.1625U L=0.065U
M181_ Vdd I_at_54_6 n__O0__t_54_6 Vdd pmos W=0.1625U L=0.065U
M182_ Vdd I_af_54_6 n__O0__f_54_6 Vdd pmos W=0.1625U L=0.065U
M183_ Vdd I_at_54_6 n__O1__t_54_6 Vdd pmos W=0.1625U L=0.065U
M184_ Vdd I_af_54_6 n__O1__f_54_6 Vdd pmos W=0.1625U L=0.065U
M185_ Vdd I_at_55_6 n__O0__t_55_6 Vdd pmos W=0.1625U L=0.065U
M186_ Vdd I_af_55_6 n__O0__f_55_6 Vdd pmos W=0.1625U L=0.065U
M187_ Vdd I_at_55_6 n__O1__t_55_6 Vdd pmos W=0.1625U L=0.065U
M188_ Vdd I_af_55_6 n__O1__f_55_6 Vdd pmos W=0.1625U L=0.065U
M189_ Vdd I_at_56_6 n__O0__t_56_6 Vdd pmos W=0.1625U L=0.065U
M190_ Vdd I_af_56_6 n__O0__f_56_6 Vdd pmos W=0.1625U L=0.065U
M191_ Vdd I_at_56_6 n__O1__t_56_6 Vdd pmos W=0.1625U L=0.065U
M192_ Vdd I_af_56_6 n__O1__f_56_6 Vdd pmos W=0.1625U L=0.065U
M193_ Vdd I_at_57_6 n__O0__t_57_6 Vdd pmos W=0.1625U L=0.065U
M194_ Vdd I_af_57_6 n__O0__f_57_6 Vdd pmos W=0.1625U L=0.065U
M195_ Vdd I_at_57_6 n__O1__t_57_6 Vdd pmos W=0.1625U L=0.065U
M196_ Vdd I_af_57_6 n__O1__f_57_6 Vdd pmos W=0.1625U L=0.065U
M197_ Vdd I_at_58_6 n__O0__t_58_6 Vdd pmos W=0.1625U L=0.065U
M198_ Vdd I_af_58_6 n__O0__f_58_6 Vdd pmos W=0.1625U L=0.065U
M199_ Vdd I_at_58_6 n__O1__t_58_6 Vdd pmos W=0.1625U L=0.065U
M200_ Vdd I_af_58_6 n__O1__f_58_6 Vdd pmos W=0.1625U L=0.065U
M201_ Vdd I_at_59_6 n__O0__t_59_6 Vdd pmos W=0.1625U L=0.065U
M202_ Vdd I_af_59_6 n__O0__f_59_6 Vdd pmos W=0.1625U L=0.065U
M203_ Vdd I_at_59_6 n__O1__t_59_6 Vdd pmos W=0.1625U L=0.065U
M204_ Vdd I_af_59_6 n__O1__f_59_6 Vdd pmos W=0.1625U L=0.065U
M205_ Vdd I_at_510_6 n__O0__t_510_6 Vdd pmos W=0.1625U L=0.065U
M206_ Vdd I_af_510_6 n__O0__f_510_6 Vdd pmos W=0.1625U L=0.065U
M207_ Vdd I_at_510_6 n__O1__t_510_6 Vdd pmos W=0.1625U L=0.065U
M208_ Vdd I_af_510_6 n__O1__f_510_6 Vdd pmos W=0.1625U L=0.065U
M209_ Vdd I_at_511_6 n__O0__t_511_6 Vdd pmos W=0.1625U L=0.065U
M210_ Vdd I_af_511_6 n__O0__f_511_6 Vdd pmos W=0.1625U L=0.065U
M211_ Vdd I_at_511_6 n__O1__t_511_6 Vdd pmos W=0.1625U L=0.065U
M212_ Vdd I_af_511_6 n__O1__f_511_6 Vdd pmos W=0.1625U L=0.065U
M213_ Vdd I_at_512_6 n__O0__t_512_6 Vdd pmos W=0.1625U L=0.065U
M214_ Vdd I_af_512_6 n__O0__f_512_6 Vdd pmos W=0.1625U L=0.065U
M215_ Vdd I_at_512_6 n__O1__t_512_6 Vdd pmos W=0.1625U L=0.065U
M216_ Vdd I_af_512_6 n__O1__f_512_6 Vdd pmos W=0.1625U L=0.065U
M217_ Vdd s inv__s Vdd pmos W=0.1625U L=0.065U
M218_ Vdd reset inv__reset Vdd pmos W=0.1625U L=0.065U
M219_ Vdd p inv__p Vdd pmos W=0.1625U L=0.065U
M220_ Vdd a inv__a Vdd pmos W=0.1625U L=0.065U
M221_ Vdd w__0i inv__w__0i Vdd pmos W=0.1625U L=0.065U
M222_ Vdd w__0 inv__w__0 Vdd pmos W=0.1625U L=0.065U
M223_ Vdd inv__w__1 w__1 Vdd pmos W=0.1625U L=0.065U
M224_ Vdd I_at_531_6 inv__I__t31 Vdd pmos W=0.1625U L=0.065U
M225_ Vdd I_af_531_6 inv__I__f31 Vdd pmos W=0.1625U L=0.065U
M226_ Vdd I_af_50_6 inv__I__f0 Vdd pmos W=0.1625U L=0.065U
M227_ Vdd n__I__a I_aa Vdd pmos W=0.1625U L=0.065U
M228_ Vdd n__O0__t_50_6 O0_at_50_6 Vdd pmos W=0.1625U L=0.065U
M229_ Vdd n__O0__f_50_6 O0_af_50_6 Vdd pmos W=0.1625U L=0.065U
M230_ Vdd n__O1__t_50_6 O1_at_50_6 Vdd pmos W=0.1625U L=0.065U
M231_ Vdd n__O1__f_50_6 O1_af_50_6 Vdd pmos W=0.1625U L=0.065U
M232_ Vdd n__O0__t_51_6 O0_at_51_6 Vdd pmos W=0.1625U L=0.065U
M233_ Vdd n__O0__f_51_6 O0_af_51_6 Vdd pmos W=0.1625U L=0.065U
M234_ Vdd n__O1__t_51_6 O1_at_51_6 Vdd pmos W=0.1625U L=0.065U
M235_ Vdd n__O1__f_51_6 O1_af_51_6 Vdd pmos W=0.1625U L=0.065U
M236_ Vdd n__O0__t_52_6 O0_at_52_6 Vdd pmos W=0.1625U L=0.065U
M237_ Vdd n__O0__f_52_6 O0_af_52_6 Vdd pmos W=0.1625U L=0.065U
M238_ Vdd n__O1__t_52_6 O1_at_52_6 Vdd pmos W=0.1625U L=0.065U
M239_ Vdd n__O1__f_52_6 O1_af_52_6 Vdd pmos W=0.1625U L=0.065U
M240_ Vdd n__O0__t_53_6 O0_at_53_6 Vdd pmos W=0.1625U L=0.065U
M241_ Vdd n__O0__f_53_6 O0_af_53_6 Vdd pmos W=0.1625U L=0.065U
M242_ Vdd n__O1__t_53_6 O1_at_53_6 Vdd pmos W=0.1625U L=0.065U
M243_ Vdd n__O1__f_53_6 O1_af_53_6 Vdd pmos W=0.1625U L=0.065U
M244_ Vdd n__O0__t_54_6 O0_at_54_6 Vdd pmos W=0.1625U L=0.065U
M245_ Vdd n__O0__f_54_6 O0_af_54_6 Vdd pmos W=0.1625U L=0.065U
M246_ Vdd n__O1__t_54_6 O1_at_54_6 Vdd pmos W=0.1625U L=0.065U
M247_ Vdd n__O1__f_54_6 O1_af_54_6 Vdd pmos W=0.1625U L=0.065U
M248_ Vdd n__O0__t_55_6 O0_at_55_6 Vdd pmos W=0.1625U L=0.065U
M249_ Vdd n__O0__f_55_6 O0_af_55_6 Vdd pmos W=0.1625U L=0.065U
M250_ Vdd n__O1__t_55_6 O1_at_55_6 Vdd pmos W=0.1625U L=0.065U
M251_ Vdd n__O1__f_55_6 O1_af_55_6 Vdd pmos W=0.1625U L=0.065U
M252_ Vdd n__O0__t_56_6 O0_at_56_6 Vdd pmos W=0.1625U L=0.065U
M253_ Vdd n__O0__f_56_6 O0_af_56_6 Vdd pmos W=0.1625U L=0.065U
M254_ Vdd n__O1__t_56_6 O1_at_56_6 Vdd pmos W=0.1625U L=0.065U
M255_ Vdd n__O1__f_56_6 O1_af_56_6 Vdd pmos W=0.1625U L=0.065U
M256_ Vdd n__O0__t_57_6 O0_at_57_6 Vdd pmos W=0.1625U L=0.065U
M257_ Vdd n__O0__f_57_6 O0_af_57_6 Vdd pmos W=0.1625U L=0.065U
M258_ Vdd n__O1__t_57_6 O1_at_57_6 Vdd pmos W=0.1625U L=0.065U
M259_ Vdd n__O1__f_57_6 O1_af_57_6 Vdd pmos W=0.1625U L=0.065U
M260_ Vdd n__O0__t_58_6 O0_at_58_6 Vdd pmos W=0.1625U L=0.065U
M261_ Vdd n__O0__f_58_6 O0_af_58_6 Vdd pmos W=0.1625U L=0.065U
M262_ Vdd n__O1__t_58_6 O1_at_58_6 Vdd pmos W=0.1625U L=0.065U
M263_ Vdd n__O1__f_58_6 O1_af_58_6 Vdd pmos W=0.1625U L=0.065U
M264_ Vdd n__O0__t_59_6 O0_at_59_6 Vdd pmos W=0.1625U L=0.065U
M265_ Vdd n__O0__f_59_6 O0_af_59_6 Vdd pmos W=0.1625U L=0.065U
M266_ Vdd n__O1__t_59_6 O1_at_59_6 Vdd pmos W=0.1625U L=0.065U
M267_ Vdd n__O1__f_59_6 O1_af_59_6 Vdd pmos W=0.1625U L=0.065U
M268_ Vdd n__O0__t_510_6 O0_at_510_6 Vdd pmos W=0.1625U L=0.065U
M269_ Vdd n__O0__f_510_6 O0_af_510_6 Vdd pmos W=0.1625U L=0.065U
M270_ Vdd n__O1__t_510_6 O1_at_510_6 Vdd pmos W=0.1625U L=0.065U
M271_ Vdd n__O1__f_510_6 O1_af_510_6 Vdd pmos W=0.1625U L=0.065U
M272_ Vdd n__O0__t_511_6 O0_at_511_6 Vdd pmos W=0.1625U L=0.065U
M273_ Vdd n__O0__f_511_6 O0_af_511_6 Vdd pmos W=0.1625U L=0.065U
M274_ Vdd n__O1__t_511_6 O1_at_511_6 Vdd pmos W=0.1625U L=0.065U
M275_ Vdd n__O1__f_511_6 O1_af_511_6 Vdd pmos W=0.1625U L=0.065U
M276_ Vdd n__O0__t_512_6 O0_at_512_6 Vdd pmos W=0.1625U L=0.065U
M277_ Vdd n__O0__f_512_6 O0_af_512_6 Vdd pmos W=0.1625U L=0.065U
M278_ Vdd n__O1__t_512_6 O1_at_512_6 Vdd pmos W=0.1625U L=0.065U
M279_ Vdd n__O1__f_512_6 O1_af_512_6 Vdd pmos W=0.1625U L=0.065U
M280_ Vdd n__O0__t_513_6 O0_at_513_6 Vdd pmos W=0.1625U L=0.065U
M281_ Vdd n__O0__f_513_6 O0_af_513_6 Vdd pmos W=0.1625U L=0.065U
M282_ Vdd n__O1__t_513_6 O1_at_513_6 Vdd pmos W=0.1625U L=0.065U
M283_ Vdd n__O1__f_513_6 O1_af_513_6 Vdd pmos W=0.1625U L=0.065U
M284_ Vdd n__O0__t_514_6 O0_at_514_6 Vdd pmos W=0.1625U L=0.065U
M285_ Vdd n__O0__f_514_6 O0_af_514_6 Vdd pmos W=0.1625U L=0.065U
M286_ Vdd n__O1__t_514_6 O1_at_514_6 Vdd pmos W=0.1625U L=0.065U
M287_ Vdd n__O1__f_514_6 O1_af_514_6 Vdd pmos W=0.1625U L=0.065U
M288_ Vdd n__O0__t_515_6 O0_at_515_6 Vdd pmos W=0.1625U L=0.065U
M289_ Vdd n__O0__f_515_6 O0_af_515_6 Vdd pmos W=0.1625U L=0.065U
M290_ Vdd n__O1__t_515_6 O1_at_515_6 Vdd pmos W=0.1625U L=0.065U
M291_ Vdd n__O1__f_515_6 O1_af_515_6 Vdd pmos W=0.1625U L=0.065U
M292_ Vdd n__O0__t_516_6 O0_at_516_6 Vdd pmos W=0.1625U L=0.065U
M293_ Vdd n__O0__f_516_6 O0_af_516_6 Vdd pmos W=0.1625U L=0.065U
M294_ Vdd n__O1__t_516_6 O1_at_516_6 Vdd pmos W=0.1625U L=0.065U
M295_ Vdd n__O1__f_516_6 O1_af_516_6 Vdd pmos W=0.1625U L=0.065U
M296_ Vdd n__O0__t_517_6 O0_at_517_6 Vdd pmos W=0.1625U L=0.065U
M297_ Vdd n__O0__f_517_6 O0_af_517_6 Vdd pmos W=0.1625U L=0.065U
M298_ Vdd n__O1__t_517_6 O1_at_517_6 Vdd pmos W=0.1625U L=0.065U
M299_ Vdd n__O1__f_517_6 O1_af_517_6 Vdd pmos W=0.1625U L=0.065U
M300_ Vdd n__O0__t_518_6 O0_at_518_6 Vdd pmos W=0.1625U L=0.065U
M301_ Vdd n__O0__f_518_6 O0_af_518_6 Vdd pmos W=0.1625U L=0.065U
M302_ Vdd n__O1__t_518_6 O1_at_518_6 Vdd pmos W=0.1625U L=0.065U
M303_ Vdd n__O1__f_518_6 O1_af_518_6 Vdd pmos W=0.1625U L=0.065U
M304_ Vdd n__O0__t_519_6 O0_at_519_6 Vdd pmos W=0.1625U L=0.065U
M305_ Vdd n__O0__f_519_6 O0_af_519_6 Vdd pmos W=0.1625U L=0.065U
M306_ Vdd n__O1__t_519_6 O1_at_519_6 Vdd pmos W=0.1625U L=0.065U
M307_ Vdd n__O1__f_519_6 O1_af_519_6 Vdd pmos W=0.1625U L=0.065U
M308_ Vdd n__O0__t_520_6 O0_at_520_6 Vdd pmos W=0.1625U L=0.065U
M309_ Vdd n__O0__f_520_6 O0_af_520_6 Vdd pmos W=0.1625U L=0.065U
M310_ Vdd n__O1__t_520_6 O1_at_520_6 Vdd pmos W=0.1625U L=0.065U
M311_ Vdd n__O1__f_520_6 O1_af_520_6 Vdd pmos W=0.1625U L=0.065U
M312_ Vdd n__O0__t_521_6 O0_at_521_6 Vdd pmos W=0.1625U L=0.065U
M313_ Vdd n__O0__f_521_6 O0_af_521_6 Vdd pmos W=0.1625U L=0.065U
M314_ Vdd n__O1__t_521_6 O1_at_521_6 Vdd pmos W=0.1625U L=0.065U
M315_ Vdd n__O1__f_521_6 O1_af_521_6 Vdd pmos W=0.1625U L=0.065U
M316_ Vdd n__O0__t_522_6 O0_at_522_6 Vdd pmos W=0.1625U L=0.065U
M317_ Vdd n__O0__f_522_6 O0_af_522_6 Vdd pmos W=0.1625U L=0.065U
M318_ Vdd n__O1__t_522_6 O1_at_522_6 Vdd pmos W=0.1625U L=0.065U
M319_ Vdd n__O1__f_522_6 O1_af_522_6 Vdd pmos W=0.1625U L=0.065U
M320_ Vdd n__O0__t_523_6 O0_at_523_6 Vdd pmos W=0.1625U L=0.065U
M321_ Vdd n__O0__f_523_6 O0_af_523_6 Vdd pmos W=0.1625U L=0.065U
M322_ Vdd n__O1__t_523_6 O1_at_523_6 Vdd pmos W=0.1625U L=0.065U
M323_ Vdd n__O1__f_523_6 O1_af_523_6 Vdd pmos W=0.1625U L=0.065U
M324_ Vdd n__O0__t_524_6 O0_at_524_6 Vdd pmos W=0.1625U L=0.065U
M325_ Vdd n__O0__f_524_6 O0_af_524_6 Vdd pmos W=0.1625U L=0.065U
M326_ Vdd n__O1__t_524_6 O1_at_524_6 Vdd pmos W=0.1625U L=0.065U
M327_ Vdd n__O1__f_524_6 O1_af_524_6 Vdd pmos W=0.1625U L=0.065U
M328_ Vdd n__O0__t_525_6 O0_at_525_6 Vdd pmos W=0.1625U L=0.065U
M329_ Vdd n__O0__f_525_6 O0_af_525_6 Vdd pmos W=0.1625U L=0.065U
M330_ Vdd n__O1__t_525_6 O1_at_525_6 Vdd pmos W=0.1625U L=0.065U
M331_ Vdd n__O1__f_525_6 O1_af_525_6 Vdd pmos W=0.1625U L=0.065U
M332_ Vdd n__O0__t_526_6 O0_at_526_6 Vdd pmos W=0.1625U L=0.065U
M333_ Vdd n__O0__f_526_6 O0_af_526_6 Vdd pmos W=0.1625U L=0.065U
M334_ Vdd n__O1__t_526_6 O1_at_526_6 Vdd pmos W=0.1625U L=0.065U
M335_ Vdd n__O1__f_526_6 O1_af_526_6 Vdd pmos W=0.1625U L=0.065U
M336_ Vdd n__O0__t_527_6 O0_at_527_6 Vdd pmos W=0.1625U L=0.065U
M337_ Vdd n__O0__f_527_6 O0_af_527_6 Vdd pmos W=0.1625U L=0.065U
M338_ Vdd n__O1__t_527_6 O1_at_527_6 Vdd pmos W=0.1625U L=0.065U
M339_ Vdd n__O1__f_527_6 O1_af_527_6 Vdd pmos W=0.1625U L=0.065U
M340_ Vdd n__O0__t_528_6 O0_at_528_6 Vdd pmos W=0.1625U L=0.065U
M341_ Vdd n__O0__f_528_6 O0_af_528_6 Vdd pmos W=0.1625U L=0.065U
M342_ Vdd n__O1__t_528_6 O1_at_528_6 Vdd pmos W=0.1625U L=0.065U
M343_ Vdd n__O1__f_528_6 O1_af_528_6 Vdd pmos W=0.1625U L=0.065U
M344_ Vdd n__O0__t_529_6 O0_at_529_6 Vdd pmos W=0.1625U L=0.065U
M345_ Vdd n__O0__f_529_6 O0_af_529_6 Vdd pmos W=0.1625U L=0.065U
M346_ Vdd n__O1__t_529_6 O1_at_529_6 Vdd pmos W=0.1625U L=0.065U
M347_ Vdd n__O1__f_529_6 O1_af_529_6 Vdd pmos W=0.1625U L=0.065U
M348_ Vdd n__O0__t_530_6 O0_at_530_6 Vdd pmos W=0.1625U L=0.065U
M349_ Vdd n__O0__f_530_6 O0_af_530_6 Vdd pmos W=0.1625U L=0.065U
M350_ Vdd n__O1__t_530_6 O1_at_530_6 Vdd pmos W=0.1625U L=0.065U
M351_ Vdd n__O1__f_530_6 O1_af_530_6 Vdd pmos W=0.1625U L=0.065U
M352_ Vdd n__O0__t_531_6 O0_at_531_6 Vdd pmos W=0.1625U L=0.065U
M353_ Vdd n__O0__f_531_6 O0_af_531_6 Vdd pmos W=0.1625U L=0.065U
M354_ Vdd n__O1__t_531_6 O1_at_531_6 Vdd pmos W=0.1625U L=0.065U
M355_ Vdd n__O1__f_531_6 O1_af_531_6 Vdd pmos W=0.1625U L=0.065U
M356_ Vdd p #fb976# Vdd pmos W=0.1625U L=0.13U
M357_ Vdd s #fb979# Vdd pmos W=0.1625U L=0.13U
M358_keeper Vdd GND #977 Vdd pmos W=0.0975U L=0.585U
M359_ Vdd w__0i #fb982# Vdd pmos W=0.1625U L=0.13U
M360_keeper Vdd GND #980 Vdd pmos W=0.0975U L=0.585U
M361_ Vdd a #fb985# Vdd pmos W=0.1625U L=0.13U
M362_keeper Vdd GND #983 Vdd pmos W=0.0975U L=0.585U
M363_ Vdd n__I__a #fb988# Vdd pmos W=0.1625U L=0.13U
M364_keeper Vdd GND #986 Vdd pmos W=0.0975U L=1.235U
M365_ Vdd inv__w__1 #fb991# Vdd pmos W=0.1625U L=0.13U
M366_keeper Vdd GND #989 Vdd pmos W=0.0975U L=1.235U
M367_ Vdd w__0 #fb994# Vdd pmos W=0.1625U L=0.13U
M368_keeper Vdd GND #992 Vdd pmos W=0.0975U L=0.585U
M369_ Vdd n__O0__t_514_6 #fb997# Vdd pmos W=0.1625U L=0.13U
M370_keeper Vdd GND #995 Vdd pmos W=0.0975U L=0.585U
M371_ Vdd n__O0__f_514_6 #fb1000# Vdd pmos W=0.1625U L=0.13U
M372_keeper Vdd GND #998 Vdd pmos W=0.0975U L=1.235U
M373_ Vdd n__O1__t_514_6 #fb1003# Vdd pmos W=0.1625U L=0.13U
M374_keeper Vdd GND #1001 Vdd pmos W=0.0975U L=1.235U
M375_ Vdd n__O1__f_514_6 #fb1006# Vdd pmos W=0.1625U L=0.13U
M376_keeper Vdd GND #1004 Vdd pmos W=0.0975U L=1.235U
M377_ Vdd n__O0__t_515_6 #fb1009# Vdd pmos W=0.1625U L=0.13U
M378_keeper Vdd GND #1007 Vdd pmos W=0.0975U L=1.235U
M379_ Vdd n__O0__f_515_6 #fb1012# Vdd pmos W=0.1625U L=0.13U
M380_keeper Vdd GND #1010 Vdd pmos W=0.0975U L=1.235U
M381_ Vdd n__O1__t_515_6 #fb1015# Vdd pmos W=0.1625U L=0.13U
M382_keeper Vdd GND #1013 Vdd pmos W=0.0975U L=1.235U
M383_ Vdd n__O1__f_515_6 #fb1018# Vdd pmos W=0.1625U L=0.13U
M384_keeper Vdd GND #1016 Vdd pmos W=0.0975U L=1.235U
M385_ Vdd n__O0__t_516_6 #fb1021# Vdd pmos W=0.1625U L=0.13U
M386_keeper Vdd GND #1019 Vdd pmos W=0.0975U L=1.235U
M387_ Vdd n__O0__f_516_6 #fb1024# Vdd pmos W=0.1625U L=0.13U
M388_keeper Vdd GND #1022 Vdd pmos W=0.0975U L=1.235U
M389_ Vdd n__O1__t_516_6 #fb1027# Vdd pmos W=0.1625U L=0.13U
M390_keeper Vdd GND #1025 Vdd pmos W=0.0975U L=1.235U
M391_ Vdd n__O1__f_516_6 #fb1030# Vdd pmos W=0.1625U L=0.13U
M392_keeper Vdd GND #1028 Vdd pmos W=0.0975U L=1.235U
M393_ Vdd n__O0__t_517_6 #fb1033# Vdd pmos W=0.1625U L=0.13U
M394_keeper Vdd GND #1031 Vdd pmos W=0.0975U L=1.235U
M395_ Vdd n__O0__f_517_6 #fb1036# Vdd pmos W=0.1625U L=0.13U
M396_keeper Vdd GND #1034 Vdd pmos W=0.0975U L=1.235U
M397_ Vdd n__O1__t_517_6 #fb1039# Vdd pmos W=0.1625U L=0.13U
M398_keeper Vdd GND #1037 Vdd pmos W=0.0975U L=1.235U
M399_ Vdd n__O1__f_517_6 #fb1042# Vdd pmos W=0.1625U L=0.13U
M400_keeper Vdd GND #1040 Vdd pmos W=0.0975U L=1.235U
M401_ Vdd n__O0__t_518_6 #fb1045# Vdd pmos W=0.1625U L=0.13U
M402_keeper Vdd GND #1043 Vdd pmos W=0.0975U L=1.235U
M403_ Vdd n__O0__f_518_6 #fb1048# Vdd pmos W=0.1625U L=0.13U
M404_keeper Vdd GND #1046 Vdd pmos W=0.0975U L=1.235U
M405_ Vdd n__O1__t_518_6 #fb1051# Vdd pmos W=0.1625U L=0.13U
M406_keeper Vdd GND #1049 Vdd pmos W=0.0975U L=1.235U
M407_ Vdd n__O1__f_518_6 #fb1054# Vdd pmos W=0.1625U L=0.13U
M408_keeper Vdd GND #1052 Vdd pmos W=0.0975U L=1.235U
M409_ Vdd n__O0__t_519_6 #fb1057# Vdd pmos W=0.1625U L=0.13U
M410_keeper Vdd GND #1055 Vdd pmos W=0.0975U L=1.235U
M411_ Vdd n__O0__f_519_6 #fb1060# Vdd pmos W=0.1625U L=0.13U
M412_keeper Vdd GND #1058 Vdd pmos W=0.0975U L=1.235U
M413_ Vdd n__O1__t_519_6 #fb1063# Vdd pmos W=0.1625U L=0.13U
M414_keeper Vdd GND #1061 Vdd pmos W=0.0975U L=1.235U
M415_ Vdd n__O1__f_519_6 #fb1066# Vdd pmos W=0.1625U L=0.13U
M416_keeper Vdd GND #1064 Vdd pmos W=0.0975U L=1.235U
M417_ Vdd n__O0__t_520_6 #fb1069# Vdd pmos W=0.1625U L=0.13U
M418_keeper Vdd GND #1067 Vdd pmos W=0.0975U L=1.235U
M419_ Vdd n__O0__f_520_6 #fb1072# Vdd pmos W=0.1625U L=0.13U
M420_keeper Vdd GND #1070 Vdd pmos W=0.0975U L=1.235U
M421_ Vdd n__O1__t_520_6 #fb1075# Vdd pmos W=0.1625U L=0.13U
M422_keeper Vdd GND #1073 Vdd pmos W=0.0975U L=1.235U
M423_ Vdd n__O1__f_520_6 #fb1078# Vdd pmos W=0.1625U L=0.13U
M424_keeper Vdd GND #1076 Vdd pmos W=0.0975U L=1.235U
M425_ Vdd n__O0__t_521_6 #fb1081# Vdd pmos W=0.1625U L=0.13U
M426_keeper Vdd GND #1079 Vdd pmos W=0.0975U L=1.235U
M427_ Vdd n__O0__f_521_6 #fb1084# Vdd pmos W=0.1625U L=0.13U
M428_keeper Vdd GND #1082 Vdd pmos W=0.0975U L=1.235U
M429_ Vdd n__O1__t_521_6 #fb1087# Vdd pmos W=0.1625U L=0.13U
M430_keeper Vdd GND #1085 Vdd pmos W=0.0975U L=1.235U
M431_ Vdd n__O1__f_521_6 #fb1090# Vdd pmos W=0.1625U L=0.13U
M432_keeper Vdd GND #1088 Vdd pmos W=0.0975U L=1.235U
M433_ Vdd n__O0__t_522_6 #fb1093# Vdd pmos W=0.1625U L=0.13U
M434_keeper Vdd GND #1091 Vdd pmos W=0.0975U L=1.235U
M435_ Vdd n__O0__f_522_6 #fb1096# Vdd pmos W=0.1625U L=0.13U
M436_keeper Vdd GND #1094 Vdd pmos W=0.0975U L=1.235U
M437_ Vdd n__O1__t_522_6 #fb1099# Vdd pmos W=0.1625U L=0.13U
M438_keeper Vdd GND #1097 Vdd pmos W=0.0975U L=1.235U
M439_ Vdd n__O1__f_522_6 #fb1102# Vdd pmos W=0.1625U L=0.13U
M440_keeper Vdd GND #1100 Vdd pmos W=0.0975U L=1.235U
M441_ Vdd n__O0__t_523_6 #fb1105# Vdd pmos W=0.1625U L=0.13U
M442_keeper Vdd GND #1103 Vdd pmos W=0.0975U L=1.235U
M443_ Vdd n__O0__f_523_6 #fb1108# Vdd pmos W=0.1625U L=0.13U
M444_keeper Vdd GND #1106 Vdd pmos W=0.0975U L=1.235U
M445_ Vdd n__O1__t_523_6 #fb1111# Vdd pmos W=0.1625U L=0.13U
M446_keeper Vdd GND #1109 Vdd pmos W=0.0975U L=1.235U
M447_ Vdd n__O1__f_523_6 #fb1114# Vdd pmos W=0.1625U L=0.13U
M448_keeper Vdd GND #1112 Vdd pmos W=0.0975U L=1.235U
M449_ Vdd n__O0__t_524_6 #fb1117# Vdd pmos W=0.1625U L=0.13U
M450_keeper Vdd GND #1115 Vdd pmos W=0.0975U L=1.235U
M451_ Vdd n__O0__f_524_6 #fb1120# Vdd pmos W=0.1625U L=0.13U
M452_keeper Vdd GND #1118 Vdd pmos W=0.0975U L=1.235U
M453_ Vdd n__O1__t_524_6 #fb1123# Vdd pmos W=0.1625U L=0.13U
M454_keeper Vdd GND #1121 Vdd pmos W=0.0975U L=1.235U
M455_ Vdd n__O1__f_524_6 #fb1126# Vdd pmos W=0.1625U L=0.13U
M456_keeper Vdd GND #1124 Vdd pmos W=0.0975U L=1.235U
M457_ Vdd n__O0__t_525_6 #fb1129# Vdd pmos W=0.1625U L=0.13U
M458_keeper Vdd GND #1127 Vdd pmos W=0.0975U L=1.235U
M459_ Vdd n__O0__f_525_6 #fb1132# Vdd pmos W=0.1625U L=0.13U
M460_keeper Vdd GND #1130 Vdd pmos W=0.0975U L=1.235U
M461_ Vdd n__O1__t_525_6 #fb1135# Vdd pmos W=0.1625U L=0.13U
M462_keeper Vdd GND #1133 Vdd pmos W=0.0975U L=1.235U
M463_ Vdd n__O1__f_525_6 #fb1138# Vdd pmos W=0.1625U L=0.13U
M464_keeper Vdd GND #1136 Vdd pmos W=0.0975U L=1.235U
M465_ Vdd n__O0__t_526_6 #fb1141# Vdd pmos W=0.1625U L=0.13U
M466_keeper Vdd GND #1139 Vdd pmos W=0.0975U L=1.235U
M467_ Vdd n__O0__f_526_6 #fb1144# Vdd pmos W=0.1625U L=0.13U
M468_keeper Vdd GND #1142 Vdd pmos W=0.0975U L=1.235U
M469_ Vdd n__O1__t_526_6 #fb1147# Vdd pmos W=0.1625U L=0.13U
M470_keeper Vdd GND #1145 Vdd pmos W=0.0975U L=1.235U
M471_ Vdd n__O1__f_526_6 #fb1150# Vdd pmos W=0.1625U L=0.13U
M472_keeper Vdd GND #1148 Vdd pmos W=0.0975U L=1.235U
M473_ Vdd n__O0__t_527_6 #fb1153# Vdd pmos W=0.1625U L=0.13U
M474_keeper Vdd GND #1151 Vdd pmos W=0.0975U L=1.235U
M475_ Vdd n__O0__f_527_6 #fb1156# Vdd pmos W=0.1625U L=0.13U
M476_keeper Vdd GND #1154 Vdd pmos W=0.0975U L=1.235U
M477_ Vdd n__O1__t_527_6 #fb1159# Vdd pmos W=0.1625U L=0.13U
M478_keeper Vdd GND #1157 Vdd pmos W=0.0975U L=1.235U
M479_ Vdd n__O1__f_527_6 #fb1162# Vdd pmos W=0.1625U L=0.13U
M480_keeper Vdd GND #1160 Vdd pmos W=0.0975U L=1.235U
M481_ Vdd n__O0__t_528_6 #fb1165# Vdd pmos W=0.1625U L=0.13U
M482_keeper Vdd GND #1163 Vdd pmos W=0.0975U L=1.235U
M483_ Vdd n__O0__f_528_6 #fb1168# Vdd pmos W=0.1625U L=0.13U
M484_keeper Vdd GND #1166 Vdd pmos W=0.0975U L=1.235U
M485_ Vdd n__O1__t_528_6 #fb1171# Vdd pmos W=0.1625U L=0.13U
M486_keeper Vdd GND #1169 Vdd pmos W=0.0975U L=1.235U
M487_ Vdd n__O1__f_528_6 #fb1174# Vdd pmos W=0.1625U L=0.13U
M488_keeper Vdd GND #1172 Vdd pmos W=0.0975U L=1.235U
M489_ Vdd n__O0__t_529_6 #fb1177# Vdd pmos W=0.1625U L=0.13U
M490_keeper Vdd GND #1175 Vdd pmos W=0.0975U L=1.235U
M491_ Vdd n__O0__f_529_6 #fb1180# Vdd pmos W=0.1625U L=0.13U
M492_keeper Vdd GND #1178 Vdd pmos W=0.0975U L=1.235U
M493_ Vdd n__O1__t_529_6 #fb1183# Vdd pmos W=0.1625U L=0.13U
M494_keeper Vdd GND #1181 Vdd pmos W=0.0975U L=1.235U
M495_ Vdd n__O1__f_529_6 #fb1186# Vdd pmos W=0.1625U L=0.13U
M496_keeper Vdd GND #1184 Vdd pmos W=0.0975U L=1.235U
M497_ Vdd n__O0__t_530_6 #fb1189# Vdd pmos W=0.1625U L=0.13U
M498_keeper Vdd GND #1187 Vdd pmos W=0.0975U L=1.235U
M499_ Vdd n__O0__f_530_6 #fb1192# Vdd pmos W=0.1625U L=0.13U
M500_keeper Vdd GND #1190 Vdd pmos W=0.0975U L=1.235U
M501_ Vdd n__O1__t_530_6 #fb1195# Vdd pmos W=0.1625U L=0.13U
M502_keeper Vdd GND #1193 Vdd pmos W=0.0975U L=1.235U
M503_ Vdd n__O1__f_530_6 #fb1198# Vdd pmos W=0.1625U L=0.13U
M504_keeper Vdd GND #1196 Vdd pmos W=0.0975U L=1.235U
M505_ Vdd n__O0__t_531_6 #fb1201# Vdd pmos W=0.1625U L=0.13U
M506_keeper Vdd GND #1199 Vdd pmos W=0.0975U L=1.235U
M507_ Vdd n__O0__f_531_6 #fb1204# Vdd pmos W=0.1625U L=0.13U
M508_keeper Vdd GND #1202 Vdd pmos W=0.0975U L=1.235U
M509_ Vdd n__O1__t_531_6 #fb1207# Vdd pmos W=0.1625U L=0.13U
M510_keeper Vdd GND #1205 Vdd pmos W=0.0975U L=1.235U
M511_ Vdd n__O1__f_531_6 #fb1210# Vdd pmos W=0.1625U L=0.13U
M512_keeper Vdd GND #1208 Vdd pmos W=0.0975U L=1.235U
M513_ Vdd n__O0__t_513_6 #fb1213# Vdd pmos W=0.1625U L=0.13U
M514_keeper Vdd GND #1211 Vdd pmos W=0.0975U L=1.235U
M515_ Vdd n__O0__f_513_6 #fb1216# Vdd pmos W=0.1625U L=0.13U
M516_keeper Vdd GND #1214 Vdd pmos W=0.0975U L=0.91U
M517_ Vdd n__O1__t_513_6 #fb1219# Vdd pmos W=0.1625U L=0.13U
M518_keeper Vdd GND #1217 Vdd pmos W=0.0975U L=1.235U
M519_ Vdd n__O1__f_513_6 #fb1222# Vdd pmos W=0.1625U L=0.13U
M520_keeper Vdd GND #1220 Vdd pmos W=0.0975U L=0.91U
M521_ Vdd n__O0__t_50_6 #fb1225# Vdd pmos W=0.1625U L=0.13U
M522_keeper Vdd GND #1223 Vdd pmos W=0.0975U L=1.235U
M523_ Vdd n__O0__f_50_6 #fb1228# Vdd pmos W=0.1625U L=0.13U
M524_keeper Vdd GND #1226 Vdd pmos W=0.0975U L=1.235U
M525_ Vdd n__O1__t_50_6 #fb1231# Vdd pmos W=0.1625U L=0.13U
M526_keeper Vdd GND #1229 Vdd pmos W=0.0975U L=1.235U
M527_ Vdd n__O1__f_50_6 #fb1234# Vdd pmos W=0.1625U L=0.13U
M528_keeper Vdd GND #1232 Vdd pmos W=0.0975U L=1.235U
M529_ Vdd n__O0__t_51_6 #fb1237# Vdd pmos W=0.1625U L=0.13U
M530_keeper Vdd GND #1235 Vdd pmos W=0.0975U L=1.235U
M531_ Vdd n__O0__f_51_6 #fb1240# Vdd pmos W=0.1625U L=0.13U
M532_keeper Vdd GND #1238 Vdd pmos W=0.0975U L=1.235U
M533_ Vdd n__O1__t_51_6 #fb1243# Vdd pmos W=0.1625U L=0.13U
M534_keeper Vdd GND #1241 Vdd pmos W=0.0975U L=1.235U
M535_ Vdd n__O1__f_51_6 #fb1246# Vdd pmos W=0.1625U L=0.13U
M536_keeper Vdd GND #1244 Vdd pmos W=0.0975U L=1.235U
M537_ Vdd n__O0__t_52_6 #fb1249# Vdd pmos W=0.1625U L=0.13U
M538_keeper Vdd GND #1247 Vdd pmos W=0.0975U L=1.235U
M539_ Vdd n__O0__f_52_6 #fb1252# Vdd pmos W=0.1625U L=0.13U
M540_keeper Vdd GND #1250 Vdd pmos W=0.0975U L=1.235U
M541_ Vdd n__O1__t_52_6 #fb1255# Vdd pmos W=0.1625U L=0.13U
M542_keeper Vdd GND #1253 Vdd pmos W=0.0975U L=1.235U
M543_ Vdd n__O1__f_52_6 #fb1258# Vdd pmos W=0.1625U L=0.13U
M544_keeper Vdd GND #1256 Vdd pmos W=0.0975U L=1.235U
M545_ Vdd n__O0__t_53_6 #fb1261# Vdd pmos W=0.1625U L=0.13U
M546_keeper Vdd GND #1259 Vdd pmos W=0.0975U L=1.235U
M547_ Vdd n__O0__f_53_6 #fb1264# Vdd pmos W=0.1625U L=0.13U
M548_keeper Vdd GND #1262 Vdd pmos W=0.0975U L=1.235U
M549_ Vdd n__O1__t_53_6 #fb1267# Vdd pmos W=0.1625U L=0.13U
M550_keeper Vdd GND #1265 Vdd pmos W=0.0975U L=1.235U
M551_ Vdd n__O1__f_53_6 #fb1270# Vdd pmos W=0.1625U L=0.13U
M552_keeper Vdd GND #1268 Vdd pmos W=0.0975U L=1.235U
M553_ Vdd n__O0__t_54_6 #fb1273# Vdd pmos W=0.1625U L=0.13U
M554_keeper Vdd GND #1271 Vdd pmos W=0.0975U L=1.235U
M555_ Vdd n__O0__f_54_6 #fb1276# Vdd pmos W=0.1625U L=0.13U
M556_keeper Vdd GND #1274 Vdd pmos W=0.0975U L=1.235U
M557_ Vdd n__O1__t_54_6 #fb1279# Vdd pmos W=0.1625U L=0.13U
M558_keeper Vdd GND #1277 Vdd pmos W=0.0975U L=1.235U
M559_ Vdd n__O1__f_54_6 #fb1282# Vdd pmos W=0.1625U L=0.13U
M560_keeper Vdd GND #1280 Vdd pmos W=0.0975U L=1.235U
M561_ Vdd n__O0__t_55_6 #fb1285# Vdd pmos W=0.1625U L=0.13U
M562_keeper Vdd GND #1283 Vdd pmos W=0.0975U L=1.235U
M563_ Vdd n__O0__f_55_6 #fb1288# Vdd pmos W=0.1625U L=0.13U
M564_keeper Vdd GND #1286 Vdd pmos W=0.0975U L=1.235U
M565_ Vdd n__O1__t_55_6 #fb1291# Vdd pmos W=0.1625U L=0.13U
M566_keeper Vdd GND #1289 Vdd pmos W=0.0975U L=1.235U
M567_ Vdd n__O1__f_55_6 #fb1294# Vdd pmos W=0.1625U L=0.13U
M568_keeper Vdd GND #1292 Vdd pmos W=0.0975U L=1.235U
M569_ Vdd n__O0__t_56_6 #fb1297# Vdd pmos W=0.1625U L=0.13U
M570_keeper Vdd GND #1295 Vdd pmos W=0.0975U L=1.235U
M571_ Vdd n__O0__f_56_6 #fb1300# Vdd pmos W=0.1625U L=0.13U
M572_keeper Vdd GND #1298 Vdd pmos W=0.0975U L=1.235U
M573_ Vdd n__O1__t_56_6 #fb1303# Vdd pmos W=0.1625U L=0.13U
M574_keeper Vdd GND #1301 Vdd pmos W=0.0975U L=1.235U
M575_ Vdd n__O1__f_56_6 #fb1306# Vdd pmos W=0.1625U L=0.13U
M576_keeper Vdd GND #1304 Vdd pmos W=0.0975U L=1.235U
M577_ Vdd n__O0__t_57_6 #fb1309# Vdd pmos W=0.1625U L=0.13U
M578_keeper Vdd GND #1307 Vdd pmos W=0.0975U L=1.235U
M579_ Vdd n__O0__f_57_6 #fb1312# Vdd pmos W=0.1625U L=0.13U
M580_keeper Vdd GND #1310 Vdd pmos W=0.0975U L=1.235U
M581_ Vdd n__O1__t_57_6 #fb1315# Vdd pmos W=0.1625U L=0.13U
M582_keeper Vdd GND #1313 Vdd pmos W=0.0975U L=1.235U
M583_ Vdd n__O1__f_57_6 #fb1318# Vdd pmos W=0.1625U L=0.13U
M584_keeper Vdd GND #1316 Vdd pmos W=0.0975U L=1.235U
M585_ Vdd n__O0__t_58_6 #fb1321# Vdd pmos W=0.1625U L=0.13U
M586_keeper Vdd GND #1319 Vdd pmos W=0.0975U L=1.235U
M587_ Vdd n__O0__f_58_6 #fb1324# Vdd pmos W=0.1625U L=0.13U
M588_keeper Vdd GND #1322 Vdd pmos W=0.0975U L=1.235U
M589_ Vdd n__O1__t_58_6 #fb1327# Vdd pmos W=0.1625U L=0.13U
M590_keeper Vdd GND #1325 Vdd pmos W=0.0975U L=1.235U
M591_ Vdd n__O1__f_58_6 #fb1330# Vdd pmos W=0.1625U L=0.13U
M592_keeper Vdd GND #1328 Vdd pmos W=0.0975U L=1.235U
M593_ Vdd n__O0__t_59_6 #fb1333# Vdd pmos W=0.1625U L=0.13U
M594_keeper Vdd GND #1331 Vdd pmos W=0.0975U L=1.235U
M595_ Vdd n__O0__f_59_6 #fb1336# Vdd pmos W=0.1625U L=0.13U
M596_keeper Vdd GND #1334 Vdd pmos W=0.0975U L=1.235U
M597_ Vdd n__O1__t_59_6 #fb1339# Vdd pmos W=0.1625U L=0.13U
M598_keeper Vdd GND #1337 Vdd pmos W=0.0975U L=1.235U
M599_ Vdd n__O1__f_59_6 #fb1342# Vdd pmos W=0.1625U L=0.13U
M600_keeper Vdd GND #1340 Vdd pmos W=0.0975U L=1.235U
M601_ Vdd n__O0__t_510_6 #fb1345# Vdd pmos W=0.1625U L=0.13U
M602_keeper Vdd GND #1343 Vdd pmos W=0.0975U L=1.235U
M603_ Vdd n__O0__f_510_6 #fb1348# Vdd pmos W=0.1625U L=0.13U
M604_keeper Vdd GND #1346 Vdd pmos W=0.0975U L=1.235U
M605_ Vdd n__O1__t_510_6 #fb1351# Vdd pmos W=0.1625U L=0.13U
M606_keeper Vdd GND #1349 Vdd pmos W=0.0975U L=1.235U
M607_ Vdd n__O1__f_510_6 #fb1354# Vdd pmos W=0.1625U L=0.13U
M608_keeper Vdd GND #1352 Vdd pmos W=0.0975U L=1.235U
M609_ Vdd n__O0__t_511_6 #fb1357# Vdd pmos W=0.1625U L=0.13U
M610_keeper Vdd GND #1355 Vdd pmos W=0.0975U L=1.235U
M611_ Vdd n__O0__f_511_6 #fb1360# Vdd pmos W=0.1625U L=0.13U
M612_keeper Vdd GND #1358 Vdd pmos W=0.0975U L=1.235U
M613_ Vdd n__O1__t_511_6 #fb1363# Vdd pmos W=0.1625U L=0.13U
M614_keeper Vdd GND #1361 Vdd pmos W=0.0975U L=1.235U
M615_ Vdd n__O1__f_511_6 #fb1366# Vdd pmos W=0.1625U L=0.13U
M616_keeper Vdd GND #1364 Vdd pmos W=0.0975U L=1.235U
M617_ Vdd n__O0__t_512_6 #fb1369# Vdd pmos W=0.1625U L=0.13U
M618_keeper Vdd GND #1367 Vdd pmos W=0.0975U L=1.235U
M619_ Vdd n__O0__f_512_6 #fb1372# Vdd pmos W=0.1625U L=0.13U
M620_keeper Vdd GND #1370 Vdd pmos W=0.0975U L=1.235U
M621_ Vdd n__O1__t_512_6 #fb1375# Vdd pmos W=0.1625U L=0.13U
M622_keeper Vdd GND #1373 Vdd pmos W=0.0975U L=1.235U
M623_ Vdd n__O1__f_512_6 #fb1378# Vdd pmos W=0.1625U L=0.13U
M624_keeper Vdd GND #1376 Vdd pmos W=0.0975U L=1.235U
M625_keeper Vdd GND #1379 Vdd pmos W=0.0975U L=1.235U
M626_ GND I_af_531_6 #7 GND nmos W=0.0975U L=0.065U
M627_ GND inv__s #16 GND nmos W=0.0975U L=0.065U
M628_ GND reset w__0i GND nmos W=0.0975U L=0.065U
M629_ GND inv__w__1 #31 GND nmos W=0.0975U L=0.065U
M630_ GND reset a GND nmos W=0.0975U L=0.065U
M631_ GND inv__s #36 GND nmos W=0.0975U L=0.065U
M632_ GND reset w__0 GND nmos W=0.0975U L=0.065U
M633_ GND inv__s #37 GND nmos W=0.0975U L=0.065U
M634_ GND w__0i #42 GND nmos W=0.0975U L=0.065U
M635_ GND O0_aa #43 GND nmos W=0.0975U L=0.065U
M636_ GND O1_aa #43 GND nmos W=0.0975U L=0.065U
M637_ GND p #52 GND nmos W=0.0975U L=0.065U
M638_ GND p #61 GND nmos W=0.0975U L=0.065U
M639_ GND inv__p #70 GND nmos W=0.0975U L=0.065U
M640_ GND inv__p #77 GND nmos W=0.0975U L=0.065U
M641_ GND p #84 GND nmos W=0.0975U L=0.065U
M642_ GND p #92 GND nmos W=0.0975U L=0.065U
M643_ GND inv__p #100 GND nmos W=0.0975U L=0.065U
M644_ GND inv__p #107 GND nmos W=0.0975U L=0.065U
M645_ GND p #114 GND nmos W=0.0975U L=0.065U
M646_ GND p #122 GND nmos W=0.0975U L=0.065U
M647_ GND inv__p #130 GND nmos W=0.0975U L=0.065U
M648_ GND inv__p #137 GND nmos W=0.0975U L=0.065U
M649_ GND p #144 GND nmos W=0.0975U L=0.065U
M650_ GND p #152 GND nmos W=0.0975U L=0.065U
M651_ GND inv__p #160 GND nmos W=0.0975U L=0.065U
M652_ GND inv__p #167 GND nmos W=0.0975U L=0.065U
M653_ GND p #174 GND nmos W=0.0975U L=0.065U
M654_ GND p #182 GND nmos W=0.0975U L=0.065U
M655_ GND inv__p #190 GND nmos W=0.0975U L=0.065U
M656_ GND inv__p #197 GND nmos W=0.0975U L=0.065U
M657_ GND p #204 GND nmos W=0.0975U L=0.065U
M658_ GND p #212 GND nmos W=0.0975U L=0.065U
M659_ GND inv__p #220 GND nmos W=0.0975U L=0.065U
M660_ GND inv__p #227 GND nmos W=0.0975U L=0.065U
M661_ GND p #234 GND nmos W=0.0975U L=0.065U
M662_ GND p #242 GND nmos W=0.0975U L=0.065U
M663_ GND inv__p #250 GND nmos W=0.0975U L=0.065U
M664_ GND inv__p #257 GND nmos W=0.0975U L=0.065U
M665_ GND p #264 GND nmos W=0.0975U L=0.065U
M666_ GND p #272 GND nmos W=0.0975U L=0.065U
M667_ GND inv__p #280 GND nmos W=0.0975U L=0.065U
M668_ GND inv__p #287 GND nmos W=0.0975U L=0.065U
M669_ GND p #294 GND nmos W=0.0975U L=0.065U
M670_ GND p #302 GND nmos W=0.0975U L=0.065U
M671_ GND inv__p #310 GND nmos W=0.0975U L=0.065U
M672_ GND inv__p #317 GND nmos W=0.0975U L=0.065U
M673_ GND p #324 GND nmos W=0.0975U L=0.065U
M674_ GND p #332 GND nmos W=0.0975U L=0.065U
M675_ GND inv__p #340 GND nmos W=0.0975U L=0.065U
M676_ GND inv__p #347 GND nmos W=0.0975U L=0.065U
M677_ GND p #354 GND nmos W=0.0975U L=0.065U
M678_ GND p #362 GND nmos W=0.0975U L=0.065U
M679_ GND inv__p #370 GND nmos W=0.0975U L=0.065U
M680_ GND inv__p #377 GND nmos W=0.0975U L=0.065U
M681_ GND p #384 GND nmos W=0.0975U L=0.065U
M682_ GND p #392 GND nmos W=0.0975U L=0.065U
M683_ GND inv__p #400 GND nmos W=0.0975U L=0.065U
M684_ GND inv__p #407 GND nmos W=0.0975U L=0.065U
M685_ GND p #414 GND nmos W=0.0975U L=0.065U
M686_ GND p #422 GND nmos W=0.0975U L=0.065U
M687_ GND inv__p #430 GND nmos W=0.0975U L=0.065U
M688_ GND inv__p #437 GND nmos W=0.0975U L=0.065U
M689_ GND p #444 GND nmos W=0.0975U L=0.065U
M690_ GND p #452 GND nmos W=0.0975U L=0.065U
M691_ GND inv__p #460 GND nmos W=0.0975U L=0.065U
M692_ GND inv__p #467 GND nmos W=0.0975U L=0.065U
M693_ GND p #474 GND nmos W=0.0975U L=0.065U
M694_ GND p #482 GND nmos W=0.0975U L=0.065U
M695_ GND inv__p #490 GND nmos W=0.0975U L=0.065U
M696_ GND inv__p #497 GND nmos W=0.0975U L=0.065U
M697_ GND p #504 GND nmos W=0.0975U L=0.065U
M698_ GND p #512 GND nmos W=0.0975U L=0.065U
M699_ GND inv__p #520 GND nmos W=0.0975U L=0.065U
M700_ GND inv__p #527 GND nmos W=0.0975U L=0.065U
M701_ GND p #534 GND nmos W=0.0975U L=0.065U
M702_ GND p #542 GND nmos W=0.0975U L=0.065U
M703_ GND inv__p #550 GND nmos W=0.0975U L=0.065U
M704_ GND inv__p #557 GND nmos W=0.0975U L=0.065U
M705_ GND p #564 GND nmos W=0.0975U L=0.065U
M706_ GND p #572 GND nmos W=0.0975U L=0.065U
M707_ GND inv__p #579 GND nmos W=0.0975U L=0.065U
M708_ GND inv__p #586 GND nmos W=0.0975U L=0.065U
M709_ GND p #594 GND nmos W=0.0975U L=0.065U
M710_ GND p #597 GND nmos W=0.0975U L=0.065U
M711_ GND inv__p #605 GND nmos W=0.0975U L=0.065U
M712_ GND inv__p #608 GND nmos W=0.0975U L=0.065U
M713_ GND p #616 GND nmos W=0.0975U L=0.065U
M714_ GND p #620 GND nmos W=0.0975U L=0.065U
M715_ GND inv__p #625 GND nmos W=0.0975U L=0.065U
M716_ GND inv__p #629 GND nmos W=0.0975U L=0.065U
M717_ GND p #633 GND nmos W=0.0975U L=0.065U
M718_ GND p #638 GND nmos W=0.0975U L=0.065U
M719_ GND inv__p #643 GND nmos W=0.0975U L=0.065U
M720_ GND inv__p #647 GND nmos W=0.0975U L=0.065U
M721_ GND p #651 GND nmos W=0.0975U L=0.065U
M722_ GND p #656 GND nmos W=0.0975U L=0.065U
M723_ GND inv__p #661 GND nmos W=0.0975U L=0.065U
M724_ GND inv__p #665 GND nmos W=0.0975U L=0.065U
M725_ GND p #669 GND nmos W=0.0975U L=0.065U
M726_ GND p #674 GND nmos W=0.0975U L=0.065U
M727_ GND inv__p #679 GND nmos W=0.0975U L=0.065U
M728_ GND inv__p #683 GND nmos W=0.0975U L=0.065U
M729_ GND p #687 GND nmos W=0.0975U L=0.065U
M730_ GND p #692 GND nmos W=0.0975U L=0.065U
M731_ GND inv__p #697 GND nmos W=0.0975U L=0.065U
M732_ GND inv__p #701 GND nmos W=0.0975U L=0.065U
M733_ GND p #705 GND nmos W=0.0975U L=0.065U
M734_ GND p #710 GND nmos W=0.0975U L=0.065U
M735_ GND inv__p #715 GND nmos W=0.0975U L=0.065U
M736_ GND inv__p #719 GND nmos W=0.0975U L=0.065U
M737_ GND p #723 GND nmos W=0.0975U L=0.065U
M738_ GND p #728 GND nmos W=0.0975U L=0.065U
M739_ GND inv__p #733 GND nmos W=0.0975U L=0.065U
M740_ GND inv__p #737 GND nmos W=0.0975U L=0.065U
M741_ GND p #741 GND nmos W=0.0975U L=0.065U
M742_ GND p #746 GND nmos W=0.0975U L=0.065U
M743_ GND inv__p #751 GND nmos W=0.0975U L=0.065U
M744_ GND inv__p #755 GND nmos W=0.0975U L=0.065U
M745_ GND p #759 GND nmos W=0.0975U L=0.065U
M746_ GND p #764 GND nmos W=0.0975U L=0.065U
M747_ GND inv__p #769 GND nmos W=0.0975U L=0.065U
M748_ GND inv__p #773 GND nmos W=0.0975U L=0.065U
M749_ GND p #777 GND nmos W=0.0975U L=0.065U
M750_ GND p #782 GND nmos W=0.0975U L=0.065U
M751_ GND inv__p #787 GND nmos W=0.0975U L=0.065U
M752_ GND inv__p #791 GND nmos W=0.0975U L=0.065U
M753_ GND p #795 GND nmos W=0.0975U L=0.065U
M754_ GND p #800 GND nmos W=0.0975U L=0.065U
M755_ GND inv__p #805 GND nmos W=0.0975U L=0.065U
M756_ GND inv__p #809 GND nmos W=0.0975U L=0.065U
M757_ GND p #813 GND nmos W=0.0975U L=0.065U
M758_ GND p #818 GND nmos W=0.0975U L=0.065U
M759_ GND inv__p #823 GND nmos W=0.0975U L=0.065U
M760_ GND inv__p #827 GND nmos W=0.0975U L=0.065U
M761_ GND p #831 GND nmos W=0.0975U L=0.065U
M762_ GND p #836 GND nmos W=0.0975U L=0.065U
M763_ GND inv__p #841 GND nmos W=0.0975U L=0.065U
M764_ GND inv__p #845 GND nmos W=0.0975U L=0.065U
M765_ GND s inv__s GND nmos W=0.0975U L=0.065U
M766_ GND reset inv__reset GND nmos W=0.0975U L=0.065U
M767_ GND p inv__p GND nmos W=0.0975U L=0.065U
M768_ GND a inv__a GND nmos W=0.0975U L=0.065U
M769_ GND w__0i inv__w__0i GND nmos W=0.0975U L=0.065U
M770_ GND w__0 inv__w__0 GND nmos W=0.0975U L=0.065U
M771_ GND inv__w__1 w__1 GND nmos W=0.0975U L=0.065U
M772_ GND I_at_531_6 inv__I__t31 GND nmos W=0.0975U L=0.065U
M773_ GND I_af_531_6 inv__I__f31 GND nmos W=0.0975U L=0.065U
M774_ GND I_af_50_6 inv__I__f0 GND nmos W=0.0975U L=0.065U
M775_ GND n__I__a I_aa GND nmos W=0.0975U L=0.065U
M776_ GND n__O0__t_50_6 O0_at_50_6 GND nmos W=0.0975U L=0.065U
M777_ GND n__O0__f_50_6 O0_af_50_6 GND nmos W=0.0975U L=0.065U
M778_ GND n__O1__t_50_6 O1_at_50_6 GND nmos W=0.0975U L=0.065U
M779_ GND n__O1__f_50_6 O1_af_50_6 GND nmos W=0.0975U L=0.065U
M780_ GND n__O0__t_51_6 O0_at_51_6 GND nmos W=0.0975U L=0.065U
M781_ GND n__O0__f_51_6 O0_af_51_6 GND nmos W=0.0975U L=0.065U
M782_ GND n__O1__t_51_6 O1_at_51_6 GND nmos W=0.0975U L=0.065U
M783_ GND n__O1__f_51_6 O1_af_51_6 GND nmos W=0.0975U L=0.065U
M784_ GND n__O0__t_52_6 O0_at_52_6 GND nmos W=0.0975U L=0.065U
M785_ GND n__O0__f_52_6 O0_af_52_6 GND nmos W=0.0975U L=0.065U
M786_ GND n__O1__t_52_6 O1_at_52_6 GND nmos W=0.0975U L=0.065U
M787_ GND n__O1__f_52_6 O1_af_52_6 GND nmos W=0.0975U L=0.065U
M788_ GND n__O0__t_53_6 O0_at_53_6 GND nmos W=0.0975U L=0.065U
M789_ GND n__O0__f_53_6 O0_af_53_6 GND nmos W=0.0975U L=0.065U
M790_ GND n__O1__t_53_6 O1_at_53_6 GND nmos W=0.0975U L=0.065U
M791_ GND n__O1__f_53_6 O1_af_53_6 GND nmos W=0.0975U L=0.065U
M792_ GND n__O0__t_54_6 O0_at_54_6 GND nmos W=0.0975U L=0.065U
M793_ GND n__O0__f_54_6 O0_af_54_6 GND nmos W=0.0975U L=0.065U
M794_ GND n__O1__t_54_6 O1_at_54_6 GND nmos W=0.0975U L=0.065U
M795_ GND n__O1__f_54_6 O1_af_54_6 GND nmos W=0.0975U L=0.065U
M796_ GND n__O0__t_55_6 O0_at_55_6 GND nmos W=0.0975U L=0.065U
M797_ GND n__O0__f_55_6 O0_af_55_6 GND nmos W=0.0975U L=0.065U
M798_ GND n__O1__t_55_6 O1_at_55_6 GND nmos W=0.0975U L=0.065U
M799_ GND n__O1__f_55_6 O1_af_55_6 GND nmos W=0.0975U L=0.065U
M800_ GND n__O0__t_56_6 O0_at_56_6 GND nmos W=0.0975U L=0.065U
M801_ GND n__O0__f_56_6 O0_af_56_6 GND nmos W=0.0975U L=0.065U
M802_ GND n__O1__t_56_6 O1_at_56_6 GND nmos W=0.0975U L=0.065U
M803_ GND n__O1__f_56_6 O1_af_56_6 GND nmos W=0.0975U L=0.065U
M804_ GND n__O0__t_57_6 O0_at_57_6 GND nmos W=0.0975U L=0.065U
M805_ GND n__O0__f_57_6 O0_af_57_6 GND nmos W=0.0975U L=0.065U
M806_ GND n__O1__t_57_6 O1_at_57_6 GND nmos W=0.0975U L=0.065U
M807_ GND n__O1__f_57_6 O1_af_57_6 GND nmos W=0.0975U L=0.065U
M808_ GND n__O0__t_58_6 O0_at_58_6 GND nmos W=0.0975U L=0.065U
M809_ GND n__O0__f_58_6 O0_af_58_6 GND nmos W=0.0975U L=0.065U
M810_ GND n__O1__t_58_6 O1_at_58_6 GND nmos W=0.0975U L=0.065U
M811_ GND n__O1__f_58_6 O1_af_58_6 GND nmos W=0.0975U L=0.065U
M812_ GND n__O0__t_59_6 O0_at_59_6 GND nmos W=0.0975U L=0.065U
M813_ GND n__O0__f_59_6 O0_af_59_6 GND nmos W=0.0975U L=0.065U
M814_ GND n__O1__t_59_6 O1_at_59_6 GND nmos W=0.0975U L=0.065U
M815_ GND n__O1__f_59_6 O1_af_59_6 GND nmos W=0.0975U L=0.065U
M816_ GND n__O0__t_510_6 O0_at_510_6 GND nmos W=0.0975U L=0.065U
M817_ GND n__O0__f_510_6 O0_af_510_6 GND nmos W=0.0975U L=0.065U
M818_ GND n__O1__t_510_6 O1_at_510_6 GND nmos W=0.0975U L=0.065U
M819_ GND n__O1__f_510_6 O1_af_510_6 GND nmos W=0.0975U L=0.065U
M820_ GND n__O0__t_511_6 O0_at_511_6 GND nmos W=0.0975U L=0.065U
M821_ GND n__O0__f_511_6 O0_af_511_6 GND nmos W=0.0975U L=0.065U
M822_ GND n__O1__t_511_6 O1_at_511_6 GND nmos W=0.0975U L=0.065U
M823_ GND n__O1__f_511_6 O1_af_511_6 GND nmos W=0.0975U L=0.065U
M824_ GND n__O0__t_512_6 O0_at_512_6 GND nmos W=0.0975U L=0.065U
M825_ GND n__O0__f_512_6 O0_af_512_6 GND nmos W=0.0975U L=0.065U
M826_ GND n__O1__t_512_6 O1_at_512_6 GND nmos W=0.0975U L=0.065U
M827_ GND n__O1__f_512_6 O1_af_512_6 GND nmos W=0.0975U L=0.065U
M828_ GND n__O0__t_513_6 O0_at_513_6 GND nmos W=0.0975U L=0.065U
M829_ GND n__O0__f_513_6 O0_af_513_6 GND nmos W=0.0975U L=0.065U
M830_ GND n__O1__t_513_6 O1_at_513_6 GND nmos W=0.0975U L=0.065U
M831_ GND n__O1__f_513_6 O1_af_513_6 GND nmos W=0.0975U L=0.065U
M832_ GND n__O0__t_514_6 O0_at_514_6 GND nmos W=0.0975U L=0.065U
M833_ GND n__O0__f_514_6 O0_af_514_6 GND nmos W=0.0975U L=0.065U
M834_ GND n__O1__t_514_6 O1_at_514_6 GND nmos W=0.0975U L=0.065U
M835_ GND n__O1__f_514_6 O1_af_514_6 GND nmos W=0.0975U L=0.065U
M836_ GND n__O0__t_515_6 O0_at_515_6 GND nmos W=0.0975U L=0.065U
M837_ GND n__O0__f_515_6 O0_af_515_6 GND nmos W=0.0975U L=0.065U
M838_ GND n__O1__t_515_6 O1_at_515_6 GND nmos W=0.0975U L=0.065U
M839_ GND n__O1__f_515_6 O1_af_515_6 GND nmos W=0.0975U L=0.065U
M840_ GND n__O0__t_516_6 O0_at_516_6 GND nmos W=0.0975U L=0.065U
M841_ GND n__O0__f_516_6 O0_af_516_6 GND nmos W=0.0975U L=0.065U
M842_ GND n__O1__t_516_6 O1_at_516_6 GND nmos W=0.0975U L=0.065U
M843_ GND n__O1__f_516_6 O1_af_516_6 GND nmos W=0.0975U L=0.065U
M844_ GND n__O0__t_517_6 O0_at_517_6 GND nmos W=0.0975U L=0.065U
M845_ GND n__O0__f_517_6 O0_af_517_6 GND nmos W=0.0975U L=0.065U
M846_ GND n__O1__t_517_6 O1_at_517_6 GND nmos W=0.0975U L=0.065U
M847_ GND n__O1__f_517_6 O1_af_517_6 GND nmos W=0.0975U L=0.065U
M848_ GND n__O0__t_518_6 O0_at_518_6 GND nmos W=0.0975U L=0.065U
M849_ GND n__O0__f_518_6 O0_af_518_6 GND nmos W=0.0975U L=0.065U
M850_ GND n__O1__t_518_6 O1_at_518_6 GND nmos W=0.0975U L=0.065U
M851_ GND n__O1__f_518_6 O1_af_518_6 GND nmos W=0.0975U L=0.065U
M852_ GND n__O0__t_519_6 O0_at_519_6 GND nmos W=0.0975U L=0.065U
M853_ GND n__O0__f_519_6 O0_af_519_6 GND nmos W=0.0975U L=0.065U
M854_ GND n__O1__t_519_6 O1_at_519_6 GND nmos W=0.0975U L=0.065U
M855_ GND n__O1__f_519_6 O1_af_519_6 GND nmos W=0.0975U L=0.065U
M856_ GND n__O0__t_520_6 O0_at_520_6 GND nmos W=0.0975U L=0.065U
M857_ GND n__O0__f_520_6 O0_af_520_6 GND nmos W=0.0975U L=0.065U
M858_ GND n__O1__t_520_6 O1_at_520_6 GND nmos W=0.0975U L=0.065U
M859_ GND n__O1__f_520_6 O1_af_520_6 GND nmos W=0.0975U L=0.065U
M860_ GND n__O0__t_521_6 O0_at_521_6 GND nmos W=0.0975U L=0.065U
M861_ GND n__O0__f_521_6 O0_af_521_6 GND nmos W=0.0975U L=0.065U
M862_ GND n__O1__t_521_6 O1_at_521_6 GND nmos W=0.0975U L=0.065U
M863_ GND n__O1__f_521_6 O1_af_521_6 GND nmos W=0.0975U L=0.065U
M864_ GND n__O0__t_522_6 O0_at_522_6 GND nmos W=0.0975U L=0.065U
M865_ GND n__O0__f_522_6 O0_af_522_6 GND nmos W=0.0975U L=0.065U
M866_ GND n__O1__t_522_6 O1_at_522_6 GND nmos W=0.0975U L=0.065U
M867_ GND n__O1__f_522_6 O1_af_522_6 GND nmos W=0.0975U L=0.065U
M868_ GND n__O0__t_523_6 O0_at_523_6 GND nmos W=0.0975U L=0.065U
M869_ GND n__O0__f_523_6 O0_af_523_6 GND nmos W=0.0975U L=0.065U
M870_ GND n__O1__t_523_6 O1_at_523_6 GND nmos W=0.0975U L=0.065U
M871_ GND n__O1__f_523_6 O1_af_523_6 GND nmos W=0.0975U L=0.065U
M872_ GND n__O0__t_524_6 O0_at_524_6 GND nmos W=0.0975U L=0.065U
M873_ GND n__O0__f_524_6 O0_af_524_6 GND nmos W=0.0975U L=0.065U
M874_ GND n__O1__t_524_6 O1_at_524_6 GND nmos W=0.0975U L=0.065U
M875_ GND n__O1__f_524_6 O1_af_524_6 GND nmos W=0.0975U L=0.065U
M876_ GND n__O0__t_525_6 O0_at_525_6 GND nmos W=0.0975U L=0.065U
M877_ GND n__O0__f_525_6 O0_af_525_6 GND nmos W=0.0975U L=0.065U
M878_ GND n__O1__t_525_6 O1_at_525_6 GND nmos W=0.0975U L=0.065U
M879_ GND n__O1__f_525_6 O1_af_525_6 GND nmos W=0.0975U L=0.065U
M880_ GND n__O0__t_526_6 O0_at_526_6 GND nmos W=0.0975U L=0.065U
M881_ GND n__O0__f_526_6 O0_af_526_6 GND nmos W=0.0975U L=0.065U
M882_ GND n__O1__t_526_6 O1_at_526_6 GND nmos W=0.0975U L=0.065U
M883_ GND n__O1__f_526_6 O1_af_526_6 GND nmos W=0.0975U L=0.065U
M884_ GND n__O0__t_527_6 O0_at_527_6 GND nmos W=0.0975U L=0.065U
M885_ GND n__O0__f_527_6 O0_af_527_6 GND nmos W=0.0975U L=0.065U
M886_ GND n__O1__t_527_6 O1_at_527_6 GND nmos W=0.0975U L=0.065U
M887_ GND n__O1__f_527_6 O1_af_527_6 GND nmos W=0.0975U L=0.065U
M888_ GND n__O0__t_528_6 O0_at_528_6 GND nmos W=0.0975U L=0.065U
M889_ GND n__O0__f_528_6 O0_af_528_6 GND nmos W=0.0975U L=0.065U
M890_ GND n__O1__t_528_6 O1_at_528_6 GND nmos W=0.0975U L=0.065U
M891_ GND n__O1__f_528_6 O1_af_528_6 GND nmos W=0.0975U L=0.065U
M892_ GND n__O0__t_529_6 O0_at_529_6 GND nmos W=0.0975U L=0.065U
M893_ GND n__O0__f_529_6 O0_af_529_6 GND nmos W=0.0975U L=0.065U
M894_ GND n__O1__t_529_6 O1_at_529_6 GND nmos W=0.0975U L=0.065U
M895_ GND n__O1__f_529_6 O1_af_529_6 GND nmos W=0.0975U L=0.065U
M896_ GND n__O0__t_530_6 O0_at_530_6 GND nmos W=0.0975U L=0.065U
M897_ GND n__O0__f_530_6 O0_af_530_6 GND nmos W=0.0975U L=0.065U
M898_ GND n__O1__t_530_6 O1_at_530_6 GND nmos W=0.0975U L=0.065U
M899_ GND n__O1__f_530_6 O1_af_530_6 GND nmos W=0.0975U L=0.065U
M900_ GND n__O0__t_531_6 O0_at_531_6 GND nmos W=0.0975U L=0.065U
M901_ GND n__O0__f_531_6 O0_af_531_6 GND nmos W=0.0975U L=0.065U
M902_ GND n__O1__t_531_6 O1_at_531_6 GND nmos W=0.0975U L=0.065U
M903_ GND n__O1__f_531_6 O1_af_531_6 GND nmos W=0.0975U L=0.065U
M904_ GND p #fb976# GND nmos W=0.0975U L=0.13U
M905_ GND s #fb979# GND nmos W=0.0975U L=0.13U
M906_keeper GND Vdd #978 GND nmos W=0.0975U L=1.495U
M907_ GND w__0i #fb982# GND nmos W=0.0975U L=0.13U
M908_keeper GND Vdd #981 GND nmos W=0.0975U L=1.495U
M909_ GND a #fb985# GND nmos W=0.0975U L=0.13U
M910_keeper GND Vdd #984 GND nmos W=0.0975U L=2.275U
M911_ GND n__I__a #fb988# GND nmos W=0.0975U L=0.13U
M912_keeper GND Vdd #987 GND nmos W=0.0975U L=3.835U
M913_ GND inv__w__1 #fb991# GND nmos W=0.0975U L=0.13U
M914_keeper GND Vdd #990 GND nmos W=0.0975U L=3.835U
M915_ GND w__0 #fb994# GND nmos W=0.0975U L=0.13U
M916_keeper GND Vdd #993 GND nmos W=0.0975U L=1.495U
M917_ GND n__O0__t_514_6 #fb997# GND nmos W=0.0975U L=0.13U
M918_keeper GND Vdd #996 GND nmos W=0.0975U L=1.495U
M919_ GND n__O0__f_514_6 #fb1000# GND nmos W=0.0975U L=0.13U
M920_keeper GND Vdd #999 GND nmos W=0.0975U L=1.495U
M921_ GND n__O1__t_514_6 #fb1003# GND nmos W=0.0975U L=0.13U
M922_keeper GND Vdd #1002 GND nmos W=0.0975U L=1.495U
M923_ GND n__O1__f_514_6 #fb1006# GND nmos W=0.0975U L=0.13U
M924_keeper GND Vdd #1005 GND nmos W=0.0975U L=1.495U
M925_ GND n__O0__t_515_6 #fb1009# GND nmos W=0.0975U L=0.13U
M926_keeper GND Vdd #1008 GND nmos W=0.0975U L=1.495U
M927_ GND n__O0__f_515_6 #fb1012# GND nmos W=0.0975U L=0.13U
M928_keeper GND Vdd #1011 GND nmos W=0.0975U L=1.495U
M929_ GND n__O1__t_515_6 #fb1015# GND nmos W=0.0975U L=0.13U
M930_keeper GND Vdd #1014 GND nmos W=0.0975U L=1.495U
M931_ GND n__O1__f_515_6 #fb1018# GND nmos W=0.0975U L=0.13U
M932_keeper GND Vdd #1017 GND nmos W=0.0975U L=1.495U
M933_ GND n__O0__t_516_6 #fb1021# GND nmos W=0.0975U L=0.13U
M934_keeper GND Vdd #1020 GND nmos W=0.0975U L=1.495U
M935_ GND n__O0__f_516_6 #fb1024# GND nmos W=0.0975U L=0.13U
M936_keeper GND Vdd #1023 GND nmos W=0.0975U L=1.495U
M937_ GND n__O1__t_516_6 #fb1027# GND nmos W=0.0975U L=0.13U
M938_keeper GND Vdd #1026 GND nmos W=0.0975U L=1.495U
M939_ GND n__O1__f_516_6 #fb1030# GND nmos W=0.0975U L=0.13U
M940_keeper GND Vdd #1029 GND nmos W=0.0975U L=1.495U
M941_ GND n__O0__t_517_6 #fb1033# GND nmos W=0.0975U L=0.13U
M942_keeper GND Vdd #1032 GND nmos W=0.0975U L=1.495U
M943_ GND n__O0__f_517_6 #fb1036# GND nmos W=0.0975U L=0.13U
M944_keeper GND Vdd #1035 GND nmos W=0.0975U L=1.495U
M945_ GND n__O1__t_517_6 #fb1039# GND nmos W=0.0975U L=0.13U
M946_keeper GND Vdd #1038 GND nmos W=0.0975U L=1.495U
M947_ GND n__O1__f_517_6 #fb1042# GND nmos W=0.0975U L=0.13U
M948_keeper GND Vdd #1041 GND nmos W=0.0975U L=1.495U
M949_ GND n__O0__t_518_6 #fb1045# GND nmos W=0.0975U L=0.13U
M950_keeper GND Vdd #1044 GND nmos W=0.0975U L=1.495U
M951_ GND n__O0__f_518_6 #fb1048# GND nmos W=0.0975U L=0.13U
M952_keeper GND Vdd #1047 GND nmos W=0.0975U L=1.495U
M953_ GND n__O1__t_518_6 #fb1051# GND nmos W=0.0975U L=0.13U
M954_keeper GND Vdd #1050 GND nmos W=0.0975U L=1.495U
M955_ GND n__O1__f_518_6 #fb1054# GND nmos W=0.0975U L=0.13U
M956_keeper GND Vdd #1053 GND nmos W=0.0975U L=1.495U
M957_ GND n__O0__t_519_6 #fb1057# GND nmos W=0.0975U L=0.13U
M958_keeper GND Vdd #1056 GND nmos W=0.0975U L=1.495U
M959_ GND n__O0__f_519_6 #fb1060# GND nmos W=0.0975U L=0.13U
M960_keeper GND Vdd #1059 GND nmos W=0.0975U L=1.495U
M961_ GND n__O1__t_519_6 #fb1063# GND nmos W=0.0975U L=0.13U
M962_keeper GND Vdd #1062 GND nmos W=0.0975U L=1.495U
M963_ GND n__O1__f_519_6 #fb1066# GND nmos W=0.0975U L=0.13U
M964_keeper GND Vdd #1065 GND nmos W=0.0975U L=1.495U
M965_ GND n__O0__t_520_6 #fb1069# GND nmos W=0.0975U L=0.13U
M966_keeper GND Vdd #1068 GND nmos W=0.0975U L=1.495U
M967_ GND n__O0__f_520_6 #fb1072# GND nmos W=0.0975U L=0.13U
M968_keeper GND Vdd #1071 GND nmos W=0.0975U L=1.495U
M969_ GND n__O1__t_520_6 #fb1075# GND nmos W=0.0975U L=0.13U
M970_keeper GND Vdd #1074 GND nmos W=0.0975U L=1.495U
M971_ GND n__O1__f_520_6 #fb1078# GND nmos W=0.0975U L=0.13U
M972_keeper GND Vdd #1077 GND nmos W=0.0975U L=1.495U
M973_ GND n__O0__t_521_6 #fb1081# GND nmos W=0.0975U L=0.13U
M974_keeper GND Vdd #1080 GND nmos W=0.0975U L=1.495U
M975_ GND n__O0__f_521_6 #fb1084# GND nmos W=0.0975U L=0.13U
M976_keeper GND Vdd #1083 GND nmos W=0.0975U L=1.495U
M977_ GND n__O1__t_521_6 #fb1087# GND nmos W=0.0975U L=0.13U
M978_keeper GND Vdd #1086 GND nmos W=0.0975U L=1.495U
M979_ GND n__O1__f_521_6 #fb1090# GND nmos W=0.0975U L=0.13U
M980_keeper GND Vdd #1089 GND nmos W=0.0975U L=1.495U
M981_ GND n__O0__t_522_6 #fb1093# GND nmos W=0.0975U L=0.13U
M982_keeper GND Vdd #1092 GND nmos W=0.0975U L=1.495U
M983_ GND n__O0__f_522_6 #fb1096# GND nmos W=0.0975U L=0.13U
M984_keeper GND Vdd #1095 GND nmos W=0.0975U L=1.495U
M985_ GND n__O1__t_522_6 #fb1099# GND nmos W=0.0975U L=0.13U
M986_keeper GND Vdd #1098 GND nmos W=0.0975U L=1.495U
M987_ GND n__O1__f_522_6 #fb1102# GND nmos W=0.0975U L=0.13U
M988_keeper GND Vdd #1101 GND nmos W=0.0975U L=1.495U
M989_ GND n__O0__t_523_6 #fb1105# GND nmos W=0.0975U L=0.13U
M990_keeper GND Vdd #1104 GND nmos W=0.0975U L=1.495U
M991_ GND n__O0__f_523_6 #fb1108# GND nmos W=0.0975U L=0.13U
M992_keeper GND Vdd #1107 GND nmos W=0.0975U L=1.495U
M993_ GND n__O1__t_523_6 #fb1111# GND nmos W=0.0975U L=0.13U
M994_keeper GND Vdd #1110 GND nmos W=0.0975U L=1.495U
M995_ GND n__O1__f_523_6 #fb1114# GND nmos W=0.0975U L=0.13U
M996_keeper GND Vdd #1113 GND nmos W=0.0975U L=1.495U
M997_ GND n__O0__t_524_6 #fb1117# GND nmos W=0.0975U L=0.13U
M998_keeper GND Vdd #1116 GND nmos W=0.0975U L=1.495U
M999_ GND n__O0__f_524_6 #fb1120# GND nmos W=0.0975U L=0.13U
M1000_keeper GND Vdd #1119 GND nmos W=0.0975U L=1.495U
M1001_ GND n__O1__t_524_6 #fb1123# GND nmos W=0.0975U L=0.13U
M1002_keeper GND Vdd #1122 GND nmos W=0.0975U L=1.495U
M1003_ GND n__O1__f_524_6 #fb1126# GND nmos W=0.0975U L=0.13U
M1004_keeper GND Vdd #1125 GND nmos W=0.0975U L=1.495U
M1005_ GND n__O0__t_525_6 #fb1129# GND nmos W=0.0975U L=0.13U
M1006_keeper GND Vdd #1128 GND nmos W=0.0975U L=1.495U
M1007_ GND n__O0__f_525_6 #fb1132# GND nmos W=0.0975U L=0.13U
M1008_keeper GND Vdd #1131 GND nmos W=0.0975U L=1.495U
M1009_ GND n__O1__t_525_6 #fb1135# GND nmos W=0.0975U L=0.13U
M1010_keeper GND Vdd #1134 GND nmos W=0.0975U L=1.495U
M1011_ GND n__O1__f_525_6 #fb1138# GND nmos W=0.0975U L=0.13U
M1012_keeper GND Vdd #1137 GND nmos W=0.0975U L=1.495U
M1013_ GND n__O0__t_526_6 #fb1141# GND nmos W=0.0975U L=0.13U
M1014_keeper GND Vdd #1140 GND nmos W=0.0975U L=1.495U
M1015_ GND n__O0__f_526_6 #fb1144# GND nmos W=0.0975U L=0.13U
M1016_keeper GND Vdd #1143 GND nmos W=0.0975U L=1.495U
M1017_ GND n__O1__t_526_6 #fb1147# GND nmos W=0.0975U L=0.13U
M1018_keeper GND Vdd #1146 GND nmos W=0.0975U L=1.495U
M1019_ GND n__O1__f_526_6 #fb1150# GND nmos W=0.0975U L=0.13U
M1020_keeper GND Vdd #1149 GND nmos W=0.0975U L=1.495U
M1021_ GND n__O0__t_527_6 #fb1153# GND nmos W=0.0975U L=0.13U
M1022_keeper GND Vdd #1152 GND nmos W=0.0975U L=1.495U
M1023_ GND n__O0__f_527_6 #fb1156# GND nmos W=0.0975U L=0.13U
M1024_keeper GND Vdd #1155 GND nmos W=0.0975U L=1.495U
M1025_ GND n__O1__t_527_6 #fb1159# GND nmos W=0.0975U L=0.13U
M1026_keeper GND Vdd #1158 GND nmos W=0.0975U L=1.495U
M1027_ GND n__O1__f_527_6 #fb1162# GND nmos W=0.0975U L=0.13U
M1028_keeper GND Vdd #1161 GND nmos W=0.0975U L=1.495U
M1029_ GND n__O0__t_528_6 #fb1165# GND nmos W=0.0975U L=0.13U
M1030_keeper GND Vdd #1164 GND nmos W=0.0975U L=1.495U
M1031_ GND n__O0__f_528_6 #fb1168# GND nmos W=0.0975U L=0.13U
M1032_keeper GND Vdd #1167 GND nmos W=0.0975U L=1.495U
M1033_ GND n__O1__t_528_6 #fb1171# GND nmos W=0.0975U L=0.13U
M1034_keeper GND Vdd #1170 GND nmos W=0.0975U L=1.495U
M1035_ GND n__O1__f_528_6 #fb1174# GND nmos W=0.0975U L=0.13U
M1036_keeper GND Vdd #1173 GND nmos W=0.0975U L=1.495U
M1037_ GND n__O0__t_529_6 #fb1177# GND nmos W=0.0975U L=0.13U
M1038_keeper GND Vdd #1176 GND nmos W=0.0975U L=1.495U
M1039_ GND n__O0__f_529_6 #fb1180# GND nmos W=0.0975U L=0.13U
M1040_keeper GND Vdd #1179 GND nmos W=0.0975U L=1.495U
M1041_ GND n__O1__t_529_6 #fb1183# GND nmos W=0.0975U L=0.13U
M1042_keeper GND Vdd #1182 GND nmos W=0.0975U L=1.495U
M1043_ GND n__O1__f_529_6 #fb1186# GND nmos W=0.0975U L=0.13U
M1044_keeper GND Vdd #1185 GND nmos W=0.0975U L=1.495U
M1045_ GND n__O0__t_530_6 #fb1189# GND nmos W=0.0975U L=0.13U
M1046_keeper GND Vdd #1188 GND nmos W=0.0975U L=1.495U
M1047_ GND n__O0__f_530_6 #fb1192# GND nmos W=0.0975U L=0.13U
M1048_keeper GND Vdd #1191 GND nmos W=0.0975U L=1.495U
M1049_ GND n__O1__t_530_6 #fb1195# GND nmos W=0.0975U L=0.13U
M1050_keeper GND Vdd #1194 GND nmos W=0.0975U L=1.495U
M1051_ GND n__O1__f_530_6 #fb1198# GND nmos W=0.0975U L=0.13U
M1052_keeper GND Vdd #1197 GND nmos W=0.0975U L=1.495U
M1053_ GND n__O0__t_531_6 #fb1201# GND nmos W=0.0975U L=0.13U
M1054_keeper GND Vdd #1200 GND nmos W=0.0975U L=1.495U
M1055_ GND n__O0__f_531_6 #fb1204# GND nmos W=0.0975U L=0.13U
M1056_keeper GND Vdd #1203 GND nmos W=0.0975U L=1.495U
M1057_ GND n__O1__t_531_6 #fb1207# GND nmos W=0.0975U L=0.13U
M1058_keeper GND Vdd #1206 GND nmos W=0.0975U L=1.495U
M1059_ GND n__O1__f_531_6 #fb1210# GND nmos W=0.0975U L=0.13U
M1060_keeper GND Vdd #1209 GND nmos W=0.0975U L=1.495U
M1061_ GND n__O0__t_513_6 #fb1213# GND nmos W=0.0975U L=0.13U
M1062_keeper GND Vdd #1212 GND nmos W=0.0975U L=1.495U
M1063_ GND n__O0__f_513_6 #fb1216# GND nmos W=0.0975U L=0.13U
M1064_keeper GND Vdd #1215 GND nmos W=0.0975U L=1.495U
M1065_ GND n__O1__t_513_6 #fb1219# GND nmos W=0.0975U L=0.13U
M1066_keeper GND Vdd #1218 GND nmos W=0.0975U L=1.495U
M1067_ GND n__O1__f_513_6 #fb1222# GND nmos W=0.0975U L=0.13U
M1068_keeper GND Vdd #1221 GND nmos W=0.0975U L=1.495U
M1069_ GND n__O0__t_50_6 #fb1225# GND nmos W=0.0975U L=0.13U
M1070_keeper GND Vdd #1224 GND nmos W=0.0975U L=1.495U
M1071_ GND n__O0__f_50_6 #fb1228# GND nmos W=0.0975U L=0.13U
M1072_keeper GND Vdd #1227 GND nmos W=0.0975U L=0.715U
M1073_ GND n__O1__t_50_6 #fb1231# GND nmos W=0.0975U L=0.13U
M1074_keeper GND Vdd #1230 GND nmos W=0.0975U L=0.715U
M1075_ GND n__O1__f_50_6 #fb1234# GND nmos W=0.0975U L=0.13U
M1076_keeper GND Vdd #1233 GND nmos W=0.0975U L=0.715U
M1077_ GND n__O0__t_51_6 #fb1237# GND nmos W=0.0975U L=0.13U
M1078_keeper GND Vdd #1236 GND nmos W=0.0975U L=0.715U
M1079_ GND n__O0__f_51_6 #fb1240# GND nmos W=0.0975U L=0.13U
M1080_keeper GND Vdd #1239 GND nmos W=0.0975U L=0.715U
M1081_ GND n__O1__t_51_6 #fb1243# GND nmos W=0.0975U L=0.13U
M1082_keeper GND Vdd #1242 GND nmos W=0.0975U L=0.715U
M1083_ GND n__O1__f_51_6 #fb1246# GND nmos W=0.0975U L=0.13U
M1084_keeper GND Vdd #1245 GND nmos W=0.0975U L=0.715U
M1085_ GND n__O0__t_52_6 #fb1249# GND nmos W=0.0975U L=0.13U
M1086_keeper GND Vdd #1248 GND nmos W=0.0975U L=0.715U
M1087_ GND n__O0__f_52_6 #fb1252# GND nmos W=0.0975U L=0.13U
M1088_keeper GND Vdd #1251 GND nmos W=0.0975U L=0.715U
M1089_ GND n__O1__t_52_6 #fb1255# GND nmos W=0.0975U L=0.13U
M1090_keeper GND Vdd #1254 GND nmos W=0.0975U L=0.715U
M1091_ GND n__O1__f_52_6 #fb1258# GND nmos W=0.0975U L=0.13U
M1092_keeper GND Vdd #1257 GND nmos W=0.0975U L=0.715U
M1093_ GND n__O0__t_53_6 #fb1261# GND nmos W=0.0975U L=0.13U
M1094_keeper GND Vdd #1260 GND nmos W=0.0975U L=0.715U
M1095_ GND n__O0__f_53_6 #fb1264# GND nmos W=0.0975U L=0.13U
M1096_keeper GND Vdd #1263 GND nmos W=0.0975U L=0.715U
M1097_ GND n__O1__t_53_6 #fb1267# GND nmos W=0.0975U L=0.13U
M1098_keeper GND Vdd #1266 GND nmos W=0.0975U L=0.715U
M1099_ GND n__O1__f_53_6 #fb1270# GND nmos W=0.0975U L=0.13U
M1100_keeper GND Vdd #1269 GND nmos W=0.0975U L=0.715U
M1101_ GND n__O0__t_54_6 #fb1273# GND nmos W=0.0975U L=0.13U
M1102_keeper GND Vdd #1272 GND nmos W=0.0975U L=0.715U
M1103_ GND n__O0__f_54_6 #fb1276# GND nmos W=0.0975U L=0.13U
M1104_keeper GND Vdd #1275 GND nmos W=0.0975U L=0.715U
M1105_ GND n__O1__t_54_6 #fb1279# GND nmos W=0.0975U L=0.13U
M1106_keeper GND Vdd #1278 GND nmos W=0.0975U L=0.715U
M1107_ GND n__O1__f_54_6 #fb1282# GND nmos W=0.0975U L=0.13U
M1108_keeper GND Vdd #1281 GND nmos W=0.0975U L=0.715U
M1109_ GND n__O0__t_55_6 #fb1285# GND nmos W=0.0975U L=0.13U
M1110_keeper GND Vdd #1284 GND nmos W=0.0975U L=0.715U
M1111_ GND n__O0__f_55_6 #fb1288# GND nmos W=0.0975U L=0.13U
M1112_keeper GND Vdd #1287 GND nmos W=0.0975U L=0.715U
M1113_ GND n__O1__t_55_6 #fb1291# GND nmos W=0.0975U L=0.13U
M1114_keeper GND Vdd #1290 GND nmos W=0.0975U L=0.715U
M1115_ GND n__O1__f_55_6 #fb1294# GND nmos W=0.0975U L=0.13U
M1116_keeper GND Vdd #1293 GND nmos W=0.0975U L=0.715U
M1117_ GND n__O0__t_56_6 #fb1297# GND nmos W=0.0975U L=0.13U
M1118_keeper GND Vdd #1296 GND nmos W=0.0975U L=0.715U
M1119_ GND n__O0__f_56_6 #fb1300# GND nmos W=0.0975U L=0.13U
M1120_keeper GND Vdd #1299 GND nmos W=0.0975U L=0.715U
M1121_ GND n__O1__t_56_6 #fb1303# GND nmos W=0.0975U L=0.13U
M1122_keeper GND Vdd #1302 GND nmos W=0.0975U L=0.715U
M1123_ GND n__O1__f_56_6 #fb1306# GND nmos W=0.0975U L=0.13U
M1124_keeper GND Vdd #1305 GND nmos W=0.0975U L=0.715U
M1125_ GND n__O0__t_57_6 #fb1309# GND nmos W=0.0975U L=0.13U
M1126_keeper GND Vdd #1308 GND nmos W=0.0975U L=0.715U
M1127_ GND n__O0__f_57_6 #fb1312# GND nmos W=0.0975U L=0.13U
M1128_keeper GND Vdd #1311 GND nmos W=0.0975U L=0.715U
M1129_ GND n__O1__t_57_6 #fb1315# GND nmos W=0.0975U L=0.13U
M1130_keeper GND Vdd #1314 GND nmos W=0.0975U L=0.715U
M1131_ GND n__O1__f_57_6 #fb1318# GND nmos W=0.0975U L=0.13U
M1132_keeper GND Vdd #1317 GND nmos W=0.0975U L=0.715U
M1133_ GND n__O0__t_58_6 #fb1321# GND nmos W=0.0975U L=0.13U
M1134_keeper GND Vdd #1320 GND nmos W=0.0975U L=0.715U
M1135_ GND n__O0__f_58_6 #fb1324# GND nmos W=0.0975U L=0.13U
M1136_keeper GND Vdd #1323 GND nmos W=0.0975U L=0.715U
M1137_ GND n__O1__t_58_6 #fb1327# GND nmos W=0.0975U L=0.13U
M1138_keeper GND Vdd #1326 GND nmos W=0.0975U L=0.715U
M1139_ GND n__O1__f_58_6 #fb1330# GND nmos W=0.0975U L=0.13U
M1140_keeper GND Vdd #1329 GND nmos W=0.0975U L=0.715U
M1141_ GND n__O0__t_59_6 #fb1333# GND nmos W=0.0975U L=0.13U
M1142_keeper GND Vdd #1332 GND nmos W=0.0975U L=0.715U
M1143_ GND n__O0__f_59_6 #fb1336# GND nmos W=0.0975U L=0.13U
M1144_keeper GND Vdd #1335 GND nmos W=0.0975U L=0.715U
M1145_ GND n__O1__t_59_6 #fb1339# GND nmos W=0.0975U L=0.13U
M1146_keeper GND Vdd #1338 GND nmos W=0.0975U L=0.715U
M1147_ GND n__O1__f_59_6 #fb1342# GND nmos W=0.0975U L=0.13U
M1148_keeper GND Vdd #1341 GND nmos W=0.0975U L=0.715U
M1149_ GND n__O0__t_510_6 #fb1345# GND nmos W=0.0975U L=0.13U
M1150_keeper GND Vdd #1344 GND nmos W=0.0975U L=0.715U
M1151_ GND n__O0__f_510_6 #fb1348# GND nmos W=0.0975U L=0.13U
M1152_keeper GND Vdd #1347 GND nmos W=0.0975U L=0.715U
M1153_ GND n__O1__t_510_6 #fb1351# GND nmos W=0.0975U L=0.13U
M1154_keeper GND Vdd #1350 GND nmos W=0.0975U L=0.715U
M1155_ GND n__O1__f_510_6 #fb1354# GND nmos W=0.0975U L=0.13U
M1156_keeper GND Vdd #1353 GND nmos W=0.0975U L=0.715U
M1157_ GND n__O0__t_511_6 #fb1357# GND nmos W=0.0975U L=0.13U
M1158_keeper GND Vdd #1356 GND nmos W=0.0975U L=0.715U
M1159_ GND n__O0__f_511_6 #fb1360# GND nmos W=0.0975U L=0.13U
M1160_keeper GND Vdd #1359 GND nmos W=0.0975U L=0.715U
M1161_ GND n__O1__t_511_6 #fb1363# GND nmos W=0.0975U L=0.13U
M1162_keeper GND Vdd #1362 GND nmos W=0.0975U L=0.715U
M1163_ GND n__O1__f_511_6 #fb1366# GND nmos W=0.0975U L=0.13U
M1164_keeper GND Vdd #1365 GND nmos W=0.0975U L=0.715U
M1165_ GND n__O0__t_512_6 #fb1369# GND nmos W=0.0975U L=0.13U
M1166_keeper GND Vdd #1368 GND nmos W=0.0975U L=0.715U
M1167_ GND n__O0__f_512_6 #fb1372# GND nmos W=0.0975U L=0.13U
M1168_keeper GND Vdd #1371 GND nmos W=0.0975U L=0.715U
M1169_ GND n__O1__t_512_6 #fb1375# GND nmos W=0.0975U L=0.13U
M1170_keeper GND Vdd #1374 GND nmos W=0.0975U L=0.715U
M1171_ GND n__O1__f_512_6 #fb1378# GND nmos W=0.0975U L=0.13U
M1172_keeper GND Vdd #1377 GND nmos W=0.0975U L=0.715U
M1173_keeper GND Vdd #1380 GND nmos W=0.0975U L=0.715U
M1174_ #3 inv__s p Vdd pmos W=0.1625U L=0.065U
M1175_ #7 s p GND nmos W=0.0975U L=0.065U
M1176_keeper #977 #fb976# p Vdd pmos W=0.0975U L=0.065U
M1177_keeper #978 #fb976# p GND nmos W=0.0975U L=0.065U
M1178_ #41 inv__a s Vdd pmos W=0.1625U L=0.065U
M1179_ #42 a s GND nmos W=0.0975U L=0.065U
M1180_keeper #980 #fb979# s Vdd pmos W=0.0975U L=0.065U
M1181_keeper #981 #fb979# s GND nmos W=0.0975U L=0.065U
M1182_ #12 inv__p w__0i Vdd pmos W=0.1625U L=0.065U
M1183_ #14 p w__0i Vdd pmos W=0.1625U L=0.065U
M1184_ #16 O0_aa w__0i GND nmos W=0.0975U L=0.065U
M1185_ #16 O1_aa w__0i GND nmos W=0.0975U L=0.065U
M1186_keeper #983 #fb982# w__0i Vdd pmos W=0.0975U L=0.065U
M1187_keeper #984 #fb982# w__0i GND nmos W=0.0975U L=0.065U
M1188_ #11 inv__I__t31 #12 Vdd pmos W=0.1625U L=0.065U
M1189_ #11 inv__I__f31 #14 Vdd pmos W=0.1625U L=0.065U
M1190_ #25 inv__w__0i a Vdd pmos W=0.1625U L=0.065U
M1191_ #27 inv__w__0 a Vdd pmos W=0.1625U L=0.065U
M1192_ #27 inv__w__1 a Vdd pmos W=0.1625U L=0.065U
M1193_ #32 inv__s a GND nmos W=0.0975U L=0.065U
M1194_ #30 inv__w__0i a GND nmos W=0.0975U L=0.065U
M1195_keeper #986 #fb985# a Vdd pmos W=0.0975U L=0.065U
M1196_keeper #987 #fb985# a GND nmos W=0.0975U L=0.065U
M1197_ #24 O1_aa #21 Vdd pmos W=0.1625U L=0.065U
M1198_ #21 inv__s #25 Vdd pmos W=0.1625U L=0.065U
M1199_ #21 s #27 Vdd pmos W=0.1625U L=0.065U
M1200_ #22 O0_aa #24 Vdd pmos W=0.1625U L=0.065U
M1201_ #45 w__1 n__I__a GND nmos W=0.0975U L=0.065U
M1202_ #45 w__0 n__I__a GND nmos W=0.0975U L=0.065U
M1203_ #43 s n__I__a GND nmos W=0.0975U L=0.065U
M1204_ #50 s n__I__a Vdd pmos W=0.1625U L=0.065U
M1205_ #47 w__0i n__I__a Vdd pmos W=0.1625U L=0.065U
M1206_keeper #989 #fb988# n__I__a Vdd pmos W=0.0975U L=0.065U
M1207_keeper #990 #fb988# n__I__a GND nmos W=0.0975U L=0.065U
M1208_ #37 I_at_50_6 inv__w__1 GND nmos W=0.0975U L=0.065U
M1209_ #39 inv__a inv__w__1 Vdd pmos W=0.1625U L=0.065U
M1210_keeper #992 #fb991# inv__w__1 Vdd pmos W=0.0975U L=0.065U
M1211_keeper #993 #fb991# inv__w__1 GND nmos W=0.0975U L=0.065U
M1212_ #31 inv__w__0 #30 GND nmos W=0.0975U L=0.065U
M1213_ #30 w__0i #32 GND nmos W=0.0975U L=0.065U
M1214_ #34 inv__I__f0 w__0 Vdd pmos W=0.1625U L=0.065U
M1215_ #36 a w__0 GND nmos W=0.0975U L=0.065U
M1216_keeper #995 #fb994# w__0 Vdd pmos W=0.0975U L=0.065U
M1217_keeper #996 #fb994# w__0 GND nmos W=0.0975U L=0.065U
M1218_ #43 inv__s #44 GND nmos W=0.0975U L=0.065U
M1219_ #44 inv__w__0i #45 GND nmos W=0.0975U L=0.065U
M1220_ #49 w__1 #47 Vdd pmos W=0.1625U L=0.065U
M1221_ #47 inv__w__0i #50 Vdd pmos W=0.1625U L=0.065U
M1222_ #48 w__0 #49 Vdd pmos W=0.1625U L=0.065U
M1223_ #53 inv__s n__O0__t_514_6 GND nmos W=0.0975U L=0.065U
M1224_ #55 w__0i n__O0__t_514_6 GND nmos W=0.0975U L=0.065U
M1225_ #58 s n__O0__t_514_6 Vdd pmos W=0.1625U L=0.065U
M1226_ #59 inv__s n__O0__t_514_6 Vdd pmos W=0.1625U L=0.065U
M1227_keeper #998 #fb997# n__O0__t_514_6 Vdd pmos W=0.0975U L=0.065U
M1228_keeper #999 #fb997# n__O0__t_514_6 GND nmos W=0.0975U L=0.065U
M1229_ #52 I_at_514_6 #53 GND nmos W=0.0975U L=0.065U
M1230_ #52 I_at_513_6 #56 GND nmos W=0.0975U L=0.065U
M1231_ #56 s #55 GND nmos W=0.0975U L=0.065U
M1232_ #62 inv__s n__O0__f_514_6 GND nmos W=0.0975U L=0.065U
M1233_ #64 w__0i n__O0__f_514_6 GND nmos W=0.0975U L=0.065U
M1234_ #67 s n__O0__f_514_6 Vdd pmos W=0.1625U L=0.065U
M1235_ #68 inv__s n__O0__f_514_6 Vdd pmos W=0.1625U L=0.065U
M1236_keeper #1001 #fb1000# n__O0__f_514_6 Vdd pmos W=0.0975U L=0.065U
M1237_keeper #1002 #fb1000# n__O0__f_514_6 GND nmos W=0.0975U L=0.065U
M1238_ #61 I_af_514_6 #62 GND nmos W=0.0975U L=0.065U
M1239_ #61 I_af_513_6 #65 GND nmos W=0.0975U L=0.065U
M1240_ #65 s #64 GND nmos W=0.0975U L=0.065U
M1241_ #71 inv__s n__O1__t_514_6 GND nmos W=0.0975U L=0.065U
M1242_ #72 w__0i n__O1__t_514_6 GND nmos W=0.0975U L=0.065U
M1243_ #74 s n__O1__t_514_6 Vdd pmos W=0.1625U L=0.065U
M1244_ #75 inv__s n__O1__t_514_6 Vdd pmos W=0.1625U L=0.065U
M1245_keeper #1004 #fb1003# n__O1__t_514_6 Vdd pmos W=0.0975U L=0.065U
M1246_keeper #1005 #fb1003# n__O1__t_514_6 GND nmos W=0.0975U L=0.065U
M1247_ #70 I_at_514_6 #71 GND nmos W=0.0975U L=0.065U
M1248_ #70 I_at_513_6 #73 GND nmos W=0.0975U L=0.065U
M1249_ #73 s #72 GND nmos W=0.0975U L=0.065U
M1250_ #78 inv__s n__O1__f_514_6 GND nmos W=0.0975U L=0.065U
M1251_ #79 w__0i n__O1__f_514_6 GND nmos W=0.0975U L=0.065U
M1252_ #81 s n__O1__f_514_6 Vdd pmos W=0.1625U L=0.065U
M1253_ #82 inv__s n__O1__f_514_6 Vdd pmos W=0.1625U L=0.065U
M1254_keeper #1007 #fb1006# n__O1__f_514_6 Vdd pmos W=0.0975U L=0.065U
M1255_keeper #1008 #fb1006# n__O1__f_514_6 GND nmos W=0.0975U L=0.065U
M1256_ #77 I_af_514_6 #78 GND nmos W=0.0975U L=0.065U
M1257_ #77 I_af_513_6 #80 GND nmos W=0.0975U L=0.065U
M1258_ #80 s #79 GND nmos W=0.0975U L=0.065U
M1259_ #85 inv__s n__O0__t_515_6 GND nmos W=0.0975U L=0.065U
M1260_ #87 w__0i n__O0__t_515_6 GND nmos W=0.0975U L=0.065U
M1261_ #89 s n__O0__t_515_6 Vdd pmos W=0.1625U L=0.065U
M1262_ #90 inv__s n__O0__t_515_6 Vdd pmos W=0.1625U L=0.065U
M1263_keeper #1010 #fb1009# n__O0__t_515_6 Vdd pmos W=0.0975U L=0.065U
M1264_keeper #1011 #fb1009# n__O0__t_515_6 GND nmos W=0.0975U L=0.065U
M1265_ #84 I_at_515_6 #85 GND nmos W=0.0975U L=0.065U
M1266_ #84 I_at_514_6 #88 GND nmos W=0.0975U L=0.065U
M1267_ #88 s #87 GND nmos W=0.0975U L=0.065U
M1268_ #93 inv__s n__O0__f_515_6 GND nmos W=0.0975U L=0.065U
M1269_ #95 w__0i n__O0__f_515_6 GND nmos W=0.0975U L=0.065U
M1270_ #97 s n__O0__f_515_6 Vdd pmos W=0.1625U L=0.065U
M1271_ #98 inv__s n__O0__f_515_6 Vdd pmos W=0.1625U L=0.065U
M1272_keeper #1013 #fb1012# n__O0__f_515_6 Vdd pmos W=0.0975U L=0.065U
M1273_keeper #1014 #fb1012# n__O0__f_515_6 GND nmos W=0.0975U L=0.065U
M1274_ #92 I_af_515_6 #93 GND nmos W=0.0975U L=0.065U
M1275_ #92 I_af_514_6 #96 GND nmos W=0.0975U L=0.065U
M1276_ #96 s #95 GND nmos W=0.0975U L=0.065U
M1277_ #101 inv__s n__O1__t_515_6 GND nmos W=0.0975U L=0.065U
M1278_ #102 w__0i n__O1__t_515_6 GND nmos W=0.0975U L=0.065U
M1279_ #104 s n__O1__t_515_6 Vdd pmos W=0.1625U L=0.065U
M1280_ #105 inv__s n__O1__t_515_6 Vdd pmos W=0.1625U L=0.065U
M1281_keeper #1016 #fb1015# n__O1__t_515_6 Vdd pmos W=0.0975U L=0.065U
M1282_keeper #1017 #fb1015# n__O1__t_515_6 GND nmos W=0.0975U L=0.065U
M1283_ #100 I_at_515_6 #101 GND nmos W=0.0975U L=0.065U
M1284_ #100 I_at_514_6 #103 GND nmos W=0.0975U L=0.065U
M1285_ #103 s #102 GND nmos W=0.0975U L=0.065U
M1286_ #108 inv__s n__O1__f_515_6 GND nmos W=0.0975U L=0.065U
M1287_ #109 w__0i n__O1__f_515_6 GND nmos W=0.0975U L=0.065U
M1288_ #111 s n__O1__f_515_6 Vdd pmos W=0.1625U L=0.065U
M1289_ #112 inv__s n__O1__f_515_6 Vdd pmos W=0.1625U L=0.065U
M1290_keeper #1019 #fb1018# n__O1__f_515_6 Vdd pmos W=0.0975U L=0.065U
M1291_keeper #1020 #fb1018# n__O1__f_515_6 GND nmos W=0.0975U L=0.065U
M1292_ #107 I_af_515_6 #108 GND nmos W=0.0975U L=0.065U
M1293_ #107 I_af_514_6 #110 GND nmos W=0.0975U L=0.065U
M1294_ #110 s #109 GND nmos W=0.0975U L=0.065U
M1295_ #115 inv__s n__O0__t_516_6 GND nmos W=0.0975U L=0.065U
M1296_ #117 w__0i n__O0__t_516_6 GND nmos W=0.0975U L=0.065U
M1297_ #119 s n__O0__t_516_6 Vdd pmos W=0.1625U L=0.065U
M1298_ #120 inv__s n__O0__t_516_6 Vdd pmos W=0.1625U L=0.065U
M1299_keeper #1022 #fb1021# n__O0__t_516_6 Vdd pmos W=0.0975U L=0.065U
M1300_keeper #1023 #fb1021# n__O0__t_516_6 GND nmos W=0.0975U L=0.065U
M1301_ #114 I_at_516_6 #115 GND nmos W=0.0975U L=0.065U
M1302_ #114 I_at_515_6 #118 GND nmos W=0.0975U L=0.065U
M1303_ #118 s #117 GND nmos W=0.0975U L=0.065U
M1304_ #123 inv__s n__O0__f_516_6 GND nmos W=0.0975U L=0.065U
M1305_ #125 w__0i n__O0__f_516_6 GND nmos W=0.0975U L=0.065U
M1306_ #127 s n__O0__f_516_6 Vdd pmos W=0.1625U L=0.065U
M1307_ #128 inv__s n__O0__f_516_6 Vdd pmos W=0.1625U L=0.065U
M1308_keeper #1025 #fb1024# n__O0__f_516_6 Vdd pmos W=0.0975U L=0.065U
M1309_keeper #1026 #fb1024# n__O0__f_516_6 GND nmos W=0.0975U L=0.065U
M1310_ #122 I_af_516_6 #123 GND nmos W=0.0975U L=0.065U
M1311_ #122 I_af_515_6 #126 GND nmos W=0.0975U L=0.065U
M1312_ #126 s #125 GND nmos W=0.0975U L=0.065U
M1313_ #131 inv__s n__O1__t_516_6 GND nmos W=0.0975U L=0.065U
M1314_ #132 w__0i n__O1__t_516_6 GND nmos W=0.0975U L=0.065U
M1315_ #134 s n__O1__t_516_6 Vdd pmos W=0.1625U L=0.065U
M1316_ #135 inv__s n__O1__t_516_6 Vdd pmos W=0.1625U L=0.065U
M1317_keeper #1028 #fb1027# n__O1__t_516_6 Vdd pmos W=0.0975U L=0.065U
M1318_keeper #1029 #fb1027# n__O1__t_516_6 GND nmos W=0.0975U L=0.065U
M1319_ #130 I_at_516_6 #131 GND nmos W=0.0975U L=0.065U
M1320_ #130 I_at_515_6 #133 GND nmos W=0.0975U L=0.065U
M1321_ #133 s #132 GND nmos W=0.0975U L=0.065U
M1322_ #138 inv__s n__O1__f_516_6 GND nmos W=0.0975U L=0.065U
M1323_ #139 w__0i n__O1__f_516_6 GND nmos W=0.0975U L=0.065U
M1324_ #141 s n__O1__f_516_6 Vdd pmos W=0.1625U L=0.065U
M1325_ #142 inv__s n__O1__f_516_6 Vdd pmos W=0.1625U L=0.065U
M1326_keeper #1031 #fb1030# n__O1__f_516_6 Vdd pmos W=0.0975U L=0.065U
M1327_keeper #1032 #fb1030# n__O1__f_516_6 GND nmos W=0.0975U L=0.065U
M1328_ #137 I_af_516_6 #138 GND nmos W=0.0975U L=0.065U
M1329_ #137 I_af_515_6 #140 GND nmos W=0.0975U L=0.065U
M1330_ #140 s #139 GND nmos W=0.0975U L=0.065U
M1331_ #145 inv__s n__O0__t_517_6 GND nmos W=0.0975U L=0.065U
M1332_ #147 w__0i n__O0__t_517_6 GND nmos W=0.0975U L=0.065U
M1333_ #149 s n__O0__t_517_6 Vdd pmos W=0.1625U L=0.065U
M1334_ #150 inv__s n__O0__t_517_6 Vdd pmos W=0.1625U L=0.065U
M1335_keeper #1034 #fb1033# n__O0__t_517_6 Vdd pmos W=0.0975U L=0.065U
M1336_keeper #1035 #fb1033# n__O0__t_517_6 GND nmos W=0.0975U L=0.065U
M1337_ #144 I_at_517_6 #145 GND nmos W=0.0975U L=0.065U
M1338_ #144 I_at_516_6 #148 GND nmos W=0.0975U L=0.065U
M1339_ #148 s #147 GND nmos W=0.0975U L=0.065U
M1340_ #153 inv__s n__O0__f_517_6 GND nmos W=0.0975U L=0.065U
M1341_ #155 w__0i n__O0__f_517_6 GND nmos W=0.0975U L=0.065U
M1342_ #157 s n__O0__f_517_6 Vdd pmos W=0.1625U L=0.065U
M1343_ #158 inv__s n__O0__f_517_6 Vdd pmos W=0.1625U L=0.065U
M1344_keeper #1037 #fb1036# n__O0__f_517_6 Vdd pmos W=0.0975U L=0.065U
M1345_keeper #1038 #fb1036# n__O0__f_517_6 GND nmos W=0.0975U L=0.065U
M1346_ #152 I_af_517_6 #153 GND nmos W=0.0975U L=0.065U
M1347_ #152 I_af_516_6 #156 GND nmos W=0.0975U L=0.065U
M1348_ #156 s #155 GND nmos W=0.0975U L=0.065U
M1349_ #161 inv__s n__O1__t_517_6 GND nmos W=0.0975U L=0.065U
M1350_ #162 w__0i n__O1__t_517_6 GND nmos W=0.0975U L=0.065U
M1351_ #164 s n__O1__t_517_6 Vdd pmos W=0.1625U L=0.065U
M1352_ #165 inv__s n__O1__t_517_6 Vdd pmos W=0.1625U L=0.065U
M1353_keeper #1040 #fb1039# n__O1__t_517_6 Vdd pmos W=0.0975U L=0.065U
M1354_keeper #1041 #fb1039# n__O1__t_517_6 GND nmos W=0.0975U L=0.065U
M1355_ #160 I_at_517_6 #161 GND nmos W=0.0975U L=0.065U
M1356_ #160 I_at_516_6 #163 GND nmos W=0.0975U L=0.065U
M1357_ #163 s #162 GND nmos W=0.0975U L=0.065U
M1358_ #168 inv__s n__O1__f_517_6 GND nmos W=0.0975U L=0.065U
M1359_ #169 w__0i n__O1__f_517_6 GND nmos W=0.0975U L=0.065U
M1360_ #171 s n__O1__f_517_6 Vdd pmos W=0.1625U L=0.065U
M1361_ #172 inv__s n__O1__f_517_6 Vdd pmos W=0.1625U L=0.065U
M1362_keeper #1043 #fb1042# n__O1__f_517_6 Vdd pmos W=0.0975U L=0.065U
M1363_keeper #1044 #fb1042# n__O1__f_517_6 GND nmos W=0.0975U L=0.065U
M1364_ #167 I_af_517_6 #168 GND nmos W=0.0975U L=0.065U
M1365_ #167 I_af_516_6 #170 GND nmos W=0.0975U L=0.065U
M1366_ #170 s #169 GND nmos W=0.0975U L=0.065U
M1367_ #175 inv__s n__O0__t_518_6 GND nmos W=0.0975U L=0.065U
M1368_ #177 w__0i n__O0__t_518_6 GND nmos W=0.0975U L=0.065U
M1369_ #179 s n__O0__t_518_6 Vdd pmos W=0.1625U L=0.065U
M1370_ #180 inv__s n__O0__t_518_6 Vdd pmos W=0.1625U L=0.065U
M1371_keeper #1046 #fb1045# n__O0__t_518_6 Vdd pmos W=0.0975U L=0.065U
M1372_keeper #1047 #fb1045# n__O0__t_518_6 GND nmos W=0.0975U L=0.065U
M1373_ #174 I_at_518_6 #175 GND nmos W=0.0975U L=0.065U
M1374_ #174 I_at_517_6 #178 GND nmos W=0.0975U L=0.065U
M1375_ #178 s #177 GND nmos W=0.0975U L=0.065U
M1376_ #183 inv__s n__O0__f_518_6 GND nmos W=0.0975U L=0.065U
M1377_ #185 w__0i n__O0__f_518_6 GND nmos W=0.0975U L=0.065U
M1378_ #187 s n__O0__f_518_6 Vdd pmos W=0.1625U L=0.065U
M1379_ #188 inv__s n__O0__f_518_6 Vdd pmos W=0.1625U L=0.065U
M1380_keeper #1049 #fb1048# n__O0__f_518_6 Vdd pmos W=0.0975U L=0.065U
M1381_keeper #1050 #fb1048# n__O0__f_518_6 GND nmos W=0.0975U L=0.065U
M1382_ #182 I_af_518_6 #183 GND nmos W=0.0975U L=0.065U
M1383_ #182 I_af_517_6 #186 GND nmos W=0.0975U L=0.065U
M1384_ #186 s #185 GND nmos W=0.0975U L=0.065U
M1385_ #191 inv__s n__O1__t_518_6 GND nmos W=0.0975U L=0.065U
M1386_ #192 w__0i n__O1__t_518_6 GND nmos W=0.0975U L=0.065U
M1387_ #194 s n__O1__t_518_6 Vdd pmos W=0.1625U L=0.065U
M1388_ #195 inv__s n__O1__t_518_6 Vdd pmos W=0.1625U L=0.065U
M1389_keeper #1052 #fb1051# n__O1__t_518_6 Vdd pmos W=0.0975U L=0.065U
M1390_keeper #1053 #fb1051# n__O1__t_518_6 GND nmos W=0.0975U L=0.065U
M1391_ #190 I_at_518_6 #191 GND nmos W=0.0975U L=0.065U
M1392_ #190 I_at_517_6 #193 GND nmos W=0.0975U L=0.065U
M1393_ #193 s #192 GND nmos W=0.0975U L=0.065U
M1394_ #198 inv__s n__O1__f_518_6 GND nmos W=0.0975U L=0.065U
M1395_ #199 w__0i n__O1__f_518_6 GND nmos W=0.0975U L=0.065U
M1396_ #201 s n__O1__f_518_6 Vdd pmos W=0.1625U L=0.065U
M1397_ #202 inv__s n__O1__f_518_6 Vdd pmos W=0.1625U L=0.065U
M1398_keeper #1055 #fb1054# n__O1__f_518_6 Vdd pmos W=0.0975U L=0.065U
M1399_keeper #1056 #fb1054# n__O1__f_518_6 GND nmos W=0.0975U L=0.065U
M1400_ #197 I_af_518_6 #198 GND nmos W=0.0975U L=0.065U
M1401_ #197 I_af_517_6 #200 GND nmos W=0.0975U L=0.065U
M1402_ #200 s #199 GND nmos W=0.0975U L=0.065U
M1403_ #205 inv__s n__O0__t_519_6 GND nmos W=0.0975U L=0.065U
M1404_ #207 w__0i n__O0__t_519_6 GND nmos W=0.0975U L=0.065U
M1405_ #209 s n__O0__t_519_6 Vdd pmos W=0.1625U L=0.065U
M1406_ #210 inv__s n__O0__t_519_6 Vdd pmos W=0.1625U L=0.065U
M1407_keeper #1058 #fb1057# n__O0__t_519_6 Vdd pmos W=0.0975U L=0.065U
M1408_keeper #1059 #fb1057# n__O0__t_519_6 GND nmos W=0.0975U L=0.065U
M1409_ #204 I_at_519_6 #205 GND nmos W=0.0975U L=0.065U
M1410_ #204 I_at_518_6 #208 GND nmos W=0.0975U L=0.065U
M1411_ #208 s #207 GND nmos W=0.0975U L=0.065U
M1412_ #213 inv__s n__O0__f_519_6 GND nmos W=0.0975U L=0.065U
M1413_ #215 w__0i n__O0__f_519_6 GND nmos W=0.0975U L=0.065U
M1414_ #217 s n__O0__f_519_6 Vdd pmos W=0.1625U L=0.065U
M1415_ #218 inv__s n__O0__f_519_6 Vdd pmos W=0.1625U L=0.065U
M1416_keeper #1061 #fb1060# n__O0__f_519_6 Vdd pmos W=0.0975U L=0.065U
M1417_keeper #1062 #fb1060# n__O0__f_519_6 GND nmos W=0.0975U L=0.065U
M1418_ #212 I_af_519_6 #213 GND nmos W=0.0975U L=0.065U
M1419_ #212 I_af_518_6 #216 GND nmos W=0.0975U L=0.065U
M1420_ #216 s #215 GND nmos W=0.0975U L=0.065U
M1421_ #221 inv__s n__O1__t_519_6 GND nmos W=0.0975U L=0.065U
M1422_ #222 w__0i n__O1__t_519_6 GND nmos W=0.0975U L=0.065U
M1423_ #224 s n__O1__t_519_6 Vdd pmos W=0.1625U L=0.065U
M1424_ #225 inv__s n__O1__t_519_6 Vdd pmos W=0.1625U L=0.065U
M1425_keeper #1064 #fb1063# n__O1__t_519_6 Vdd pmos W=0.0975U L=0.065U
M1426_keeper #1065 #fb1063# n__O1__t_519_6 GND nmos W=0.0975U L=0.065U
M1427_ #220 I_at_519_6 #221 GND nmos W=0.0975U L=0.065U
M1428_ #220 I_at_518_6 #223 GND nmos W=0.0975U L=0.065U
M1429_ #223 s #222 GND nmos W=0.0975U L=0.065U
M1430_ #228 inv__s n__O1__f_519_6 GND nmos W=0.0975U L=0.065U
M1431_ #229 w__0i n__O1__f_519_6 GND nmos W=0.0975U L=0.065U
M1432_ #231 s n__O1__f_519_6 Vdd pmos W=0.1625U L=0.065U
M1433_ #232 inv__s n__O1__f_519_6 Vdd pmos W=0.1625U L=0.065U
M1434_keeper #1067 #fb1066# n__O1__f_519_6 Vdd pmos W=0.0975U L=0.065U
M1435_keeper #1068 #fb1066# n__O1__f_519_6 GND nmos W=0.0975U L=0.065U
M1436_ #227 I_af_519_6 #228 GND nmos W=0.0975U L=0.065U
M1437_ #227 I_af_518_6 #230 GND nmos W=0.0975U L=0.065U
M1438_ #230 s #229 GND nmos W=0.0975U L=0.065U
M1439_ #235 inv__s n__O0__t_520_6 GND nmos W=0.0975U L=0.065U
M1440_ #237 w__0i n__O0__t_520_6 GND nmos W=0.0975U L=0.065U
M1441_ #239 s n__O0__t_520_6 Vdd pmos W=0.1625U L=0.065U
M1442_ #240 inv__s n__O0__t_520_6 Vdd pmos W=0.1625U L=0.065U
M1443_keeper #1070 #fb1069# n__O0__t_520_6 Vdd pmos W=0.0975U L=0.065U
M1444_keeper #1071 #fb1069# n__O0__t_520_6 GND nmos W=0.0975U L=0.065U
M1445_ #234 I_at_520_6 #235 GND nmos W=0.0975U L=0.065U
M1446_ #234 I_at_519_6 #238 GND nmos W=0.0975U L=0.065U
M1447_ #238 s #237 GND nmos W=0.0975U L=0.065U
M1448_ #243 inv__s n__O0__f_520_6 GND nmos W=0.0975U L=0.065U
M1449_ #245 w__0i n__O0__f_520_6 GND nmos W=0.0975U L=0.065U
M1450_ #247 s n__O0__f_520_6 Vdd pmos W=0.1625U L=0.065U
M1451_ #248 inv__s n__O0__f_520_6 Vdd pmos W=0.1625U L=0.065U
M1452_keeper #1073 #fb1072# n__O0__f_520_6 Vdd pmos W=0.0975U L=0.065U
M1453_keeper #1074 #fb1072# n__O0__f_520_6 GND nmos W=0.0975U L=0.065U
M1454_ #242 I_af_520_6 #243 GND nmos W=0.0975U L=0.065U
M1455_ #242 I_af_519_6 #246 GND nmos W=0.0975U L=0.065U
M1456_ #246 s #245 GND nmos W=0.0975U L=0.065U
M1457_ #251 inv__s n__O1__t_520_6 GND nmos W=0.0975U L=0.065U
M1458_ #252 w__0i n__O1__t_520_6 GND nmos W=0.0975U L=0.065U
M1459_ #254 s n__O1__t_520_6 Vdd pmos W=0.1625U L=0.065U
M1460_ #255 inv__s n__O1__t_520_6 Vdd pmos W=0.1625U L=0.065U
M1461_keeper #1076 #fb1075# n__O1__t_520_6 Vdd pmos W=0.0975U L=0.065U
M1462_keeper #1077 #fb1075# n__O1__t_520_6 GND nmos W=0.0975U L=0.065U
M1463_ #250 I_at_520_6 #251 GND nmos W=0.0975U L=0.065U
M1464_ #250 I_at_519_6 #253 GND nmos W=0.0975U L=0.065U
M1465_ #253 s #252 GND nmos W=0.0975U L=0.065U
M1466_ #258 inv__s n__O1__f_520_6 GND nmos W=0.0975U L=0.065U
M1467_ #259 w__0i n__O1__f_520_6 GND nmos W=0.0975U L=0.065U
M1468_ #261 s n__O1__f_520_6 Vdd pmos W=0.1625U L=0.065U
M1469_ #262 inv__s n__O1__f_520_6 Vdd pmos W=0.1625U L=0.065U
M1470_keeper #1079 #fb1078# n__O1__f_520_6 Vdd pmos W=0.0975U L=0.065U
M1471_keeper #1080 #fb1078# n__O1__f_520_6 GND nmos W=0.0975U L=0.065U
M1472_ #257 I_af_520_6 #258 GND nmos W=0.0975U L=0.065U
M1473_ #257 I_af_519_6 #260 GND nmos W=0.0975U L=0.065U
M1474_ #260 s #259 GND nmos W=0.0975U L=0.065U
M1475_ #265 inv__s n__O0__t_521_6 GND nmos W=0.0975U L=0.065U
M1476_ #267 w__0i n__O0__t_521_6 GND nmos W=0.0975U L=0.065U
M1477_ #269 s n__O0__t_521_6 Vdd pmos W=0.1625U L=0.065U
M1478_ #270 inv__s n__O0__t_521_6 Vdd pmos W=0.1625U L=0.065U
M1479_keeper #1082 #fb1081# n__O0__t_521_6 Vdd pmos W=0.0975U L=0.065U
M1480_keeper #1083 #fb1081# n__O0__t_521_6 GND nmos W=0.0975U L=0.065U
M1481_ #264 I_at_521_6 #265 GND nmos W=0.0975U L=0.065U
M1482_ #264 I_at_520_6 #268 GND nmos W=0.0975U L=0.065U
M1483_ #268 s #267 GND nmos W=0.0975U L=0.065U
M1484_ #273 inv__s n__O0__f_521_6 GND nmos W=0.0975U L=0.065U
M1485_ #275 w__0i n__O0__f_521_6 GND nmos W=0.0975U L=0.065U
M1486_ #277 s n__O0__f_521_6 Vdd pmos W=0.1625U L=0.065U
M1487_ #278 inv__s n__O0__f_521_6 Vdd pmos W=0.1625U L=0.065U
M1488_keeper #1085 #fb1084# n__O0__f_521_6 Vdd pmos W=0.0975U L=0.065U
M1489_keeper #1086 #fb1084# n__O0__f_521_6 GND nmos W=0.0975U L=0.065U
M1490_ #272 I_af_521_6 #273 GND nmos W=0.0975U L=0.065U
M1491_ #272 I_af_520_6 #276 GND nmos W=0.0975U L=0.065U
M1492_ #276 s #275 GND nmos W=0.0975U L=0.065U
M1493_ #281 inv__s n__O1__t_521_6 GND nmos W=0.0975U L=0.065U
M1494_ #282 w__0i n__O1__t_521_6 GND nmos W=0.0975U L=0.065U
M1495_ #284 s n__O1__t_521_6 Vdd pmos W=0.1625U L=0.065U
M1496_ #285 inv__s n__O1__t_521_6 Vdd pmos W=0.1625U L=0.065U
M1497_keeper #1088 #fb1087# n__O1__t_521_6 Vdd pmos W=0.0975U L=0.065U
M1498_keeper #1089 #fb1087# n__O1__t_521_6 GND nmos W=0.0975U L=0.065U
M1499_ #280 I_at_521_6 #281 GND nmos W=0.0975U L=0.065U
M1500_ #280 I_at_520_6 #283 GND nmos W=0.0975U L=0.065U
M1501_ #283 s #282 GND nmos W=0.0975U L=0.065U
M1502_ #288 inv__s n__O1__f_521_6 GND nmos W=0.0975U L=0.065U
M1503_ #289 w__0i n__O1__f_521_6 GND nmos W=0.0975U L=0.065U
M1504_ #291 s n__O1__f_521_6 Vdd pmos W=0.1625U L=0.065U
M1505_ #292 inv__s n__O1__f_521_6 Vdd pmos W=0.1625U L=0.065U
M1506_keeper #1091 #fb1090# n__O1__f_521_6 Vdd pmos W=0.0975U L=0.065U
M1507_keeper #1092 #fb1090# n__O1__f_521_6 GND nmos W=0.0975U L=0.065U
M1508_ #287 I_af_521_6 #288 GND nmos W=0.0975U L=0.065U
M1509_ #287 I_af_520_6 #290 GND nmos W=0.0975U L=0.065U
M1510_ #290 s #289 GND nmos W=0.0975U L=0.065U
M1511_ #295 inv__s n__O0__t_522_6 GND nmos W=0.0975U L=0.065U
M1512_ #297 w__0i n__O0__t_522_6 GND nmos W=0.0975U L=0.065U
M1513_ #299 s n__O0__t_522_6 Vdd pmos W=0.1625U L=0.065U
M1514_ #300 inv__s n__O0__t_522_6 Vdd pmos W=0.1625U L=0.065U
M1515_keeper #1094 #fb1093# n__O0__t_522_6 Vdd pmos W=0.0975U L=0.065U
M1516_keeper #1095 #fb1093# n__O0__t_522_6 GND nmos W=0.0975U L=0.065U
M1517_ #294 I_at_522_6 #295 GND nmos W=0.0975U L=0.065U
M1518_ #294 I_at_521_6 #298 GND nmos W=0.0975U L=0.065U
M1519_ #298 s #297 GND nmos W=0.0975U L=0.065U
M1520_ #303 inv__s n__O0__f_522_6 GND nmos W=0.0975U L=0.065U
M1521_ #305 w__0i n__O0__f_522_6 GND nmos W=0.0975U L=0.065U
M1522_ #307 s n__O0__f_522_6 Vdd pmos W=0.1625U L=0.065U
M1523_ #308 inv__s n__O0__f_522_6 Vdd pmos W=0.1625U L=0.065U
M1524_keeper #1097 #fb1096# n__O0__f_522_6 Vdd pmos W=0.0975U L=0.065U
M1525_keeper #1098 #fb1096# n__O0__f_522_6 GND nmos W=0.0975U L=0.065U
M1526_ #302 I_af_522_6 #303 GND nmos W=0.0975U L=0.065U
M1527_ #302 I_af_521_6 #306 GND nmos W=0.0975U L=0.065U
M1528_ #306 s #305 GND nmos W=0.0975U L=0.065U
M1529_ #311 inv__s n__O1__t_522_6 GND nmos W=0.0975U L=0.065U
M1530_ #312 w__0i n__O1__t_522_6 GND nmos W=0.0975U L=0.065U
M1531_ #314 s n__O1__t_522_6 Vdd pmos W=0.1625U L=0.065U
M1532_ #315 inv__s n__O1__t_522_6 Vdd pmos W=0.1625U L=0.065U
M1533_keeper #1100 #fb1099# n__O1__t_522_6 Vdd pmos W=0.0975U L=0.065U
M1534_keeper #1101 #fb1099# n__O1__t_522_6 GND nmos W=0.0975U L=0.065U
M1535_ #310 I_at_522_6 #311 GND nmos W=0.0975U L=0.065U
M1536_ #310 I_at_521_6 #313 GND nmos W=0.0975U L=0.065U
M1537_ #313 s #312 GND nmos W=0.0975U L=0.065U
M1538_ #318 inv__s n__O1__f_522_6 GND nmos W=0.0975U L=0.065U
M1539_ #319 w__0i n__O1__f_522_6 GND nmos W=0.0975U L=0.065U
M1540_ #321 s n__O1__f_522_6 Vdd pmos W=0.1625U L=0.065U
M1541_ #322 inv__s n__O1__f_522_6 Vdd pmos W=0.1625U L=0.065U
M1542_keeper #1103 #fb1102# n__O1__f_522_6 Vdd pmos W=0.0975U L=0.065U
M1543_keeper #1104 #fb1102# n__O1__f_522_6 GND nmos W=0.0975U L=0.065U
M1544_ #317 I_af_522_6 #318 GND nmos W=0.0975U L=0.065U
M1545_ #317 I_af_521_6 #320 GND nmos W=0.0975U L=0.065U
M1546_ #320 s #319 GND nmos W=0.0975U L=0.065U
M1547_ #325 inv__s n__O0__t_523_6 GND nmos W=0.0975U L=0.065U
M1548_ #327 w__0i n__O0__t_523_6 GND nmos W=0.0975U L=0.065U
M1549_ #329 s n__O0__t_523_6 Vdd pmos W=0.1625U L=0.065U
M1550_ #330 inv__s n__O0__t_523_6 Vdd pmos W=0.1625U L=0.065U
M1551_keeper #1106 #fb1105# n__O0__t_523_6 Vdd pmos W=0.0975U L=0.065U
M1552_keeper #1107 #fb1105# n__O0__t_523_6 GND nmos W=0.0975U L=0.065U
M1553_ #324 I_at_523_6 #325 GND nmos W=0.0975U L=0.065U
M1554_ #324 I_at_522_6 #328 GND nmos W=0.0975U L=0.065U
M1555_ #328 s #327 GND nmos W=0.0975U L=0.065U
M1556_ #333 inv__s n__O0__f_523_6 GND nmos W=0.0975U L=0.065U
M1557_ #335 w__0i n__O0__f_523_6 GND nmos W=0.0975U L=0.065U
M1558_ #337 s n__O0__f_523_6 Vdd pmos W=0.1625U L=0.065U
M1559_ #338 inv__s n__O0__f_523_6 Vdd pmos W=0.1625U L=0.065U
M1560_keeper #1109 #fb1108# n__O0__f_523_6 Vdd pmos W=0.0975U L=0.065U
M1561_keeper #1110 #fb1108# n__O0__f_523_6 GND nmos W=0.0975U L=0.065U
M1562_ #332 I_af_523_6 #333 GND nmos W=0.0975U L=0.065U
M1563_ #332 I_af_522_6 #336 GND nmos W=0.0975U L=0.065U
M1564_ #336 s #335 GND nmos W=0.0975U L=0.065U
M1565_ #341 inv__s n__O1__t_523_6 GND nmos W=0.0975U L=0.065U
M1566_ #342 w__0i n__O1__t_523_6 GND nmos W=0.0975U L=0.065U
M1567_ #344 s n__O1__t_523_6 Vdd pmos W=0.1625U L=0.065U
M1568_ #345 inv__s n__O1__t_523_6 Vdd pmos W=0.1625U L=0.065U
M1569_keeper #1112 #fb1111# n__O1__t_523_6 Vdd pmos W=0.0975U L=0.065U
M1570_keeper #1113 #fb1111# n__O1__t_523_6 GND nmos W=0.0975U L=0.065U
M1571_ #340 I_at_523_6 #341 GND nmos W=0.0975U L=0.065U
M1572_ #340 I_at_522_6 #343 GND nmos W=0.0975U L=0.065U
M1573_ #343 s #342 GND nmos W=0.0975U L=0.065U
M1574_ #348 inv__s n__O1__f_523_6 GND nmos W=0.0975U L=0.065U
M1575_ #349 w__0i n__O1__f_523_6 GND nmos W=0.0975U L=0.065U
M1576_ #351 s n__O1__f_523_6 Vdd pmos W=0.1625U L=0.065U
M1577_ #352 inv__s n__O1__f_523_6 Vdd pmos W=0.1625U L=0.065U
M1578_keeper #1115 #fb1114# n__O1__f_523_6 Vdd pmos W=0.0975U L=0.065U
M1579_keeper #1116 #fb1114# n__O1__f_523_6 GND nmos W=0.0975U L=0.065U
M1580_ #347 I_af_523_6 #348 GND nmos W=0.0975U L=0.065U
M1581_ #347 I_af_522_6 #350 GND nmos W=0.0975U L=0.065U
M1582_ #350 s #349 GND nmos W=0.0975U L=0.065U
M1583_ #355 inv__s n__O0__t_524_6 GND nmos W=0.0975U L=0.065U
M1584_ #357 w__0i n__O0__t_524_6 GND nmos W=0.0975U L=0.065U
M1585_ #359 s n__O0__t_524_6 Vdd pmos W=0.1625U L=0.065U
M1586_ #360 inv__s n__O0__t_524_6 Vdd pmos W=0.1625U L=0.065U
M1587_keeper #1118 #fb1117# n__O0__t_524_6 Vdd pmos W=0.0975U L=0.065U
M1588_keeper #1119 #fb1117# n__O0__t_524_6 GND nmos W=0.0975U L=0.065U
M1589_ #354 I_at_524_6 #355 GND nmos W=0.0975U L=0.065U
M1590_ #354 I_at_523_6 #358 GND nmos W=0.0975U L=0.065U
M1591_ #358 s #357 GND nmos W=0.0975U L=0.065U
M1592_ #363 inv__s n__O0__f_524_6 GND nmos W=0.0975U L=0.065U
M1593_ #365 w__0i n__O0__f_524_6 GND nmos W=0.0975U L=0.065U
M1594_ #367 s n__O0__f_524_6 Vdd pmos W=0.1625U L=0.065U
M1595_ #368 inv__s n__O0__f_524_6 Vdd pmos W=0.1625U L=0.065U
M1596_keeper #1121 #fb1120# n__O0__f_524_6 Vdd pmos W=0.0975U L=0.065U
M1597_keeper #1122 #fb1120# n__O0__f_524_6 GND nmos W=0.0975U L=0.065U
M1598_ #362 I_af_524_6 #363 GND nmos W=0.0975U L=0.065U
M1599_ #362 I_af_523_6 #366 GND nmos W=0.0975U L=0.065U
M1600_ #366 s #365 GND nmos W=0.0975U L=0.065U
M1601_ #371 inv__s n__O1__t_524_6 GND nmos W=0.0975U L=0.065U
M1602_ #372 w__0i n__O1__t_524_6 GND nmos W=0.0975U L=0.065U
M1603_ #374 s n__O1__t_524_6 Vdd pmos W=0.1625U L=0.065U
M1604_ #375 inv__s n__O1__t_524_6 Vdd pmos W=0.1625U L=0.065U
M1605_keeper #1124 #fb1123# n__O1__t_524_6 Vdd pmos W=0.0975U L=0.065U
M1606_keeper #1125 #fb1123# n__O1__t_524_6 GND nmos W=0.0975U L=0.065U
M1607_ #370 I_at_524_6 #371 GND nmos W=0.0975U L=0.065U
M1608_ #370 I_at_523_6 #373 GND nmos W=0.0975U L=0.065U
M1609_ #373 s #372 GND nmos W=0.0975U L=0.065U
M1610_ #378 inv__s n__O1__f_524_6 GND nmos W=0.0975U L=0.065U
M1611_ #379 w__0i n__O1__f_524_6 GND nmos W=0.0975U L=0.065U
M1612_ #381 s n__O1__f_524_6 Vdd pmos W=0.1625U L=0.065U
M1613_ #382 inv__s n__O1__f_524_6 Vdd pmos W=0.1625U L=0.065U
M1614_keeper #1127 #fb1126# n__O1__f_524_6 Vdd pmos W=0.0975U L=0.065U
M1615_keeper #1128 #fb1126# n__O1__f_524_6 GND nmos W=0.0975U L=0.065U
M1616_ #377 I_af_524_6 #378 GND nmos W=0.0975U L=0.065U
M1617_ #377 I_af_523_6 #380 GND nmos W=0.0975U L=0.065U
M1618_ #380 s #379 GND nmos W=0.0975U L=0.065U
M1619_ #385 inv__s n__O0__t_525_6 GND nmos W=0.0975U L=0.065U
M1620_ #387 w__0i n__O0__t_525_6 GND nmos W=0.0975U L=0.065U
M1621_ #389 s n__O0__t_525_6 Vdd pmos W=0.1625U L=0.065U
M1622_ #390 inv__s n__O0__t_525_6 Vdd pmos W=0.1625U L=0.065U
M1623_keeper #1130 #fb1129# n__O0__t_525_6 Vdd pmos W=0.0975U L=0.065U
M1624_keeper #1131 #fb1129# n__O0__t_525_6 GND nmos W=0.0975U L=0.065U
M1625_ #384 I_at_525_6 #385 GND nmos W=0.0975U L=0.065U
M1626_ #384 I_at_524_6 #388 GND nmos W=0.0975U L=0.065U
M1627_ #388 s #387 GND nmos W=0.0975U L=0.065U
M1628_ #393 inv__s n__O0__f_525_6 GND nmos W=0.0975U L=0.065U
M1629_ #395 w__0i n__O0__f_525_6 GND nmos W=0.0975U L=0.065U
M1630_ #397 s n__O0__f_525_6 Vdd pmos W=0.1625U L=0.065U
M1631_ #398 inv__s n__O0__f_525_6 Vdd pmos W=0.1625U L=0.065U
M1632_keeper #1133 #fb1132# n__O0__f_525_6 Vdd pmos W=0.0975U L=0.065U
M1633_keeper #1134 #fb1132# n__O0__f_525_6 GND nmos W=0.0975U L=0.065U
M1634_ #392 I_af_525_6 #393 GND nmos W=0.0975U L=0.065U
M1635_ #392 I_af_524_6 #396 GND nmos W=0.0975U L=0.065U
M1636_ #396 s #395 GND nmos W=0.0975U L=0.065U
M1637_ #401 inv__s n__O1__t_525_6 GND nmos W=0.0975U L=0.065U
M1638_ #402 w__0i n__O1__t_525_6 GND nmos W=0.0975U L=0.065U
M1639_ #404 s n__O1__t_525_6 Vdd pmos W=0.1625U L=0.065U
M1640_ #405 inv__s n__O1__t_525_6 Vdd pmos W=0.1625U L=0.065U
M1641_keeper #1136 #fb1135# n__O1__t_525_6 Vdd pmos W=0.0975U L=0.065U
M1642_keeper #1137 #fb1135# n__O1__t_525_6 GND nmos W=0.0975U L=0.065U
M1643_ #400 I_at_525_6 #401 GND nmos W=0.0975U L=0.065U
M1644_ #400 I_at_524_6 #403 GND nmos W=0.0975U L=0.065U
M1645_ #403 s #402 GND nmos W=0.0975U L=0.065U
M1646_ #408 inv__s n__O1__f_525_6 GND nmos W=0.0975U L=0.065U
M1647_ #409 w__0i n__O1__f_525_6 GND nmos W=0.0975U L=0.065U
M1648_ #411 s n__O1__f_525_6 Vdd pmos W=0.1625U L=0.065U
M1649_ #412 inv__s n__O1__f_525_6 Vdd pmos W=0.1625U L=0.065U
M1650_keeper #1139 #fb1138# n__O1__f_525_6 Vdd pmos W=0.0975U L=0.065U
M1651_keeper #1140 #fb1138# n__O1__f_525_6 GND nmos W=0.0975U L=0.065U
M1652_ #407 I_af_525_6 #408 GND nmos W=0.0975U L=0.065U
M1653_ #407 I_af_524_6 #410 GND nmos W=0.0975U L=0.065U
M1654_ #410 s #409 GND nmos W=0.0975U L=0.065U
M1655_ #415 inv__s n__O0__t_526_6 GND nmos W=0.0975U L=0.065U
M1656_ #417 w__0i n__O0__t_526_6 GND nmos W=0.0975U L=0.065U
M1657_ #419 s n__O0__t_526_6 Vdd pmos W=0.1625U L=0.065U
M1658_ #420 inv__s n__O0__t_526_6 Vdd pmos W=0.1625U L=0.065U
M1659_keeper #1142 #fb1141# n__O0__t_526_6 Vdd pmos W=0.0975U L=0.065U
M1660_keeper #1143 #fb1141# n__O0__t_526_6 GND nmos W=0.0975U L=0.065U
M1661_ #414 I_at_526_6 #415 GND nmos W=0.0975U L=0.065U
M1662_ #414 I_at_525_6 #418 GND nmos W=0.0975U L=0.065U
M1663_ #418 s #417 GND nmos W=0.0975U L=0.065U
M1664_ #423 inv__s n__O0__f_526_6 GND nmos W=0.0975U L=0.065U
M1665_ #425 w__0i n__O0__f_526_6 GND nmos W=0.0975U L=0.065U
M1666_ #427 s n__O0__f_526_6 Vdd pmos W=0.1625U L=0.065U
M1667_ #428 inv__s n__O0__f_526_6 Vdd pmos W=0.1625U L=0.065U
M1668_keeper #1145 #fb1144# n__O0__f_526_6 Vdd pmos W=0.0975U L=0.065U
M1669_keeper #1146 #fb1144# n__O0__f_526_6 GND nmos W=0.0975U L=0.065U
M1670_ #422 I_af_526_6 #423 GND nmos W=0.0975U L=0.065U
M1671_ #422 I_af_525_6 #426 GND nmos W=0.0975U L=0.065U
M1672_ #426 s #425 GND nmos W=0.0975U L=0.065U
M1673_ #431 inv__s n__O1__t_526_6 GND nmos W=0.0975U L=0.065U
M1674_ #432 w__0i n__O1__t_526_6 GND nmos W=0.0975U L=0.065U
M1675_ #434 s n__O1__t_526_6 Vdd pmos W=0.1625U L=0.065U
M1676_ #435 inv__s n__O1__t_526_6 Vdd pmos W=0.1625U L=0.065U
M1677_keeper #1148 #fb1147# n__O1__t_526_6 Vdd pmos W=0.0975U L=0.065U
M1678_keeper #1149 #fb1147# n__O1__t_526_6 GND nmos W=0.0975U L=0.065U
M1679_ #430 I_at_526_6 #431 GND nmos W=0.0975U L=0.065U
M1680_ #430 I_at_525_6 #433 GND nmos W=0.0975U L=0.065U
M1681_ #433 s #432 GND nmos W=0.0975U L=0.065U
M1682_ #438 inv__s n__O1__f_526_6 GND nmos W=0.0975U L=0.065U
M1683_ #439 w__0i n__O1__f_526_6 GND nmos W=0.0975U L=0.065U
M1684_ #441 s n__O1__f_526_6 Vdd pmos W=0.1625U L=0.065U
M1685_ #442 inv__s n__O1__f_526_6 Vdd pmos W=0.1625U L=0.065U
M1686_keeper #1151 #fb1150# n__O1__f_526_6 Vdd pmos W=0.0975U L=0.065U
M1687_keeper #1152 #fb1150# n__O1__f_526_6 GND nmos W=0.0975U L=0.065U
M1688_ #437 I_af_526_6 #438 GND nmos W=0.0975U L=0.065U
M1689_ #437 I_af_525_6 #440 GND nmos W=0.0975U L=0.065U
M1690_ #440 s #439 GND nmos W=0.0975U L=0.065U
M1691_ #445 inv__s n__O0__t_527_6 GND nmos W=0.0975U L=0.065U
M1692_ #447 w__0i n__O0__t_527_6 GND nmos W=0.0975U L=0.065U
M1693_ #449 s n__O0__t_527_6 Vdd pmos W=0.1625U L=0.065U
M1694_ #450 inv__s n__O0__t_527_6 Vdd pmos W=0.1625U L=0.065U
M1695_keeper #1154 #fb1153# n__O0__t_527_6 Vdd pmos W=0.0975U L=0.065U
M1696_keeper #1155 #fb1153# n__O0__t_527_6 GND nmos W=0.0975U L=0.065U
M1697_ #444 I_at_527_6 #445 GND nmos W=0.0975U L=0.065U
M1698_ #444 I_at_526_6 #448 GND nmos W=0.0975U L=0.065U
M1699_ #448 s #447 GND nmos W=0.0975U L=0.065U
M1700_ #453 inv__s n__O0__f_527_6 GND nmos W=0.0975U L=0.065U
M1701_ #455 w__0i n__O0__f_527_6 GND nmos W=0.0975U L=0.065U
M1702_ #457 s n__O0__f_527_6 Vdd pmos W=0.1625U L=0.065U
M1703_ #458 inv__s n__O0__f_527_6 Vdd pmos W=0.1625U L=0.065U
M1704_keeper #1157 #fb1156# n__O0__f_527_6 Vdd pmos W=0.0975U L=0.065U
M1705_keeper #1158 #fb1156# n__O0__f_527_6 GND nmos W=0.0975U L=0.065U
M1706_ #452 I_af_527_6 #453 GND nmos W=0.0975U L=0.065U
M1707_ #452 I_af_526_6 #456 GND nmos W=0.0975U L=0.065U
M1708_ #456 s #455 GND nmos W=0.0975U L=0.065U
M1709_ #461 inv__s n__O1__t_527_6 GND nmos W=0.0975U L=0.065U
M1710_ #462 w__0i n__O1__t_527_6 GND nmos W=0.0975U L=0.065U
M1711_ #464 s n__O1__t_527_6 Vdd pmos W=0.1625U L=0.065U
M1712_ #465 inv__s n__O1__t_527_6 Vdd pmos W=0.1625U L=0.065U
M1713_keeper #1160 #fb1159# n__O1__t_527_6 Vdd pmos W=0.0975U L=0.065U
M1714_keeper #1161 #fb1159# n__O1__t_527_6 GND nmos W=0.0975U L=0.065U
M1715_ #460 I_at_527_6 #461 GND nmos W=0.0975U L=0.065U
M1716_ #460 I_at_526_6 #463 GND nmos W=0.0975U L=0.065U
M1717_ #463 s #462 GND nmos W=0.0975U L=0.065U
M1718_ #468 inv__s n__O1__f_527_6 GND nmos W=0.0975U L=0.065U
M1719_ #469 w__0i n__O1__f_527_6 GND nmos W=0.0975U L=0.065U
M1720_ #471 s n__O1__f_527_6 Vdd pmos W=0.1625U L=0.065U
M1721_ #472 inv__s n__O1__f_527_6 Vdd pmos W=0.1625U L=0.065U
M1722_keeper #1163 #fb1162# n__O1__f_527_6 Vdd pmos W=0.0975U L=0.065U
M1723_keeper #1164 #fb1162# n__O1__f_527_6 GND nmos W=0.0975U L=0.065U
M1724_ #467 I_af_527_6 #468 GND nmos W=0.0975U L=0.065U
M1725_ #467 I_af_526_6 #470 GND nmos W=0.0975U L=0.065U
M1726_ #470 s #469 GND nmos W=0.0975U L=0.065U
M1727_ #475 inv__s n__O0__t_528_6 GND nmos W=0.0975U L=0.065U
M1728_ #477 w__0i n__O0__t_528_6 GND nmos W=0.0975U L=0.065U
M1729_ #479 s n__O0__t_528_6 Vdd pmos W=0.1625U L=0.065U
M1730_ #480 inv__s n__O0__t_528_6 Vdd pmos W=0.1625U L=0.065U
M1731_keeper #1166 #fb1165# n__O0__t_528_6 Vdd pmos W=0.0975U L=0.065U
M1732_keeper #1167 #fb1165# n__O0__t_528_6 GND nmos W=0.0975U L=0.065U
M1733_ #474 I_at_528_6 #475 GND nmos W=0.0975U L=0.065U
M1734_ #474 I_at_527_6 #478 GND nmos W=0.0975U L=0.065U
M1735_ #478 s #477 GND nmos W=0.0975U L=0.065U
M1736_ #483 inv__s n__O0__f_528_6 GND nmos W=0.0975U L=0.065U
M1737_ #485 w__0i n__O0__f_528_6 GND nmos W=0.0975U L=0.065U
M1738_ #487 s n__O0__f_528_6 Vdd pmos W=0.1625U L=0.065U
M1739_ #488 inv__s n__O0__f_528_6 Vdd pmos W=0.1625U L=0.065U
M1740_keeper #1169 #fb1168# n__O0__f_528_6 Vdd pmos W=0.0975U L=0.065U
M1741_keeper #1170 #fb1168# n__O0__f_528_6 GND nmos W=0.0975U L=0.065U
M1742_ #482 I_af_528_6 #483 GND nmos W=0.0975U L=0.065U
M1743_ #482 I_af_527_6 #486 GND nmos W=0.0975U L=0.065U
M1744_ #486 s #485 GND nmos W=0.0975U L=0.065U
M1745_ #491 inv__s n__O1__t_528_6 GND nmos W=0.0975U L=0.065U
M1746_ #492 w__0i n__O1__t_528_6 GND nmos W=0.0975U L=0.065U
M1747_ #494 s n__O1__t_528_6 Vdd pmos W=0.1625U L=0.065U
M1748_ #495 inv__s n__O1__t_528_6 Vdd pmos W=0.1625U L=0.065U
M1749_keeper #1172 #fb1171# n__O1__t_528_6 Vdd pmos W=0.0975U L=0.065U
M1750_keeper #1173 #fb1171# n__O1__t_528_6 GND nmos W=0.0975U L=0.065U
M1751_ #490 I_at_528_6 #491 GND nmos W=0.0975U L=0.065U
M1752_ #490 I_at_527_6 #493 GND nmos W=0.0975U L=0.065U
M1753_ #493 s #492 GND nmos W=0.0975U L=0.065U
M1754_ #498 inv__s n__O1__f_528_6 GND nmos W=0.0975U L=0.065U
M1755_ #499 w__0i n__O1__f_528_6 GND nmos W=0.0975U L=0.065U
M1756_ #501 s n__O1__f_528_6 Vdd pmos W=0.1625U L=0.065U
M1757_ #502 inv__s n__O1__f_528_6 Vdd pmos W=0.1625U L=0.065U
M1758_keeper #1175 #fb1174# n__O1__f_528_6 Vdd pmos W=0.0975U L=0.065U
M1759_keeper #1176 #fb1174# n__O1__f_528_6 GND nmos W=0.0975U L=0.065U
M1760_ #497 I_af_528_6 #498 GND nmos W=0.0975U L=0.065U
M1761_ #497 I_af_527_6 #500 GND nmos W=0.0975U L=0.065U
M1762_ #500 s #499 GND nmos W=0.0975U L=0.065U
M1763_ #505 inv__s n__O0__t_529_6 GND nmos W=0.0975U L=0.065U
M1764_ #507 w__0i n__O0__t_529_6 GND nmos W=0.0975U L=0.065U
M1765_ #509 s n__O0__t_529_6 Vdd pmos W=0.1625U L=0.065U
M1766_ #510 inv__s n__O0__t_529_6 Vdd pmos W=0.1625U L=0.065U
M1767_keeper #1178 #fb1177# n__O0__t_529_6 Vdd pmos W=0.0975U L=0.065U
M1768_keeper #1179 #fb1177# n__O0__t_529_6 GND nmos W=0.0975U L=0.065U
M1769_ #504 I_at_529_6 #505 GND nmos W=0.0975U L=0.065U
M1770_ #504 I_at_528_6 #508 GND nmos W=0.0975U L=0.065U
M1771_ #508 s #507 GND nmos W=0.0975U L=0.065U
M1772_ #513 inv__s n__O0__f_529_6 GND nmos W=0.0975U L=0.065U
M1773_ #515 w__0i n__O0__f_529_6 GND nmos W=0.0975U L=0.065U
M1774_ #517 s n__O0__f_529_6 Vdd pmos W=0.1625U L=0.065U
M1775_ #518 inv__s n__O0__f_529_6 Vdd pmos W=0.1625U L=0.065U
M1776_keeper #1181 #fb1180# n__O0__f_529_6 Vdd pmos W=0.0975U L=0.065U
M1777_keeper #1182 #fb1180# n__O0__f_529_6 GND nmos W=0.0975U L=0.065U
M1778_ #512 I_af_529_6 #513 GND nmos W=0.0975U L=0.065U
M1779_ #512 I_af_528_6 #516 GND nmos W=0.0975U L=0.065U
M1780_ #516 s #515 GND nmos W=0.0975U L=0.065U
M1781_ #521 inv__s n__O1__t_529_6 GND nmos W=0.0975U L=0.065U
M1782_ #522 w__0i n__O1__t_529_6 GND nmos W=0.0975U L=0.065U
M1783_ #524 s n__O1__t_529_6 Vdd pmos W=0.1625U L=0.065U
M1784_ #525 inv__s n__O1__t_529_6 Vdd pmos W=0.1625U L=0.065U
M1785_keeper #1184 #fb1183# n__O1__t_529_6 Vdd pmos W=0.0975U L=0.065U
M1786_keeper #1185 #fb1183# n__O1__t_529_6 GND nmos W=0.0975U L=0.065U
M1787_ #520 I_at_529_6 #521 GND nmos W=0.0975U L=0.065U
M1788_ #520 I_at_528_6 #523 GND nmos W=0.0975U L=0.065U
M1789_ #523 s #522 GND nmos W=0.0975U L=0.065U
M1790_ #528 inv__s n__O1__f_529_6 GND nmos W=0.0975U L=0.065U
M1791_ #529 w__0i n__O1__f_529_6 GND nmos W=0.0975U L=0.065U
M1792_ #531 s n__O1__f_529_6 Vdd pmos W=0.1625U L=0.065U
M1793_ #532 inv__s n__O1__f_529_6 Vdd pmos W=0.1625U L=0.065U
M1794_keeper #1187 #fb1186# n__O1__f_529_6 Vdd pmos W=0.0975U L=0.065U
M1795_keeper #1188 #fb1186# n__O1__f_529_6 GND nmos W=0.0975U L=0.065U
M1796_ #527 I_af_529_6 #528 GND nmos W=0.0975U L=0.065U
M1797_ #527 I_af_528_6 #530 GND nmos W=0.0975U L=0.065U
M1798_ #530 s #529 GND nmos W=0.0975U L=0.065U
M1799_ #535 inv__s n__O0__t_530_6 GND nmos W=0.0975U L=0.065U
M1800_ #537 w__0i n__O0__t_530_6 GND nmos W=0.0975U L=0.065U
M1801_ #539 s n__O0__t_530_6 Vdd pmos W=0.1625U L=0.065U
M1802_ #540 inv__s n__O0__t_530_6 Vdd pmos W=0.1625U L=0.065U
M1803_keeper #1190 #fb1189# n__O0__t_530_6 Vdd pmos W=0.0975U L=0.065U
M1804_keeper #1191 #fb1189# n__O0__t_530_6 GND nmos W=0.0975U L=0.065U
M1805_ #534 I_at_530_6 #535 GND nmos W=0.0975U L=0.065U
M1806_ #534 I_at_529_6 #538 GND nmos W=0.0975U L=0.065U
M1807_ #538 s #537 GND nmos W=0.0975U L=0.065U
M1808_ #543 inv__s n__O0__f_530_6 GND nmos W=0.0975U L=0.065U
M1809_ #545 w__0i n__O0__f_530_6 GND nmos W=0.0975U L=0.065U
M1810_ #547 s n__O0__f_530_6 Vdd pmos W=0.1625U L=0.065U
M1811_ #548 inv__s n__O0__f_530_6 Vdd pmos W=0.1625U L=0.065U
M1812_keeper #1193 #fb1192# n__O0__f_530_6 Vdd pmos W=0.0975U L=0.065U
M1813_keeper #1194 #fb1192# n__O0__f_530_6 GND nmos W=0.0975U L=0.065U
M1814_ #542 I_af_530_6 #543 GND nmos W=0.0975U L=0.065U
M1815_ #542 I_af_529_6 #546 GND nmos W=0.0975U L=0.065U
M1816_ #546 s #545 GND nmos W=0.0975U L=0.065U
M1817_ #551 inv__s n__O1__t_530_6 GND nmos W=0.0975U L=0.065U
M1818_ #552 w__0i n__O1__t_530_6 GND nmos W=0.0975U L=0.065U
M1819_ #554 s n__O1__t_530_6 Vdd pmos W=0.1625U L=0.065U
M1820_ #555 inv__s n__O1__t_530_6 Vdd pmos W=0.1625U L=0.065U
M1821_keeper #1196 #fb1195# n__O1__t_530_6 Vdd pmos W=0.0975U L=0.065U
M1822_keeper #1197 #fb1195# n__O1__t_530_6 GND nmos W=0.0975U L=0.065U
M1823_ #550 I_at_530_6 #551 GND nmos W=0.0975U L=0.065U
M1824_ #550 I_at_529_6 #553 GND nmos W=0.0975U L=0.065U
M1825_ #553 s #552 GND nmos W=0.0975U L=0.065U
M1826_ #558 inv__s n__O1__f_530_6 GND nmos W=0.0975U L=0.065U
M1827_ #559 w__0i n__O1__f_530_6 GND nmos W=0.0975U L=0.065U
M1828_ #561 s n__O1__f_530_6 Vdd pmos W=0.1625U L=0.065U
M1829_ #562 inv__s n__O1__f_530_6 Vdd pmos W=0.1625U L=0.065U
M1830_keeper #1199 #fb1198# n__O1__f_530_6 Vdd pmos W=0.0975U L=0.065U
M1831_keeper #1200 #fb1198# n__O1__f_530_6 GND nmos W=0.0975U L=0.065U
M1832_ #557 I_af_530_6 #558 GND nmos W=0.0975U L=0.065U
M1833_ #557 I_af_529_6 #560 GND nmos W=0.0975U L=0.065U
M1834_ #560 s #559 GND nmos W=0.0975U L=0.065U
M1835_ #565 inv__s n__O0__t_531_6 GND nmos W=0.0975U L=0.065U
M1836_ #567 w__0i n__O0__t_531_6 GND nmos W=0.0975U L=0.065U
M1837_ #569 s n__O0__t_531_6 Vdd pmos W=0.1625U L=0.065U
M1838_ #570 inv__s n__O0__t_531_6 Vdd pmos W=0.1625U L=0.065U
M1839_keeper #1202 #fb1201# n__O0__t_531_6 Vdd pmos W=0.0975U L=0.065U
M1840_keeper #1203 #fb1201# n__O0__t_531_6 GND nmos W=0.0975U L=0.065U
M1841_ #564 I_at_531_6 #565 GND nmos W=0.0975U L=0.065U
M1842_ #564 I_at_530_6 #568 GND nmos W=0.0975U L=0.065U
M1843_ #568 s #567 GND nmos W=0.0975U L=0.065U
M1844_ #573 inv__s n__O0__f_531_6 GND nmos W=0.0975U L=0.065U
M1845_ #574 w__0i n__O0__f_531_6 GND nmos W=0.0975U L=0.065U
M1846_ #576 s n__O0__f_531_6 Vdd pmos W=0.1625U L=0.065U
M1847_ #577 inv__s n__O0__f_531_6 Vdd pmos W=0.1625U L=0.065U
M1848_keeper #1205 #fb1204# n__O0__f_531_6 Vdd pmos W=0.0975U L=0.065U
M1849_keeper #1206 #fb1204# n__O0__f_531_6 GND nmos W=0.0975U L=0.065U
M1850_ #572 I_af_531_6 #573 GND nmos W=0.0975U L=0.065U
M1851_ #572 I_af_530_6 #575 GND nmos W=0.0975U L=0.065U
M1852_ #575 s #574 GND nmos W=0.0975U L=0.065U
M1853_ #580 inv__s n__O1__t_531_6 GND nmos W=0.0975U L=0.065U
M1854_ #581 w__0i n__O1__t_531_6 GND nmos W=0.0975U L=0.065U
M1855_ #583 s n__O1__t_531_6 Vdd pmos W=0.1625U L=0.065U
M1856_ #584 inv__s n__O1__t_531_6 Vdd pmos W=0.1625U L=0.065U
M1857_keeper #1208 #fb1207# n__O1__t_531_6 Vdd pmos W=0.0975U L=0.065U
M1858_keeper #1209 #fb1207# n__O1__t_531_6 GND nmos W=0.0975U L=0.065U
M1859_ #579 I_at_531_6 #580 GND nmos W=0.0975U L=0.065U
M1860_ #579 I_at_530_6 #582 GND nmos W=0.0975U L=0.065U
M1861_ #582 s #581 GND nmos W=0.0975U L=0.065U
M1862_ #587 inv__s n__O1__f_531_6 GND nmos W=0.0975U L=0.065U
M1863_ #588 w__0i n__O1__f_531_6 GND nmos W=0.0975U L=0.065U
M1864_ #590 s n__O1__f_531_6 Vdd pmos W=0.1625U L=0.065U
M1865_ #591 inv__s n__O1__f_531_6 Vdd pmos W=0.1625U L=0.065U
M1866_keeper #1211 #fb1210# n__O1__f_531_6 Vdd pmos W=0.0975U L=0.065U
M1867_keeper #1212 #fb1210# n__O1__f_531_6 GND nmos W=0.0975U L=0.065U
M1868_ #586 I_af_531_6 #587 GND nmos W=0.0975U L=0.065U
M1869_ #586 I_af_530_6 #589 GND nmos W=0.0975U L=0.065U
M1870_ #589 s #588 GND nmos W=0.0975U L=0.065U
M1871_ #593 inv__s n__O0__t_513_6 GND nmos W=0.0975U L=0.065U
M1872_ #595 s n__O0__t_513_6 Vdd pmos W=0.1625U L=0.065U
M1873_keeper #1214 #fb1213# n__O0__t_513_6 Vdd pmos W=0.0975U L=0.065U
M1874_keeper #1215 #fb1213# n__O0__t_513_6 GND nmos W=0.0975U L=0.065U
M1875_ #594 I_at_513_6 #593 GND nmos W=0.0975U L=0.065U
M1876_ #598 inv__s n__O0__f_513_6 GND nmos W=0.0975U L=0.065U
M1877_ #599 s n__O0__f_513_6 GND nmos W=0.0975U L=0.065U
M1878_ #601 s n__O0__f_513_6 Vdd pmos W=0.1625U L=0.065U
M1879_ #602 inv__s n__O0__f_513_6 Vdd pmos W=0.1625U L=0.065U
M1880_keeper #1217 #fb1216# n__O0__f_513_6 Vdd pmos W=0.0975U L=0.065U
M1881_keeper #1218 #fb1216# n__O0__f_513_6 GND nmos W=0.0975U L=0.065U
M1882_ #597 I_af_513_6 #598 GND nmos W=0.0975U L=0.065U
M1883_ #597 n__I__a #600 GND nmos W=0.0975U L=0.065U
M1884_ #600 w__0i #599 GND nmos W=0.0975U L=0.065U
M1885_ #604 inv__s n__O1__t_513_6 GND nmos W=0.0975U L=0.065U
M1886_ #606 s n__O1__t_513_6 Vdd pmos W=0.1625U L=0.065U
M1887_keeper #1220 #fb1219# n__O1__t_513_6 Vdd pmos W=0.0975U L=0.065U
M1888_keeper #1221 #fb1219# n__O1__t_513_6 GND nmos W=0.0975U L=0.065U
M1889_ #605 I_at_513_6 #604 GND nmos W=0.0975U L=0.065U
M1890_ #609 inv__s n__O1__f_513_6 GND nmos W=0.0975U L=0.065U
M1891_ #610 s n__O1__f_513_6 GND nmos W=0.0975U L=0.065U
M1892_ #612 s n__O1__f_513_6 Vdd pmos W=0.1625U L=0.065U
M1893_ #613 inv__s n__O1__f_513_6 Vdd pmos W=0.1625U L=0.065U
M1894_keeper #1223 #fb1222# n__O1__f_513_6 Vdd pmos W=0.0975U L=0.065U
M1895_keeper #1224 #fb1222# n__O1__f_513_6 GND nmos W=0.0975U L=0.065U
M1896_ #608 I_af_513_6 #609 GND nmos W=0.0975U L=0.065U
M1897_ #608 n__I__a #611 GND nmos W=0.0975U L=0.065U
M1898_ #611 w__0i #610 GND nmos W=0.0975U L=0.065U
M1899_ #615 inv__s n__O0__t_50_6 GND nmos W=0.0975U L=0.065U
M1900_ #617 w__0i n__O0__t_50_6 GND nmos W=0.0975U L=0.065U
M1901_keeper #1226 #fb1225# n__O0__t_50_6 Vdd pmos W=0.0975U L=0.065U
M1902_keeper #1227 #fb1225# n__O0__t_50_6 GND nmos W=0.0975U L=0.065U
M1903_ #616 I_at_50_6 #615 GND nmos W=0.0975U L=0.065U
M1904_ #615 s #617 GND nmos W=0.0975U L=0.065U
M1905_ #619 inv__s n__O0__f_50_6 GND nmos W=0.0975U L=0.065U
M1906_ #622 w__0i n__O0__f_50_6 GND nmos W=0.0975U L=0.065U
M1907_keeper #1229 #fb1228# n__O0__f_50_6 Vdd pmos W=0.0975U L=0.065U
M1908_keeper #1230 #fb1228# n__O0__f_50_6 GND nmos W=0.0975U L=0.065U
M1909_ #620 I_af_50_6 #619 GND nmos W=0.0975U L=0.065U
M1910_ #619 s #622 GND nmos W=0.0975U L=0.065U
M1911_ #624 inv__s n__O1__t_50_6 GND nmos W=0.0975U L=0.065U
M1912_ #626 w__0i n__O1__t_50_6 GND nmos W=0.0975U L=0.065U
M1913_keeper #1232 #fb1231# n__O1__t_50_6 Vdd pmos W=0.0975U L=0.065U
M1914_keeper #1233 #fb1231# n__O1__t_50_6 GND nmos W=0.0975U L=0.065U
M1915_ #625 I_at_50_6 #624 GND nmos W=0.0975U L=0.065U
M1916_ #624 s #626 GND nmos W=0.0975U L=0.065U
M1917_ #628 inv__s n__O1__f_50_6 GND nmos W=0.0975U L=0.065U
M1918_ #630 w__0i n__O1__f_50_6 GND nmos W=0.0975U L=0.065U
M1919_keeper #1235 #fb1234# n__O1__f_50_6 Vdd pmos W=0.0975U L=0.065U
M1920_keeper #1236 #fb1234# n__O1__f_50_6 GND nmos W=0.0975U L=0.065U
M1921_ #629 I_af_50_6 #628 GND nmos W=0.0975U L=0.065U
M1922_ #628 s #630 GND nmos W=0.0975U L=0.065U
M1923_ #632 inv__s n__O0__t_51_6 GND nmos W=0.0975U L=0.065U
M1924_ #635 w__0i n__O0__t_51_6 GND nmos W=0.0975U L=0.065U
M1925_keeper #1238 #fb1237# n__O0__t_51_6 Vdd pmos W=0.0975U L=0.065U
M1926_keeper #1239 #fb1237# n__O0__t_51_6 GND nmos W=0.0975U L=0.065U
M1927_ #633 I_at_51_6 #632 GND nmos W=0.0975U L=0.065U
M1928_ #632 s #635 GND nmos W=0.0975U L=0.065U
M1929_ #637 inv__s n__O0__f_51_6 GND nmos W=0.0975U L=0.065U
M1930_ #640 w__0i n__O0__f_51_6 GND nmos W=0.0975U L=0.065U
M1931_keeper #1241 #fb1240# n__O0__f_51_6 Vdd pmos W=0.0975U L=0.065U
M1932_keeper #1242 #fb1240# n__O0__f_51_6 GND nmos W=0.0975U L=0.065U
M1933_ #638 I_af_51_6 #637 GND nmos W=0.0975U L=0.065U
M1934_ #637 s #640 GND nmos W=0.0975U L=0.065U
M1935_ #642 inv__s n__O1__t_51_6 GND nmos W=0.0975U L=0.065U
M1936_ #644 w__0i n__O1__t_51_6 GND nmos W=0.0975U L=0.065U
M1937_keeper #1244 #fb1243# n__O1__t_51_6 Vdd pmos W=0.0975U L=0.065U
M1938_keeper #1245 #fb1243# n__O1__t_51_6 GND nmos W=0.0975U L=0.065U
M1939_ #643 I_at_51_6 #642 GND nmos W=0.0975U L=0.065U
M1940_ #642 s #644 GND nmos W=0.0975U L=0.065U
M1941_ #646 inv__s n__O1__f_51_6 GND nmos W=0.0975U L=0.065U
M1942_ #648 w__0i n__O1__f_51_6 GND nmos W=0.0975U L=0.065U
M1943_keeper #1247 #fb1246# n__O1__f_51_6 Vdd pmos W=0.0975U L=0.065U
M1944_keeper #1248 #fb1246# n__O1__f_51_6 GND nmos W=0.0975U L=0.065U
M1945_ #647 I_af_51_6 #646 GND nmos W=0.0975U L=0.065U
M1946_ #646 s #648 GND nmos W=0.0975U L=0.065U
M1947_ #650 inv__s n__O0__t_52_6 GND nmos W=0.0975U L=0.065U
M1948_ #653 w__0i n__O0__t_52_6 GND nmos W=0.0975U L=0.065U
M1949_keeper #1250 #fb1249# n__O0__t_52_6 Vdd pmos W=0.0975U L=0.065U
M1950_keeper #1251 #fb1249# n__O0__t_52_6 GND nmos W=0.0975U L=0.065U
M1951_ #651 I_at_52_6 #650 GND nmos W=0.0975U L=0.065U
M1952_ #650 s #653 GND nmos W=0.0975U L=0.065U
M1953_ #655 inv__s n__O0__f_52_6 GND nmos W=0.0975U L=0.065U
M1954_ #658 w__0i n__O0__f_52_6 GND nmos W=0.0975U L=0.065U
M1955_keeper #1253 #fb1252# n__O0__f_52_6 Vdd pmos W=0.0975U L=0.065U
M1956_keeper #1254 #fb1252# n__O0__f_52_6 GND nmos W=0.0975U L=0.065U
M1957_ #656 I_af_52_6 #655 GND nmos W=0.0975U L=0.065U
M1958_ #655 s #658 GND nmos W=0.0975U L=0.065U
M1959_ #660 inv__s n__O1__t_52_6 GND nmos W=0.0975U L=0.065U
M1960_ #662 w__0i n__O1__t_52_6 GND nmos W=0.0975U L=0.065U
M1961_keeper #1256 #fb1255# n__O1__t_52_6 Vdd pmos W=0.0975U L=0.065U
M1962_keeper #1257 #fb1255# n__O1__t_52_6 GND nmos W=0.0975U L=0.065U
M1963_ #661 I_at_52_6 #660 GND nmos W=0.0975U L=0.065U
M1964_ #660 s #662 GND nmos W=0.0975U L=0.065U
M1965_ #664 inv__s n__O1__f_52_6 GND nmos W=0.0975U L=0.065U
M1966_ #666 w__0i n__O1__f_52_6 GND nmos W=0.0975U L=0.065U
M1967_keeper #1259 #fb1258# n__O1__f_52_6 Vdd pmos W=0.0975U L=0.065U
M1968_keeper #1260 #fb1258# n__O1__f_52_6 GND nmos W=0.0975U L=0.065U
M1969_ #665 I_af_52_6 #664 GND nmos W=0.0975U L=0.065U
M1970_ #664 s #666 GND nmos W=0.0975U L=0.065U
M1971_ #668 inv__s n__O0__t_53_6 GND nmos W=0.0975U L=0.065U
M1972_ #671 w__0i n__O0__t_53_6 GND nmos W=0.0975U L=0.065U
M1973_keeper #1262 #fb1261# n__O0__t_53_6 Vdd pmos W=0.0975U L=0.065U
M1974_keeper #1263 #fb1261# n__O0__t_53_6 GND nmos W=0.0975U L=0.065U
M1975_ #669 I_at_53_6 #668 GND nmos W=0.0975U L=0.065U
M1976_ #668 s #671 GND nmos W=0.0975U L=0.065U
M1977_ #673 inv__s n__O0__f_53_6 GND nmos W=0.0975U L=0.065U
M1978_ #676 w__0i n__O0__f_53_6 GND nmos W=0.0975U L=0.065U
M1979_keeper #1265 #fb1264# n__O0__f_53_6 Vdd pmos W=0.0975U L=0.065U
M1980_keeper #1266 #fb1264# n__O0__f_53_6 GND nmos W=0.0975U L=0.065U
M1981_ #674 I_af_53_6 #673 GND nmos W=0.0975U L=0.065U
M1982_ #673 s #676 GND nmos W=0.0975U L=0.065U
M1983_ #678 inv__s n__O1__t_53_6 GND nmos W=0.0975U L=0.065U
M1984_ #680 w__0i n__O1__t_53_6 GND nmos W=0.0975U L=0.065U
M1985_keeper #1268 #fb1267# n__O1__t_53_6 Vdd pmos W=0.0975U L=0.065U
M1986_keeper #1269 #fb1267# n__O1__t_53_6 GND nmos W=0.0975U L=0.065U
M1987_ #679 I_at_53_6 #678 GND nmos W=0.0975U L=0.065U
M1988_ #678 s #680 GND nmos W=0.0975U L=0.065U
M1989_ #682 inv__s n__O1__f_53_6 GND nmos W=0.0975U L=0.065U
M1990_ #684 w__0i n__O1__f_53_6 GND nmos W=0.0975U L=0.065U
M1991_keeper #1271 #fb1270# n__O1__f_53_6 Vdd pmos W=0.0975U L=0.065U
M1992_keeper #1272 #fb1270# n__O1__f_53_6 GND nmos W=0.0975U L=0.065U
M1993_ #683 I_af_53_6 #682 GND nmos W=0.0975U L=0.065U
M1994_ #682 s #684 GND nmos W=0.0975U L=0.065U
M1995_ #686 inv__s n__O0__t_54_6 GND nmos W=0.0975U L=0.065U
M1996_ #689 w__0i n__O0__t_54_6 GND nmos W=0.0975U L=0.065U
M1997_keeper #1274 #fb1273# n__O0__t_54_6 Vdd pmos W=0.0975U L=0.065U
M1998_keeper #1275 #fb1273# n__O0__t_54_6 GND nmos W=0.0975U L=0.065U
M1999_ #687 I_at_54_6 #686 GND nmos W=0.0975U L=0.065U
M2000_ #686 s #689 GND nmos W=0.0975U L=0.065U
M2001_ #691 inv__s n__O0__f_54_6 GND nmos W=0.0975U L=0.065U
M2002_ #694 w__0i n__O0__f_54_6 GND nmos W=0.0975U L=0.065U
M2003_keeper #1277 #fb1276# n__O0__f_54_6 Vdd pmos W=0.0975U L=0.065U
M2004_keeper #1278 #fb1276# n__O0__f_54_6 GND nmos W=0.0975U L=0.065U
M2005_ #692 I_af_54_6 #691 GND nmos W=0.0975U L=0.065U
M2006_ #691 s #694 GND nmos W=0.0975U L=0.065U
M2007_ #696 inv__s n__O1__t_54_6 GND nmos W=0.0975U L=0.065U
M2008_ #698 w__0i n__O1__t_54_6 GND nmos W=0.0975U L=0.065U
M2009_keeper #1280 #fb1279# n__O1__t_54_6 Vdd pmos W=0.0975U L=0.065U
M2010_keeper #1281 #fb1279# n__O1__t_54_6 GND nmos W=0.0975U L=0.065U
M2011_ #697 I_at_54_6 #696 GND nmos W=0.0975U L=0.065U
M2012_ #696 s #698 GND nmos W=0.0975U L=0.065U
M2013_ #700 inv__s n__O1__f_54_6 GND nmos W=0.0975U L=0.065U
M2014_ #702 w__0i n__O1__f_54_6 GND nmos W=0.0975U L=0.065U
M2015_keeper #1283 #fb1282# n__O1__f_54_6 Vdd pmos W=0.0975U L=0.065U
M2016_keeper #1284 #fb1282# n__O1__f_54_6 GND nmos W=0.0975U L=0.065U
M2017_ #701 I_af_54_6 #700 GND nmos W=0.0975U L=0.065U
M2018_ #700 s #702 GND nmos W=0.0975U L=0.065U
M2019_ #704 inv__s n__O0__t_55_6 GND nmos W=0.0975U L=0.065U
M2020_ #707 w__0i n__O0__t_55_6 GND nmos W=0.0975U L=0.065U
M2021_keeper #1286 #fb1285# n__O0__t_55_6 Vdd pmos W=0.0975U L=0.065U
M2022_keeper #1287 #fb1285# n__O0__t_55_6 GND nmos W=0.0975U L=0.065U
M2023_ #705 I_at_55_6 #704 GND nmos W=0.0975U L=0.065U
M2024_ #704 s #707 GND nmos W=0.0975U L=0.065U
M2025_ #709 inv__s n__O0__f_55_6 GND nmos W=0.0975U L=0.065U
M2026_ #712 w__0i n__O0__f_55_6 GND nmos W=0.0975U L=0.065U
M2027_keeper #1289 #fb1288# n__O0__f_55_6 Vdd pmos W=0.0975U L=0.065U
M2028_keeper #1290 #fb1288# n__O0__f_55_6 GND nmos W=0.0975U L=0.065U
M2029_ #710 I_af_55_6 #709 GND nmos W=0.0975U L=0.065U
M2030_ #709 s #712 GND nmos W=0.0975U L=0.065U
M2031_ #714 inv__s n__O1__t_55_6 GND nmos W=0.0975U L=0.065U
M2032_ #716 w__0i n__O1__t_55_6 GND nmos W=0.0975U L=0.065U
M2033_keeper #1292 #fb1291# n__O1__t_55_6 Vdd pmos W=0.0975U L=0.065U
M2034_keeper #1293 #fb1291# n__O1__t_55_6 GND nmos W=0.0975U L=0.065U
M2035_ #715 I_at_55_6 #714 GND nmos W=0.0975U L=0.065U
M2036_ #714 s #716 GND nmos W=0.0975U L=0.065U
M2037_ #718 inv__s n__O1__f_55_6 GND nmos W=0.0975U L=0.065U
M2038_ #720 w__0i n__O1__f_55_6 GND nmos W=0.0975U L=0.065U
M2039_keeper #1295 #fb1294# n__O1__f_55_6 Vdd pmos W=0.0975U L=0.065U
M2040_keeper #1296 #fb1294# n__O1__f_55_6 GND nmos W=0.0975U L=0.065U
M2041_ #719 I_af_55_6 #718 GND nmos W=0.0975U L=0.065U
M2042_ #718 s #720 GND nmos W=0.0975U L=0.065U
M2043_ #722 inv__s n__O0__t_56_6 GND nmos W=0.0975U L=0.065U
M2044_ #725 w__0i n__O0__t_56_6 GND nmos W=0.0975U L=0.065U
M2045_keeper #1298 #fb1297# n__O0__t_56_6 Vdd pmos W=0.0975U L=0.065U
M2046_keeper #1299 #fb1297# n__O0__t_56_6 GND nmos W=0.0975U L=0.065U
M2047_ #723 I_at_56_6 #722 GND nmos W=0.0975U L=0.065U
M2048_ #722 s #725 GND nmos W=0.0975U L=0.065U
M2049_ #727 inv__s n__O0__f_56_6 GND nmos W=0.0975U L=0.065U
M2050_ #730 w__0i n__O0__f_56_6 GND nmos W=0.0975U L=0.065U
M2051_keeper #1301 #fb1300# n__O0__f_56_6 Vdd pmos W=0.0975U L=0.065U
M2052_keeper #1302 #fb1300# n__O0__f_56_6 GND nmos W=0.0975U L=0.065U
M2053_ #728 I_af_56_6 #727 GND nmos W=0.0975U L=0.065U
M2054_ #727 s #730 GND nmos W=0.0975U L=0.065U
M2055_ #732 inv__s n__O1__t_56_6 GND nmos W=0.0975U L=0.065U
M2056_ #734 w__0i n__O1__t_56_6 GND nmos W=0.0975U L=0.065U
M2057_keeper #1304 #fb1303# n__O1__t_56_6 Vdd pmos W=0.0975U L=0.065U
M2058_keeper #1305 #fb1303# n__O1__t_56_6 GND nmos W=0.0975U L=0.065U
M2059_ #733 I_at_56_6 #732 GND nmos W=0.0975U L=0.065U
M2060_ #732 s #734 GND nmos W=0.0975U L=0.065U
M2061_ #736 inv__s n__O1__f_56_6 GND nmos W=0.0975U L=0.065U
M2062_ #738 w__0i n__O1__f_56_6 GND nmos W=0.0975U L=0.065U
M2063_keeper #1307 #fb1306# n__O1__f_56_6 Vdd pmos W=0.0975U L=0.065U
M2064_keeper #1308 #fb1306# n__O1__f_56_6 GND nmos W=0.0975U L=0.065U
M2065_ #737 I_af_56_6 #736 GND nmos W=0.0975U L=0.065U
M2066_ #736 s #738 GND nmos W=0.0975U L=0.065U
M2067_ #740 inv__s n__O0__t_57_6 GND nmos W=0.0975U L=0.065U
M2068_ #743 w__0i n__O0__t_57_6 GND nmos W=0.0975U L=0.065U
M2069_keeper #1310 #fb1309# n__O0__t_57_6 Vdd pmos W=0.0975U L=0.065U
M2070_keeper #1311 #fb1309# n__O0__t_57_6 GND nmos W=0.0975U L=0.065U
M2071_ #741 I_at_57_6 #740 GND nmos W=0.0975U L=0.065U
M2072_ #740 s #743 GND nmos W=0.0975U L=0.065U
M2073_ #745 inv__s n__O0__f_57_6 GND nmos W=0.0975U L=0.065U
M2074_ #748 w__0i n__O0__f_57_6 GND nmos W=0.0975U L=0.065U
M2075_keeper #1313 #fb1312# n__O0__f_57_6 Vdd pmos W=0.0975U L=0.065U
M2076_keeper #1314 #fb1312# n__O0__f_57_6 GND nmos W=0.0975U L=0.065U
M2077_ #746 I_af_57_6 #745 GND nmos W=0.0975U L=0.065U
M2078_ #745 s #748 GND nmos W=0.0975U L=0.065U
M2079_ #750 inv__s n__O1__t_57_6 GND nmos W=0.0975U L=0.065U
M2080_ #752 w__0i n__O1__t_57_6 GND nmos W=0.0975U L=0.065U
M2081_keeper #1316 #fb1315# n__O1__t_57_6 Vdd pmos W=0.0975U L=0.065U
M2082_keeper #1317 #fb1315# n__O1__t_57_6 GND nmos W=0.0975U L=0.065U
M2083_ #751 I_at_57_6 #750 GND nmos W=0.0975U L=0.065U
M2084_ #750 s #752 GND nmos W=0.0975U L=0.065U
M2085_ #754 inv__s n__O1__f_57_6 GND nmos W=0.0975U L=0.065U
M2086_ #756 w__0i n__O1__f_57_6 GND nmos W=0.0975U L=0.065U
M2087_keeper #1319 #fb1318# n__O1__f_57_6 Vdd pmos W=0.0975U L=0.065U
M2088_keeper #1320 #fb1318# n__O1__f_57_6 GND nmos W=0.0975U L=0.065U
M2089_ #755 I_af_57_6 #754 GND nmos W=0.0975U L=0.065U
M2090_ #754 s #756 GND nmos W=0.0975U L=0.065U
M2091_ #758 inv__s n__O0__t_58_6 GND nmos W=0.0975U L=0.065U
M2092_ #761 w__0i n__O0__t_58_6 GND nmos W=0.0975U L=0.065U
M2093_keeper #1322 #fb1321# n__O0__t_58_6 Vdd pmos W=0.0975U L=0.065U
M2094_keeper #1323 #fb1321# n__O0__t_58_6 GND nmos W=0.0975U L=0.065U
M2095_ #759 I_at_58_6 #758 GND nmos W=0.0975U L=0.065U
M2096_ #758 s #761 GND nmos W=0.0975U L=0.065U
M2097_ #763 inv__s n__O0__f_58_6 GND nmos W=0.0975U L=0.065U
M2098_ #766 w__0i n__O0__f_58_6 GND nmos W=0.0975U L=0.065U
M2099_keeper #1325 #fb1324# n__O0__f_58_6 Vdd pmos W=0.0975U L=0.065U
M2100_keeper #1326 #fb1324# n__O0__f_58_6 GND nmos W=0.0975U L=0.065U
M2101_ #764 I_af_58_6 #763 GND nmos W=0.0975U L=0.065U
M2102_ #763 s #766 GND nmos W=0.0975U L=0.065U
M2103_ #768 inv__s n__O1__t_58_6 GND nmos W=0.0975U L=0.065U
M2104_ #770 w__0i n__O1__t_58_6 GND nmos W=0.0975U L=0.065U
M2105_keeper #1328 #fb1327# n__O1__t_58_6 Vdd pmos W=0.0975U L=0.065U
M2106_keeper #1329 #fb1327# n__O1__t_58_6 GND nmos W=0.0975U L=0.065U
M2107_ #769 I_at_58_6 #768 GND nmos W=0.0975U L=0.065U
M2108_ #768 s #770 GND nmos W=0.0975U L=0.065U
M2109_ #772 inv__s n__O1__f_58_6 GND nmos W=0.0975U L=0.065U
M2110_ #774 w__0i n__O1__f_58_6 GND nmos W=0.0975U L=0.065U
M2111_keeper #1331 #fb1330# n__O1__f_58_6 Vdd pmos W=0.0975U L=0.065U
M2112_keeper #1332 #fb1330# n__O1__f_58_6 GND nmos W=0.0975U L=0.065U
M2113_ #773 I_af_58_6 #772 GND nmos W=0.0975U L=0.065U
M2114_ #772 s #774 GND nmos W=0.0975U L=0.065U
M2115_ #776 inv__s n__O0__t_59_6 GND nmos W=0.0975U L=0.065U
M2116_ #779 w__0i n__O0__t_59_6 GND nmos W=0.0975U L=0.065U
M2117_keeper #1334 #fb1333# n__O0__t_59_6 Vdd pmos W=0.0975U L=0.065U
M2118_keeper #1335 #fb1333# n__O0__t_59_6 GND nmos W=0.0975U L=0.065U
M2119_ #777 I_at_59_6 #776 GND nmos W=0.0975U L=0.065U
M2120_ #776 s #779 GND nmos W=0.0975U L=0.065U
M2121_ #781 inv__s n__O0__f_59_6 GND nmos W=0.0975U L=0.065U
M2122_ #784 w__0i n__O0__f_59_6 GND nmos W=0.0975U L=0.065U
M2123_keeper #1337 #fb1336# n__O0__f_59_6 Vdd pmos W=0.0975U L=0.065U
M2124_keeper #1338 #fb1336# n__O0__f_59_6 GND nmos W=0.0975U L=0.065U
M2125_ #782 I_af_59_6 #781 GND nmos W=0.0975U L=0.065U
M2126_ #781 s #784 GND nmos W=0.0975U L=0.065U
M2127_ #786 inv__s n__O1__t_59_6 GND nmos W=0.0975U L=0.065U
M2128_ #788 w__0i n__O1__t_59_6 GND nmos W=0.0975U L=0.065U
M2129_keeper #1340 #fb1339# n__O1__t_59_6 Vdd pmos W=0.0975U L=0.065U
M2130_keeper #1341 #fb1339# n__O1__t_59_6 GND nmos W=0.0975U L=0.065U
M2131_ #787 I_at_59_6 #786 GND nmos W=0.0975U L=0.065U
M2132_ #786 s #788 GND nmos W=0.0975U L=0.065U
M2133_ #790 inv__s n__O1__f_59_6 GND nmos W=0.0975U L=0.065U
M2134_ #792 w__0i n__O1__f_59_6 GND nmos W=0.0975U L=0.065U
M2135_keeper #1343 #fb1342# n__O1__f_59_6 Vdd pmos W=0.0975U L=0.065U
M2136_keeper #1344 #fb1342# n__O1__f_59_6 GND nmos W=0.0975U L=0.065U
M2137_ #791 I_af_59_6 #790 GND nmos W=0.0975U L=0.065U
M2138_ #790 s #792 GND nmos W=0.0975U L=0.065U
M2139_ #794 inv__s n__O0__t_510_6 GND nmos W=0.0975U L=0.065U
M2140_ #797 w__0i n__O0__t_510_6 GND nmos W=0.0975U L=0.065U
M2141_keeper #1346 #fb1345# n__O0__t_510_6 Vdd pmos W=0.0975U L=0.065U
M2142_keeper #1347 #fb1345# n__O0__t_510_6 GND nmos W=0.0975U L=0.065U
M2143_ #795 I_at_510_6 #794 GND nmos W=0.0975U L=0.065U
M2144_ #794 s #797 GND nmos W=0.0975U L=0.065U
M2145_ #799 inv__s n__O0__f_510_6 GND nmos W=0.0975U L=0.065U
M2146_ #802 w__0i n__O0__f_510_6 GND nmos W=0.0975U L=0.065U
M2147_keeper #1349 #fb1348# n__O0__f_510_6 Vdd pmos W=0.0975U L=0.065U
M2148_keeper #1350 #fb1348# n__O0__f_510_6 GND nmos W=0.0975U L=0.065U
M2149_ #800 I_af_510_6 #799 GND nmos W=0.0975U L=0.065U
M2150_ #799 s #802 GND nmos W=0.0975U L=0.065U
M2151_ #804 inv__s n__O1__t_510_6 GND nmos W=0.0975U L=0.065U
M2152_ #806 w__0i n__O1__t_510_6 GND nmos W=0.0975U L=0.065U
M2153_keeper #1352 #fb1351# n__O1__t_510_6 Vdd pmos W=0.0975U L=0.065U
M2154_keeper #1353 #fb1351# n__O1__t_510_6 GND nmos W=0.0975U L=0.065U
M2155_ #805 I_at_510_6 #804 GND nmos W=0.0975U L=0.065U
M2156_ #804 s #806 GND nmos W=0.0975U L=0.065U
M2157_ #808 inv__s n__O1__f_510_6 GND nmos W=0.0975U L=0.065U
M2158_ #810 w__0i n__O1__f_510_6 GND nmos W=0.0975U L=0.065U
M2159_keeper #1355 #fb1354# n__O1__f_510_6 Vdd pmos W=0.0975U L=0.065U
M2160_keeper #1356 #fb1354# n__O1__f_510_6 GND nmos W=0.0975U L=0.065U
M2161_ #809 I_af_510_6 #808 GND nmos W=0.0975U L=0.065U
M2162_ #808 s #810 GND nmos W=0.0975U L=0.065U
M2163_ #812 inv__s n__O0__t_511_6 GND nmos W=0.0975U L=0.065U
M2164_ #815 w__0i n__O0__t_511_6 GND nmos W=0.0975U L=0.065U
M2165_keeper #1358 #fb1357# n__O0__t_511_6 Vdd pmos W=0.0975U L=0.065U
M2166_keeper #1359 #fb1357# n__O0__t_511_6 GND nmos W=0.0975U L=0.065U
M2167_ #813 I_at_511_6 #812 GND nmos W=0.0975U L=0.065U
M2168_ #812 s #815 GND nmos W=0.0975U L=0.065U
M2169_ #817 inv__s n__O0__f_511_6 GND nmos W=0.0975U L=0.065U
M2170_ #820 w__0i n__O0__f_511_6 GND nmos W=0.0975U L=0.065U
M2171_keeper #1361 #fb1360# n__O0__f_511_6 Vdd pmos W=0.0975U L=0.065U
M2172_keeper #1362 #fb1360# n__O0__f_511_6 GND nmos W=0.0975U L=0.065U
M2173_ #818 I_af_511_6 #817 GND nmos W=0.0975U L=0.065U
M2174_ #817 s #820 GND nmos W=0.0975U L=0.065U
M2175_ #822 inv__s n__O1__t_511_6 GND nmos W=0.0975U L=0.065U
M2176_ #824 w__0i n__O1__t_511_6 GND nmos W=0.0975U L=0.065U
M2177_keeper #1364 #fb1363# n__O1__t_511_6 Vdd pmos W=0.0975U L=0.065U
M2178_keeper #1365 #fb1363# n__O1__t_511_6 GND nmos W=0.0975U L=0.065U
M2179_ #823 I_at_511_6 #822 GND nmos W=0.0975U L=0.065U
M2180_ #822 s #824 GND nmos W=0.0975U L=0.065U
M2181_ #826 inv__s n__O1__f_511_6 GND nmos W=0.0975U L=0.065U
M2182_ #828 w__0i n__O1__f_511_6 GND nmos W=0.0975U L=0.065U
M2183_keeper #1367 #fb1366# n__O1__f_511_6 Vdd pmos W=0.0975U L=0.065U
M2184_keeper #1368 #fb1366# n__O1__f_511_6 GND nmos W=0.0975U L=0.065U
M2185_ #827 I_af_511_6 #826 GND nmos W=0.0975U L=0.065U
M2186_ #826 s #828 GND nmos W=0.0975U L=0.065U
M2187_ #830 inv__s n__O0__t_512_6 GND nmos W=0.0975U L=0.065U
M2188_ #833 w__0i n__O0__t_512_6 GND nmos W=0.0975U L=0.065U
M2189_keeper #1370 #fb1369# n__O0__t_512_6 Vdd pmos W=0.0975U L=0.065U
M2190_keeper #1371 #fb1369# n__O0__t_512_6 GND nmos W=0.0975U L=0.065U
M2191_ #831 I_at_512_6 #830 GND nmos W=0.0975U L=0.065U
M2192_ #830 s #833 GND nmos W=0.0975U L=0.065U
M2193_ #835 inv__s n__O0__f_512_6 GND nmos W=0.0975U L=0.065U
M2194_ #838 w__0i n__O0__f_512_6 GND nmos W=0.0975U L=0.065U
M2195_keeper #1373 #fb1372# n__O0__f_512_6 Vdd pmos W=0.0975U L=0.065U
M2196_keeper #1374 #fb1372# n__O0__f_512_6 GND nmos W=0.0975U L=0.065U
M2197_ #836 I_af_512_6 #835 GND nmos W=0.0975U L=0.065U
M2198_ #835 s #838 GND nmos W=0.0975U L=0.065U
M2199_ #840 inv__s n__O1__t_512_6 GND nmos W=0.0975U L=0.065U
M2200_ #842 w__0i n__O1__t_512_6 GND nmos W=0.0975U L=0.065U
M2201_keeper #1376 #fb1375# n__O1__t_512_6 Vdd pmos W=0.0975U L=0.065U
M2202_keeper #1377 #fb1375# n__O1__t_512_6 GND nmos W=0.0975U L=0.065U
M2203_ #841 I_at_512_6 #840 GND nmos W=0.0975U L=0.065U
M2204_ #840 s #842 GND nmos W=0.0975U L=0.065U
M2205_ #844 inv__s n__O1__f_512_6 GND nmos W=0.0975U L=0.065U
M2206_ #846 w__0i n__O1__f_512_6 GND nmos W=0.0975U L=0.065U
M2207_keeper #1379 #fb1378# n__O1__f_512_6 Vdd pmos W=0.0975U L=0.065U
M2208_keeper #1380 #fb1378# n__O1__f_512_6 GND nmos W=0.0975U L=0.065U
M2209_ #845 I_af_512_6 #844 GND nmos W=0.0975U L=0.065U
M2210_ #844 s #846 GND nmos W=0.0975U L=0.065U
.ends
*---- end of process: UpdownSel<> -----
*
*---- act defproc: ChildSel<> -----
* raw ports:  reset I.t[0] I.t[1] I.t[2] I.t[3] I.t[4] I.t[5] I.t[6] I.t[7] I.t[8] I.t[9] I.t[10] I.t[11] I.t[12] I.t[13] I.t[14] I.t[15] I.t[16] I.t[17] I.t[18] I.t[19] I.t[20] I.t[21] I.t[22] I.t[23] I.t[24] I.t[25] I.t[26] I.t[27] I.t[28] I.t[29] I.t[30] I.t[31] I.f[0] I.f[1] I.f[2] I.f[3] I.f[4] I.f[5] I.f[6] I.f[7] I.f[8] I.f[9] I.f[10] I.f[11] I.f[12] I.f[13] I.f[14] I.f[15] I.f[16] I.f[17] I.f[18] I.f[19] I.f[20] I.f[21] I.f[22] I.f[23] I.f[24] I.f[25] I.f[26] I.f[27] I.f[28] I.f[29] I.f[30] I.f[31] I.a O0.t[0] O0.t[1] O0.t[2] O0.t[3] O0.t[4] O0.t[5] O0.t[6] O0.t[7] O0.t[8] O0.t[9] O0.t[10] O0.t[11] O0.t[12] O0.t[13] O0.t[14] O0.t[15] O0.t[16] O0.t[17] O0.t[18] O0.t[19] O0.t[20] O0.t[21] O0.t[22] O0.t[23] O0.t[24] O0.t[25] O0.t[26] O0.t[27] O0.t[28] O0.t[29] O0.t[30] O0.t[31] O0.f[0] O0.f[1] O0.f[2] O0.f[3] O0.f[4] O0.f[5] O0.f[6] O0.f[7] O0.f[8] O0.f[9] O0.f[10] O0.f[11] O0.f[12] O0.f[13] O0.f[14] O0.f[15] O0.f[16] O0.f[17] O0.f[18] O0.f[19] O0.f[20] O0.f[21] O0.f[22] O0.f[23] O0.f[24] O0.f[25] O0.f[26] O0.f[27] O0.f[28] O0.f[29] O0.f[30] O0.f[31] O0.a O1.t[0] O1.t[1] O1.t[2] O1.t[3] O1.t[4] O1.t[5] O1.t[6] O1.t[7] O1.t[8] O1.t[9] O1.t[10] O1.t[11] O1.t[12] O1.t[13] O1.t[14] O1.t[15] O1.t[16] O1.t[17] O1.t[18] O1.t[19] O1.t[20] O1.t[21] O1.t[22] O1.t[23] O1.t[24] O1.t[25] O1.t[26] O1.t[27] O1.t[28] O1.t[29] O1.t[30] O1.t[31] O1.f[0] O1.f[1] O1.f[2] O1.f[3] O1.f[4] O1.f[5] O1.f[6] O1.f[7] O1.f[8] O1.f[9] O1.f[10] O1.f[11] O1.f[12] O1.f[13] O1.f[14] O1.f[15] O1.f[16] O1.f[17] O1.f[18] O1.f[19] O1.f[20] O1.f[21] O1.f[22] O1.f[23] O1.f[24] O1.f[25] O1.f[26] O1.f[27] O1.f[28] O1.f[29] O1.f[30] O1.f[31] O1.a O2.t[0] O2.t[1] O2.t[2] O2.t[3] O2.t[4] O2.t[5] O2.t[6] O2.t[7] O2.t[8] O2.t[9] O2.t[10] O2.t[11] O2.t[12] O2.t[13] O2.t[14] O2.t[15] O2.t[16] O2.t[17] O2.t[18] O2.t[19] O2.t[20] O2.t[21] O2.t[22] O2.t[23] O2.t[24] O2.t[25] O2.t[26] O2.t[27] O2.t[28] O2.t[29] O2.t[30] O2.t[31] O2.f[0] O2.f[1] O2.f[2] O2.f[3] O2.f[4] O2.f[5] O2.f[6] O2.f[7] O2.f[8] O2.f[9] O2.f[10] O2.f[11] O2.f[12] O2.f[13] O2.f[14] O2.f[15] O2.f[16] O2.f[17] O2.f[18] O2.f[19] O2.f[20] O2.f[21] O2.f[22] O2.f[23] O2.f[24] O2.f[25] O2.f[26] O2.f[27] O2.f[28] O2.f[29] O2.f[30] O2.f[31] O2.a O3.t[0] O3.t[1] O3.t[2] O3.t[3] O3.t[4] O3.t[5] O3.t[6] O3.t[7] O3.t[8] O3.t[9] O3.t[10] O3.t[11] O3.t[12] O3.t[13] O3.t[14] O3.t[15] O3.t[16] O3.t[17] O3.t[18] O3.t[19] O3.t[20] O3.t[21] O3.t[22] O3.t[23] O3.t[24] O3.t[25] O3.t[26] O3.t[27] O3.t[28] O3.t[29] O3.t[30] O3.t[31] O3.f[0] O3.f[1] O3.f[2] O3.f[3] O3.f[4] O3.f[5] O3.f[6] O3.f[7] O3.f[8] O3.f[9] O3.f[10] O3.f[11] O3.f[12] O3.f[13] O3.f[14] O3.f[15] O3.f[16] O3.f[17] O3.f[18] O3.f[19] O3.f[20] O3.f[21] O3.f[22] O3.f[23] O3.f[24] O3.f[25] O3.f[26] O3.f[27] O3.f[28] O3.f[29] O3.f[30] O3.f[31] O3.a
*
.subckt ChildSel reset I_at_50_6 I_at_51_6 I_at_52_6 I_at_53_6 I_at_54_6 I_at_55_6 I_at_56_6 I_at_57_6 I_at_58_6 I_at_59_6 I_at_510_6 I_at_511_6 I_at_512_6 I_at_513_6 I_at_514_6 I_at_515_6 I_at_516_6 I_at_517_6 I_at_518_6 I_at_519_6 I_at_520_6 I_at_521_6 I_at_522_6 I_at_523_6 I_at_524_6 I_at_525_6 I_at_526_6 I_at_527_6 I_at_528_6 I_at_529_6 I_at_530_6 I_at_531_6 I_af_50_6 I_af_51_6 I_af_52_6 I_af_53_6 I_af_54_6 I_af_55_6 I_af_56_6 I_af_57_6 I_af_58_6 I_af_59_6 I_af_510_6 I_af_511_6 I_af_512_6 I_af_513_6 I_af_514_6 I_af_515_6 I_af_516_6 I_af_517_6 I_af_518_6 I_af_519_6 I_af_520_6 I_af_521_6 I_af_522_6 I_af_523_6 I_af_524_6 I_af_525_6 I_af_526_6 I_af_527_6 I_af_528_6 I_af_529_6 I_af_530_6 I_af_531_6 I_aa O0_at_50_6 O0_at_51_6 O0_at_52_6 O0_at_53_6 O0_at_54_6 O0_at_55_6 O0_at_56_6 O0_at_57_6 O0_at_58_6 O0_at_59_6 O0_at_510_6 O0_at_511_6 O0_at_512_6 O0_at_513_6 O0_at_514_6 O0_at_515_6 O0_at_516_6 O0_at_517_6 O0_at_518_6 O0_at_519_6 O0_at_520_6 O0_at_521_6 O0_at_522_6 O0_at_523_6 O0_at_524_6 O0_at_525_6 O0_at_526_6 O0_at_527_6 O0_at_528_6 O0_at_529_6 O0_at_530_6 O0_at_531_6 O0_af_50_6 O0_af_51_6 O0_af_52_6 O0_af_53_6 O0_af_54_6 O0_af_55_6 O0_af_56_6 O0_af_57_6 O0_af_58_6 O0_af_59_6 O0_af_510_6 O0_af_511_6 O0_af_512_6 O0_af_513_6 O0_af_514_6 O0_af_515_6 O0_af_516_6 O0_af_517_6 O0_af_518_6 O0_af_519_6 O0_af_520_6 O0_af_521_6 O0_af_522_6 O0_af_523_6 O0_af_524_6 O0_af_525_6 O0_af_526_6 O0_af_527_6 O0_af_528_6 O0_af_529_6 O0_af_530_6 O0_af_531_6 O0_aa O1_at_50_6 O1_at_51_6 O1_at_52_6 O1_at_53_6 O1_at_54_6 O1_at_55_6 O1_at_56_6 O1_at_57_6 O1_at_58_6 O1_at_59_6 O1_at_510_6 O1_at_511_6 O1_at_512_6 O1_at_513_6 O1_at_514_6 O1_at_515_6 O1_at_516_6 O1_at_517_6 O1_at_518_6 O1_at_519_6 O1_at_520_6 O1_at_521_6 O1_at_522_6 O1_at_523_6 O1_at_524_6 O1_at_525_6 O1_at_526_6 O1_at_527_6 O1_at_528_6 O1_at_529_6 O1_at_530_6 O1_at_531_6 O1_af_50_6 O1_af_51_6 O1_af_52_6 O1_af_53_6 O1_af_54_6 O1_af_55_6 O1_af_56_6 O1_af_57_6 O1_af_58_6 O1_af_59_6 O1_af_510_6 O1_af_511_6 O1_af_512_6 O1_af_513_6 O1_af_514_6 O1_af_515_6 O1_af_516_6 O1_af_517_6 O1_af_518_6 O1_af_519_6 O1_af_520_6 O1_af_521_6 O1_af_522_6 O1_af_523_6 O1_af_524_6 O1_af_525_6 O1_af_526_6 O1_af_527_6 O1_af_528_6 O1_af_529_6 O1_af_530_6 O1_af_531_6 O1_aa O2_at_50_6 O2_at_51_6 O2_at_52_6 O2_at_53_6 O2_at_54_6 O2_at_55_6 O2_at_56_6 O2_at_57_6 O2_at_58_6 O2_at_59_6 O2_at_510_6 O2_at_511_6 O2_at_512_6 O2_at_513_6 O2_at_514_6 O2_at_515_6 O2_at_516_6 O2_at_517_6 O2_at_518_6 O2_at_519_6 O2_at_520_6 O2_at_521_6 O2_at_522_6 O2_at_523_6 O2_at_524_6 O2_at_525_6 O2_at_526_6 O2_at_527_6 O2_at_528_6 O2_at_529_6 O2_at_530_6 O2_at_531_6 O2_af_50_6 O2_af_51_6 O2_af_52_6 O2_af_53_6 O2_af_54_6 O2_af_55_6 O2_af_56_6 O2_af_57_6 O2_af_58_6 O2_af_59_6 O2_af_510_6 O2_af_511_6 O2_af_512_6 O2_af_513_6 O2_af_514_6 O2_af_515_6 O2_af_516_6 O2_af_517_6 O2_af_518_6 O2_af_519_6 O2_af_520_6 O2_af_521_6 O2_af_522_6 O2_af_523_6 O2_af_524_6 O2_af_525_6 O2_af_526_6 O2_af_527_6 O2_af_528_6 O2_af_529_6 O2_af_530_6 O2_af_531_6 O2_aa O3_at_50_6 O3_at_51_6 O3_at_52_6 O3_at_53_6 O3_at_54_6 O3_at_55_6 O3_at_56_6 O3_at_57_6 O3_at_58_6 O3_at_59_6 O3_at_510_6 O3_at_511_6 O3_at_512_6 O3_at_513_6 O3_at_514_6 O3_at_515_6 O3_at_516_6 O3_at_517_6 O3_at_518_6 O3_at_519_6 O3_at_520_6 O3_at_521_6 O3_at_522_6 O3_at_523_6 O3_at_524_6 O3_at_525_6 O3_at_526_6 O3_at_527_6 O3_at_528_6 O3_at_529_6 O3_at_530_6 O3_at_531_6 O3_af_50_6 O3_af_51_6 O3_af_52_6 O3_af_53_6 O3_af_54_6 O3_af_55_6 O3_af_56_6 O3_af_57_6 O3_af_58_6 O3_af_59_6 O3_af_510_6 O3_af_511_6 O3_af_512_6 O3_af_513_6 O3_af_514_6 O3_af_515_6 O3_af_516_6 O3_af_517_6 O3_af_518_6 O3_af_519_6 O3_af_520_6 O3_af_521_6 O3_af_522_6 O3_af_523_6 O3_af_524_6 O3_af_525_6 O3_af_526_6 O3_af_527_6 O3_af_528_6 O3_af_529_6 O3_af_530_6 O3_af_531_6 O3_aa
*.PININFO reset:I I_at_50_6:I I_at_51_6:I I_at_52_6:I I_at_53_6:I I_at_54_6:I I_at_55_6:I I_at_56_6:I I_at_57_6:I I_at_58_6:I I_at_59_6:I I_at_510_6:I I_at_511_6:I I_at_512_6:I I_at_513_6:I I_at_514_6:I I_at_515_6:I I_at_516_6:I I_at_517_6:I I_at_518_6:I I_at_519_6:I I_at_520_6:I I_at_521_6:I I_at_522_6:I I_at_523_6:I I_at_524_6:I I_at_525_6:I I_at_526_6:I I_at_527_6:I I_at_528_6:I I_at_529_6:I I_at_530_6:I I_at_531_6:I I_af_50_6:I I_af_51_6:I I_af_52_6:I I_af_53_6:I I_af_54_6:I I_af_55_6:I I_af_56_6:I I_af_57_6:I I_af_58_6:I I_af_59_6:I I_af_510_6:I I_af_511_6:I I_af_512_6:I I_af_513_6:I I_af_514_6:I I_af_515_6:I I_af_516_6:I I_af_517_6:I I_af_518_6:I I_af_519_6:I I_af_520_6:I I_af_521_6:I I_af_522_6:I I_af_523_6:I I_af_524_6:I I_af_525_6:I I_af_526_6:I I_af_527_6:I I_af_528_6:I I_af_529_6:I I_af_530_6:I I_af_531_6:I I_aa:O O0_at_50_6:O O0_at_51_6:O O0_at_52_6:O O0_at_53_6:O O0_at_54_6:O O0_at_55_6:O O0_at_56_6:O O0_at_57_6:O O0_at_58_6:O O0_at_59_6:O O0_at_510_6:O O0_at_511_6:O O0_at_512_6:O O0_at_513_6:O O0_at_514_6:O O0_at_515_6:O O0_at_516_6:O O0_at_517_6:O O0_at_518_6:O O0_at_519_6:O O0_at_520_6:O O0_at_521_6:O O0_at_522_6:O O0_at_523_6:O O0_at_524_6:O O0_at_525_6:O O0_at_526_6:O O0_at_527_6:O O0_at_528_6:O O0_at_529_6:O O0_at_530_6:O O0_at_531_6:O O0_af_50_6:O O0_af_51_6:O O0_af_52_6:O O0_af_53_6:O O0_af_54_6:O O0_af_55_6:O O0_af_56_6:O O0_af_57_6:O O0_af_58_6:O O0_af_59_6:O O0_af_510_6:O O0_af_511_6:O O0_af_512_6:O O0_af_513_6:O O0_af_514_6:O O0_af_515_6:O O0_af_516_6:O O0_af_517_6:O O0_af_518_6:O O0_af_519_6:O O0_af_520_6:O O0_af_521_6:O O0_af_522_6:O O0_af_523_6:O O0_af_524_6:O O0_af_525_6:O O0_af_526_6:O O0_af_527_6:O O0_af_528_6:O O0_af_529_6:O O0_af_530_6:O O0_af_531_6:O O0_aa:I O1_at_50_6:O O1_at_51_6:O O1_at_52_6:O O1_at_53_6:O O1_at_54_6:O O1_at_55_6:O O1_at_56_6:O O1_at_57_6:O O1_at_58_6:O O1_at_59_6:O O1_at_510_6:O O1_at_511_6:O O1_at_512_6:O O1_at_513_6:O O1_at_514_6:O O1_at_515_6:O O1_at_516_6:O O1_at_517_6:O O1_at_518_6:O O1_at_519_6:O O1_at_520_6:O O1_at_521_6:O O1_at_522_6:O O1_at_523_6:O O1_at_524_6:O O1_at_525_6:O O1_at_526_6:O O1_at_527_6:O O1_at_528_6:O O1_at_529_6:O O1_at_530_6:O O1_at_531_6:O O1_af_50_6:O O1_af_51_6:O O1_af_52_6:O O1_af_53_6:O O1_af_54_6:O O1_af_55_6:O O1_af_56_6:O O1_af_57_6:O O1_af_58_6:O O1_af_59_6:O O1_af_510_6:O O1_af_511_6:O O1_af_512_6:O O1_af_513_6:O O1_af_514_6:O O1_af_515_6:O O1_af_516_6:O O1_af_517_6:O O1_af_518_6:O O1_af_519_6:O O1_af_520_6:O O1_af_521_6:O O1_af_522_6:O O1_af_523_6:O O1_af_524_6:O O1_af_525_6:O O1_af_526_6:O O1_af_527_6:O O1_af_528_6:O O1_af_529_6:O O1_af_530_6:O O1_af_531_6:O O1_aa:I O2_at_50_6:O O2_at_51_6:O O2_at_52_6:O O2_at_53_6:O O2_at_54_6:O O2_at_55_6:O O2_at_56_6:O O2_at_57_6:O O2_at_58_6:O O2_at_59_6:O O2_at_510_6:O O2_at_511_6:O O2_at_512_6:O O2_at_513_6:O O2_at_514_6:O O2_at_515_6:O O2_at_516_6:O O2_at_517_6:O O2_at_518_6:O O2_at_519_6:O O2_at_520_6:O O2_at_521_6:O O2_at_522_6:O O2_at_523_6:O O2_at_524_6:O O2_at_525_6:O O2_at_526_6:O O2_at_527_6:O O2_at_528_6:O O2_at_529_6:O O2_at_530_6:O O2_at_531_6:O O2_af_50_6:O O2_af_51_6:O O2_af_52_6:O O2_af_53_6:O O2_af_54_6:O O2_af_55_6:O O2_af_56_6:O O2_af_57_6:O O2_af_58_6:O O2_af_59_6:O O2_af_510_6:O O2_af_511_6:O O2_af_512_6:O O2_af_513_6:O O2_af_514_6:O O2_af_515_6:O O2_af_516_6:O O2_af_517_6:O O2_af_518_6:O O2_af_519_6:O O2_af_520_6:O O2_af_521_6:O O2_af_522_6:O O2_af_523_6:O O2_af_524_6:O O2_af_525_6:O O2_af_526_6:O O2_af_527_6:O O2_af_528_6:O O2_af_529_6:O O2_af_530_6:O O2_af_531_6:O O2_aa:I O3_at_50_6:O O3_at_51_6:O O3_at_52_6:O O3_at_53_6:O O3_at_54_6:O O3_at_55_6:O O3_at_56_6:O O3_at_57_6:O O3_at_58_6:O O3_at_59_6:O O3_at_510_6:O O3_at_511_6:O O3_at_512_6:O O3_at_513_6:O O3_at_514_6:O O3_at_515_6:O O3_at_516_6:O O3_at_517_6:O O3_at_518_6:O O3_at_519_6:O O3_at_520_6:O O3_at_521_6:O O3_at_522_6:O O3_at_523_6:O O3_at_524_6:O O3_at_525_6:O O3_at_526_6:O O3_at_527_6:O O3_at_528_6:O O3_at_529_6:O O3_at_530_6:O O3_at_531_6:O O3_af_50_6:O O3_af_51_6:O O3_af_52_6:O O3_af_53_6:O O3_af_54_6:O O3_af_55_6:O O3_af_56_6:O O3_af_57_6:O O3_af_58_6:O O3_af_59_6:O O3_af_510_6:O O3_af_511_6:O O3_af_512_6:O O3_af_513_6:O O3_af_514_6:O O3_af_515_6:O O3_af_516_6:O O3_af_517_6:O O3_af_518_6:O O3_af_519_6:O O3_af_520_6:O O3_af_521_6:O O3_af_522_6:O O3_af_523_6:O O3_af_524_6:O O3_af_525_6:O O3_af_526_6:O O3_af_527_6:O O3_af_528_6:O O3_af_529_6:O O3_af_530_6:O O3_af_531_6:O O3_aa:I
*.POWER VDD Vdd
*.POWER GND GND
*.POWER NSUB GND
*.POWER PSUB Vdd
xright reset root_aO1_at_50_6 root_aO1_at_51_6 root_aO1_at_52_6 root_aO1_at_53_6 root_aO1_at_54_6 root_aO1_at_55_6 root_aO1_at_56_6 root_aO1_at_57_6 root_aO1_at_58_6 root_aO1_at_59_6 root_aO1_at_510_6 root_aO1_at_511_6 root_aO1_at_512_6 root_aO1_at_513_6 root_aO1_at_514_6 root_aO1_at_515_6 root_aO1_at_516_6 root_aO1_at_517_6 root_aO1_at_518_6 root_aO1_at_519_6 root_aO1_at_520_6 root_aO1_at_521_6 root_aO1_at_522_6 root_aO1_at_523_6 root_aO1_at_524_6 root_aO1_at_525_6 root_aO1_at_526_6 root_aO1_at_527_6 root_aO1_at_528_6 root_aO1_at_529_6 root_aO1_at_530_6 root_aO1_at_531_6 root_aO1_af_50_6 root_aO1_af_51_6 root_aO1_af_52_6 root_aO1_af_53_6 root_aO1_af_54_6 root_aO1_af_55_6 root_aO1_af_56_6 root_aO1_af_57_6 root_aO1_af_58_6 root_aO1_af_59_6 root_aO1_af_510_6 root_aO1_af_511_6 root_aO1_af_512_6 root_aO1_af_513_6 root_aO1_af_514_6 root_aO1_af_515_6 root_aO1_af_516_6 root_aO1_af_517_6 root_aO1_af_518_6 root_aO1_af_519_6 root_aO1_af_520_6 root_aO1_af_521_6 root_aO1_af_522_6 root_aO1_af_523_6 root_aO1_af_524_6 root_aO1_af_525_6 root_aO1_af_526_6 root_aO1_af_527_6 root_aO1_af_528_6 root_aO1_af_529_6 root_aO1_af_530_6 root_aO1_af_531_6 root_aO1_aa O1_at_50_6 O1_at_51_6 O1_at_52_6 O1_at_53_6 O1_at_54_6 O1_at_55_6 O1_at_56_6 O1_at_57_6 O1_at_58_6 O1_at_59_6 O1_at_510_6 O1_at_511_6 O1_at_512_6 O1_at_513_6 O1_at_514_6 O1_at_515_6 O1_at_516_6 O1_at_517_6 O1_at_518_6 O1_at_519_6 O1_at_520_6 O1_at_521_6 O1_at_522_6 O1_at_523_6 O1_at_524_6 O1_at_525_6 O1_at_526_6 O1_at_527_6 O1_at_528_6 O1_at_529_6 O1_at_530_6 O1_at_531_6 O1_af_50_6 O1_af_51_6 O1_af_52_6 O1_af_53_6 O1_af_54_6 O1_af_55_6 O1_af_56_6 O1_af_57_6 O1_af_58_6 O1_af_59_6 O1_af_510_6 O1_af_511_6 O1_af_512_6 O1_af_513_6 O1_af_514_6 O1_af_515_6 O1_af_516_6 O1_af_517_6 O1_af_518_6 O1_af_519_6 O1_af_520_6 O1_af_521_6 O1_af_522_6 O1_af_523_6 O1_af_524_6 O1_af_525_6 O1_af_526_6 O1_af_527_6 O1_af_528_6 O1_af_529_6 O1_af_530_6 O1_af_531_6 O1_aa O0_at_50_6 O0_at_51_6 O0_at_52_6 O0_at_53_6 O0_at_54_6 O0_at_55_6 O0_at_56_6 O0_at_57_6 O0_at_58_6 O0_at_59_6 O0_at_510_6 O0_at_511_6 O0_at_512_6 O0_at_513_6 O0_at_514_6 O0_at_515_6 O0_at_516_6 O0_at_517_6 O0_at_518_6 O0_at_519_6 O0_at_520_6 O0_at_521_6 O0_at_522_6 O0_at_523_6 O0_at_524_6 O0_at_525_6 O0_at_526_6 O0_at_527_6 O0_at_528_6 O0_at_529_6 O0_at_530_6 O0_at_531_6 O0_af_50_6 O0_af_51_6 O0_af_52_6 O0_af_53_6 O0_af_54_6 O0_af_55_6 O0_af_56_6 O0_af_57_6 O0_af_58_6 O0_af_59_6 O0_af_510_6 O0_af_511_6 O0_af_512_6 O0_af_513_6 O0_af_514_6 O0_af_515_6 O0_af_516_6 O0_af_517_6 O0_af_518_6 O0_af_519_6 O0_af_520_6 O0_af_521_6 O0_af_522_6 O0_af_523_6 O0_af_524_6 O0_af_525_6 O0_af_526_6 O0_af_527_6 O0_af_528_6 O0_af_529_6 O0_af_530_6 O0_af_531_6 O0_aa UpdownSel
xroot reset I_at_50_6 I_at_51_6 I_at_52_6 I_at_53_6 I_at_54_6 I_at_55_6 I_at_56_6 I_at_57_6 I_at_58_6 I_at_59_6 I_at_510_6 I_at_511_6 I_at_512_6 I_at_513_6 I_at_514_6 I_at_515_6 I_at_516_6 I_at_517_6 I_at_518_6 I_at_519_6 I_at_520_6 I_at_521_6 I_at_522_6 I_at_523_6 I_at_524_6 I_at_525_6 I_at_526_6 I_at_527_6 I_at_528_6 I_at_529_6 I_at_530_6 I_at_531_6 I_af_50_6 I_af_51_6 I_af_52_6 I_af_53_6 I_af_54_6 I_af_55_6 I_af_56_6 I_af_57_6 I_af_58_6 I_af_59_6 I_af_510_6 I_af_511_6 I_af_512_6 I_af_513_6 I_af_514_6 I_af_515_6 I_af_516_6 I_af_517_6 I_af_518_6 I_af_519_6 I_af_520_6 I_af_521_6 I_af_522_6 I_af_523_6 I_af_524_6 I_af_525_6 I_af_526_6 I_af_527_6 I_af_528_6 I_af_529_6 I_af_530_6 I_af_531_6 I_aa left_aI_at_50_6 left_aI_at_51_6 left_aI_at_52_6 left_aI_at_53_6 left_aI_at_54_6 left_aI_at_55_6 left_aI_at_56_6 left_aI_at_57_6 left_aI_at_58_6 left_aI_at_59_6 left_aI_at_510_6 left_aI_at_511_6 left_aI_at_512_6 left_aI_at_513_6 left_aI_at_514_6 left_aI_at_515_6 left_aI_at_516_6 left_aI_at_517_6 left_aI_at_518_6 left_aI_at_519_6 left_aI_at_520_6 left_aI_at_521_6 left_aI_at_522_6 left_aI_at_523_6 left_aI_at_524_6 left_aI_at_525_6 left_aI_at_526_6 left_aI_at_527_6 left_aI_at_528_6 left_aI_at_529_6 left_aI_at_530_6 left_aI_at_531_6 left_aI_af_50_6 left_aI_af_51_6 left_aI_af_52_6 left_aI_af_53_6 left_aI_af_54_6 left_aI_af_55_6 left_aI_af_56_6 left_aI_af_57_6 left_aI_af_58_6 left_aI_af_59_6 left_aI_af_510_6 left_aI_af_511_6 left_aI_af_512_6 left_aI_af_513_6 left_aI_af_514_6 left_aI_af_515_6 left_aI_af_516_6 left_aI_af_517_6 left_aI_af_518_6 left_aI_af_519_6 left_aI_af_520_6 left_aI_af_521_6 left_aI_af_522_6 left_aI_af_523_6 left_aI_af_524_6 left_aI_af_525_6 left_aI_af_526_6 left_aI_af_527_6 left_aI_af_528_6 left_aI_af_529_6 left_aI_af_530_6 left_aI_af_531_6 left_aI_aa root_aO1_at_50_6 root_aO1_at_51_6 root_aO1_at_52_6 root_aO1_at_53_6 root_aO1_at_54_6 root_aO1_at_55_6 root_aO1_at_56_6 root_aO1_at_57_6 root_aO1_at_58_6 root_aO1_at_59_6 root_aO1_at_510_6 root_aO1_at_511_6 root_aO1_at_512_6 root_aO1_at_513_6 root_aO1_at_514_6 root_aO1_at_515_6 root_aO1_at_516_6 root_aO1_at_517_6 root_aO1_at_518_6 root_aO1_at_519_6 root_aO1_at_520_6 root_aO1_at_521_6 root_aO1_at_522_6 root_aO1_at_523_6 root_aO1_at_524_6 root_aO1_at_525_6 root_aO1_at_526_6 root_aO1_at_527_6 root_aO1_at_528_6 root_aO1_at_529_6 root_aO1_at_530_6 root_aO1_at_531_6 root_aO1_af_50_6 root_aO1_af_51_6 root_aO1_af_52_6 root_aO1_af_53_6 root_aO1_af_54_6 root_aO1_af_55_6 root_aO1_af_56_6 root_aO1_af_57_6 root_aO1_af_58_6 root_aO1_af_59_6 root_aO1_af_510_6 root_aO1_af_511_6 root_aO1_af_512_6 root_aO1_af_513_6 root_aO1_af_514_6 root_aO1_af_515_6 root_aO1_af_516_6 root_aO1_af_517_6 root_aO1_af_518_6 root_aO1_af_519_6 root_aO1_af_520_6 root_aO1_af_521_6 root_aO1_af_522_6 root_aO1_af_523_6 root_aO1_af_524_6 root_aO1_af_525_6 root_aO1_af_526_6 root_aO1_af_527_6 root_aO1_af_528_6 root_aO1_af_529_6 root_aO1_af_530_6 root_aO1_af_531_6 root_aO1_aa UpdownSel
xleft reset left_aI_at_50_6 left_aI_at_51_6 left_aI_at_52_6 left_aI_at_53_6 left_aI_at_54_6 left_aI_at_55_6 left_aI_at_56_6 left_aI_at_57_6 left_aI_at_58_6 left_aI_at_59_6 left_aI_at_510_6 left_aI_at_511_6 left_aI_at_512_6 left_aI_at_513_6 left_aI_at_514_6 left_aI_at_515_6 left_aI_at_516_6 left_aI_at_517_6 left_aI_at_518_6 left_aI_at_519_6 left_aI_at_520_6 left_aI_at_521_6 left_aI_at_522_6 left_aI_at_523_6 left_aI_at_524_6 left_aI_at_525_6 left_aI_at_526_6 left_aI_at_527_6 left_aI_at_528_6 left_aI_at_529_6 left_aI_at_530_6 left_aI_at_531_6 left_aI_af_50_6 left_aI_af_51_6 left_aI_af_52_6 left_aI_af_53_6 left_aI_af_54_6 left_aI_af_55_6 left_aI_af_56_6 left_aI_af_57_6 left_aI_af_58_6 left_aI_af_59_6 left_aI_af_510_6 left_aI_af_511_6 left_aI_af_512_6 left_aI_af_513_6 left_aI_af_514_6 left_aI_af_515_6 left_aI_af_516_6 left_aI_af_517_6 left_aI_af_518_6 left_aI_af_519_6 left_aI_af_520_6 left_aI_af_521_6 left_aI_af_522_6 left_aI_af_523_6 left_aI_af_524_6 left_aI_af_525_6 left_aI_af_526_6 left_aI_af_527_6 left_aI_af_528_6 left_aI_af_529_6 left_aI_af_530_6 left_aI_af_531_6 left_aI_aa O3_at_50_6 O3_at_51_6 O3_at_52_6 O3_at_53_6 O3_at_54_6 O3_at_55_6 O3_at_56_6 O3_at_57_6 O3_at_58_6 O3_at_59_6 O3_at_510_6 O3_at_511_6 O3_at_512_6 O3_at_513_6 O3_at_514_6 O3_at_515_6 O3_at_516_6 O3_at_517_6 O3_at_518_6 O3_at_519_6 O3_at_520_6 O3_at_521_6 O3_at_522_6 O3_at_523_6 O3_at_524_6 O3_at_525_6 O3_at_526_6 O3_at_527_6 O3_at_528_6 O3_at_529_6 O3_at_530_6 O3_at_531_6 O3_af_50_6 O3_af_51_6 O3_af_52_6 O3_af_53_6 O3_af_54_6 O3_af_55_6 O3_af_56_6 O3_af_57_6 O3_af_58_6 O3_af_59_6 O3_af_510_6 O3_af_511_6 O3_af_512_6 O3_af_513_6 O3_af_514_6 O3_af_515_6 O3_af_516_6 O3_af_517_6 O3_af_518_6 O3_af_519_6 O3_af_520_6 O3_af_521_6 O3_af_522_6 O3_af_523_6 O3_af_524_6 O3_af_525_6 O3_af_526_6 O3_af_527_6 O3_af_528_6 O3_af_529_6 O3_af_530_6 O3_af_531_6 O3_aa O2_at_50_6 O2_at_51_6 O2_at_52_6 O2_at_53_6 O2_at_54_6 O2_at_55_6 O2_at_56_6 O2_at_57_6 O2_at_58_6 O2_at_59_6 O2_at_510_6 O2_at_511_6 O2_at_512_6 O2_at_513_6 O2_at_514_6 O2_at_515_6 O2_at_516_6 O2_at_517_6 O2_at_518_6 O2_at_519_6 O2_at_520_6 O2_at_521_6 O2_at_522_6 O2_at_523_6 O2_at_524_6 O2_at_525_6 O2_at_526_6 O2_at_527_6 O2_at_528_6 O2_at_529_6 O2_at_530_6 O2_at_531_6 O2_af_50_6 O2_af_51_6 O2_af_52_6 O2_af_53_6 O2_af_54_6 O2_af_55_6 O2_af_56_6 O2_af_57_6 O2_af_58_6 O2_af_59_6 O2_af_510_6 O2_af_511_6 O2_af_512_6 O2_af_513_6 O2_af_514_6 O2_af_515_6 O2_af_516_6 O2_af_517_6 O2_af_518_6 O2_af_519_6 O2_af_520_6 O2_af_521_6 O2_af_522_6 O2_af_523_6 O2_af_524_6 O2_af_525_6 O2_af_526_6 O2_af_527_6 O2_af_528_6 O2_af_529_6 O2_af_530_6 O2_af_531_6 O2_aa UpdownSel
.ends
*---- end of process: ChildSel<> -----
*
*---- act defproc: StopcodeSel<> -----
* raw ports:  reset I.t[0] I.t[1] I.t[2] I.t[3] I.t[4] I.t[5] I.t[6] I.t[7] I.t[8] I.t[9] I.t[10] I.t[11] I.t[12] I.t[13] I.t[14] I.t[15] I.t[16] I.t[17] I.t[18] I.t[19] I.t[20] I.t[21] I.t[22] I.t[23] I.t[24] I.t[25] I.t[26] I.t[27] I.t[28] I.t[29] I.t[30] I.t[31] I.f[0] I.f[1] I.f[2] I.f[3] I.f[4] I.f[5] I.f[6] I.f[7] I.f[8] I.f[9] I.f[10] I.f[11] I.f[12] I.f[13] I.f[14] I.f[15] I.f[16] I.f[17] I.f[18] I.f[19] I.f[20] I.f[21] I.f[22] I.f[23] I.f[24] I.f[25] I.f[26] I.f[27] I.f[28] I.f[29] I.f[30] I.f[31] I.a O0.t[0] O0.t[1] O0.t[2] O0.t[3] O0.t[4] O0.t[5] O0.t[6] O0.t[7] O0.t[8] O0.t[9] O0.t[10] O0.t[11] O0.t[12] O0.t[13] O0.t[14] O0.t[15] O0.t[16] O0.t[17] O0.t[18] O0.t[19] O0.t[20] O0.t[21] O0.t[22] O0.t[23] O0.t[24] O0.t[25] O0.t[26] O0.t[27] O0.t[28] O0.t[29] O0.t[30] O0.t[31] O0.f[0] O0.f[1] O0.f[2] O0.f[3] O0.f[4] O0.f[5] O0.f[6] O0.f[7] O0.f[8] O0.f[9] O0.f[10] O0.f[11] O0.f[12] O0.f[13] O0.f[14] O0.f[15] O0.f[16] O0.f[17] O0.f[18] O0.f[19] O0.f[20] O0.f[21] O0.f[22] O0.f[23] O0.f[24] O0.f[25] O0.f[26] O0.f[27] O0.f[28] O0.f[29] O0.f[30] O0.f[31] O0.a O1.t[0] O1.t[1] O1.t[2] O1.t[3] O1.t[4] O1.t[5] O1.t[6] O1.t[7] O1.t[8] O1.t[9] O1.t[10] O1.t[11] O1.t[12] O1.t[13] O1.t[14] O1.t[15] O1.t[16] O1.t[17] O1.t[18] O1.t[19] O1.t[20] O1.t[21] O1.t[22] O1.t[23] O1.t[24] O1.t[25] O1.t[26] O1.t[27] O1.t[28] O1.t[29] O1.t[30] O1.t[31] O1.f[0] O1.f[1] O1.f[2] O1.f[3] O1.f[4] O1.f[5] O1.f[6] O1.f[7] O1.f[8] O1.f[9] O1.f[10] O1.f[11] O1.f[12] O1.f[13] O1.f[14] O1.f[15] O1.f[16] O1.f[17] O1.f[18] O1.f[19] O1.f[20] O1.f[21] O1.f[22] O1.f[23] O1.f[24] O1.f[25] O1.f[26] O1.f[27] O1.f[28] O1.f[29] O1.f[30] O1.f[31] O1.a
*
.subckt StopcodeSel reset I_at_50_6 I_at_51_6 I_at_52_6 I_at_53_6 I_at_54_6 I_at_55_6 I_at_56_6 I_at_57_6 I_at_58_6 I_at_59_6 I_at_510_6 I_at_511_6 I_at_512_6 I_at_513_6 I_at_514_6 I_at_515_6 I_at_516_6 I_at_517_6 I_at_518_6 I_at_519_6 I_at_520_6 I_at_521_6 I_at_522_6 I_at_523_6 I_at_524_6 I_at_525_6 I_at_526_6 I_at_527_6 I_at_528_6 I_at_529_6 I_at_530_6 I_at_531_6 I_af_50_6 I_af_51_6 I_af_52_6 I_af_53_6 I_af_54_6 I_af_55_6 I_af_56_6 I_af_57_6 I_af_58_6 I_af_59_6 I_af_510_6 I_af_511_6 I_af_512_6 I_af_513_6 I_af_514_6 I_af_515_6 I_af_516_6 I_af_517_6 I_af_518_6 I_af_519_6 I_af_520_6 I_af_521_6 I_af_522_6 I_af_523_6 I_af_524_6 I_af_525_6 I_af_526_6 I_af_527_6 I_af_528_6 I_af_529_6 I_af_530_6 I_af_531_6 I_aa O0_at_50_6 O0_at_51_6 O0_at_52_6 O0_at_53_6 O0_at_54_6 O0_at_55_6 O0_at_56_6 O0_at_57_6 O0_at_58_6 O0_at_59_6 O0_at_510_6 O0_at_511_6 O0_at_512_6 O0_at_513_6 O0_at_514_6 O0_at_515_6 O0_at_516_6 O0_at_517_6 O0_at_518_6 O0_at_519_6 O0_at_520_6 O0_at_521_6 O0_at_522_6 O0_at_523_6 O0_at_524_6 O0_at_525_6 O0_at_526_6 O0_at_527_6 O0_at_528_6 O0_at_529_6 O0_at_530_6 O0_at_531_6 O0_af_50_6 O0_af_51_6 O0_af_52_6 O0_af_53_6 O0_af_54_6 O0_af_55_6 O0_af_56_6 O0_af_57_6 O0_af_58_6 O0_af_59_6 O0_af_510_6 O0_af_511_6 O0_af_512_6 O0_af_513_6 O0_af_514_6 O0_af_515_6 O0_af_516_6 O0_af_517_6 O0_af_518_6 O0_af_519_6 O0_af_520_6 O0_af_521_6 O0_af_522_6 O0_af_523_6 O0_af_524_6 O0_af_525_6 O0_af_526_6 O0_af_527_6 O0_af_528_6 O0_af_529_6 O0_af_530_6 O0_af_531_6 O0_aa O1_at_50_6 O1_at_51_6 O1_at_52_6 O1_at_53_6 O1_at_54_6 O1_at_55_6 O1_at_56_6 O1_at_57_6 O1_at_58_6 O1_at_59_6 O1_at_510_6 O1_at_511_6 O1_at_512_6 O1_at_513_6 O1_at_514_6 O1_at_515_6 O1_at_516_6 O1_at_517_6 O1_at_518_6 O1_at_519_6 O1_at_520_6 O1_at_521_6 O1_at_522_6 O1_at_523_6 O1_at_524_6 O1_at_525_6 O1_at_526_6 O1_at_527_6 O1_at_528_6 O1_at_529_6 O1_at_530_6 O1_at_531_6 O1_af_50_6 O1_af_51_6 O1_af_52_6 O1_af_53_6 O1_af_54_6 O1_af_55_6 O1_af_56_6 O1_af_57_6 O1_af_58_6 O1_af_59_6 O1_af_510_6 O1_af_511_6 O1_af_512_6 O1_af_513_6 O1_af_514_6 O1_af_515_6 O1_af_516_6 O1_af_517_6 O1_af_518_6 O1_af_519_6 O1_af_520_6 O1_af_521_6 O1_af_522_6 O1_af_523_6 O1_af_524_6 O1_af_525_6 O1_af_526_6 O1_af_527_6 O1_af_528_6 O1_af_529_6 O1_af_530_6 O1_af_531_6 O1_aa
*.PININFO reset:I I_at_50_6:I I_at_51_6:I I_at_52_6:I I_at_53_6:I I_at_54_6:I I_at_55_6:I I_at_56_6:I I_at_57_6:I I_at_58_6:I I_at_59_6:I I_at_510_6:I I_at_511_6:I I_at_512_6:I I_at_513_6:I I_at_514_6:I I_at_515_6:I I_at_516_6:I I_at_517_6:I I_at_518_6:I I_at_519_6:I I_at_520_6:I I_at_521_6:I I_at_522_6:I I_at_523_6:I I_at_524_6:I I_at_525_6:I I_at_526_6:I I_at_527_6:I I_at_528_6:I I_at_529_6:I I_at_530_6:I I_at_531_6:I I_af_50_6:I I_af_51_6:I I_af_52_6:I I_af_53_6:I I_af_54_6:I I_af_55_6:I I_af_56_6:I I_af_57_6:I I_af_58_6:I I_af_59_6:I I_af_510_6:I I_af_511_6:I I_af_512_6:I I_af_513_6:I I_af_514_6:I I_af_515_6:I I_af_516_6:I I_af_517_6:I I_af_518_6:I I_af_519_6:I I_af_520_6:I I_af_521_6:I I_af_522_6:I I_af_523_6:I I_af_524_6:I I_af_525_6:I I_af_526_6:I I_af_527_6:I I_af_528_6:I I_af_529_6:I I_af_530_6:I I_af_531_6:I I_aa:O O0_at_50_6:O O0_at_51_6:O O0_at_52_6:O O0_at_53_6:O O0_at_54_6:O O0_at_55_6:O O0_at_56_6:O O0_at_57_6:O O0_at_58_6:O O0_at_59_6:O O0_at_510_6:O O0_at_511_6:O O0_at_512_6:O O0_at_513_6:O O0_at_514_6:O O0_at_515_6:O O0_at_516_6:O O0_at_517_6:O O0_at_518_6:O O0_at_519_6:O O0_at_520_6:O O0_at_521_6:O O0_at_522_6:O O0_at_523_6:O O0_at_524_6:O O0_at_525_6:O O0_at_526_6:O O0_at_527_6:O O0_at_528_6:O O0_at_529_6:O O0_at_530_6:O O0_at_531_6:O O0_af_50_6:O O0_af_51_6:O O0_af_52_6:O O0_af_53_6:O O0_af_54_6:O O0_af_55_6:O O0_af_56_6:O O0_af_57_6:O O0_af_58_6:O O0_af_59_6:O O0_af_510_6:O O0_af_511_6:O O0_af_512_6:O O0_af_513_6:O O0_af_514_6:O O0_af_515_6:O O0_af_516_6:O O0_af_517_6:O O0_af_518_6:O O0_af_519_6:O O0_af_520_6:O O0_af_521_6:O O0_af_522_6:O O0_af_523_6:O O0_af_524_6:O O0_af_525_6:O O0_af_526_6:O O0_af_527_6:O O0_af_528_6:O O0_af_529_6:O O0_af_530_6:O O0_af_531_6:O O0_aa:I O1_at_50_6:O O1_at_51_6:O O1_at_52_6:O O1_at_53_6:O O1_at_54_6:O O1_at_55_6:O O1_at_56_6:O O1_at_57_6:O O1_at_58_6:O O1_at_59_6:O O1_at_510_6:O O1_at_511_6:O O1_at_512_6:O O1_at_513_6:O O1_at_514_6:O O1_at_515_6:O O1_at_516_6:O O1_at_517_6:O O1_at_518_6:O O1_at_519_6:O O1_at_520_6:O O1_at_521_6:O O1_at_522_6:O O1_at_523_6:O O1_at_524_6:O O1_at_525_6:O O1_at_526_6:O O1_at_527_6:O O1_at_528_6:O O1_at_529_6:O O1_at_530_6:O O1_at_531_6:O O1_af_50_6:O O1_af_51_6:O O1_af_52_6:O O1_af_53_6:O O1_af_54_6:O O1_af_55_6:O O1_af_56_6:O O1_af_57_6:O O1_af_58_6:O O1_af_59_6:O O1_af_510_6:O O1_af_511_6:O O1_af_512_6:O O1_af_513_6:O O1_af_514_6:O O1_af_515_6:O O1_af_516_6:O O1_af_517_6:O O1_af_518_6:O O1_af_519_6:O O1_af_520_6:O O1_af_521_6:O O1_af_522_6:O O1_af_523_6:O O1_af_524_6:O O1_af_525_6:O O1_af_526_6:O O1_af_527_6:O O1_af_528_6:O O1_af_529_6:O O1_af_530_6:O O1_af_531_6:O O1_aa:I
*.POWER VDD Vdd
*.POWER GND GND
*.POWER NSUB GND
*.POWER PSUB Vdd
*
* --- node flags ---
*
* p (state-holding): pup_reff=8.4; pdn_reff=2
* w__0i (state-holding): pup_reff=8.4; pdn_reff=1.33333
* inv__I__t_531_6 (combinational)
* inv__I__f_530_6 (combinational)
* inv__I__f_529_6 (combinational)
* inv__I__f_528_6 (combinational)
* inv__I__f_527_6 (combinational)
* inv__I__f_526_6 (combinational)
* inv__I__f_525_6 (combinational)
* inv__I__f_524_6 (combinational)
* inv__I__f_523_6 (combinational)
* inv__I__f_522_6 (combinational)
* inv__I__f_521_6 (combinational)
* inv__I__f_520_6 (combinational)
* inv__I__f_519_6 (combinational)
* inv__I__f_518_6 (combinational)
* inv__I__f_517_6 (combinational)
* inv__I__f_516_6 (combinational)
* inv__I__f_515_6 (combinational)
* inv__I__f_514_6 (combinational)
* inv__I__f_513_6 (combinational)
* inv__s (combinational)
* inv__reset (combinational)
* inv__w__0i (combinational)
* s (state-holding): pup_reff=1.6; pdn_reff=2.66667
* inv__p (combinational)
* inv__I__f_531_6 (combinational)
* inv__I__t_530_6 (combinational)
* inv__I__t_529_6 (combinational)
* inv__I__t_528_6 (combinational)
* inv__I__t_527_6 (combinational)
* inv__I__t_526_6 (combinational)
* inv__I__t_525_6 (combinational)
* inv__I__t_524_6 (combinational)
* inv__I__t_523_6 (combinational)
* inv__I__t_522_6 (combinational)
* inv__I__t_521_6 (combinational)
* inv__I__t_520_6 (combinational)
* inv__I__t_519_6 (combinational)
* inv__I__t_518_6 (combinational)
* inv__I__t_517_6 (combinational)
* inv__I__t_516_6 (combinational)
* inv__I__t_515_6 (combinational)
* inv__I__t_514_6 (combinational)
* inv__I__t_513_6 (combinational)
* f (state-holding): pup_reff=26; pdn_reff=0.666667
* n__w__0 (state-holding): pup_reff=1.6; pdn_reff=1.33333
* n__I__a (state-holding): pup_reff=0.8; pdn_reff=2.66667
* n__w__1 (state-holding): pup_reff=1.6; pdn_reff=1.33333
* n__v (state-holding): pup_reff=1.6; pdn_reff=2.66667
* w__1 (combinational)
* w__0 (combinational)
* inv__f (combinational)
* v (combinational)
* n__O0__t_50_6 (state-holding): pup_reff=0.4; pdn_reff=2
* n__O0__f_50_6 (state-holding): pup_reff=0.4; pdn_reff=2
* O1_at_50_6 (state-holding): pup_reff=1.2; pdn_reff=0.666667
* inv__I__t_50_6 (combinational)
* O1_af_50_6 (state-holding): pup_reff=1.2; pdn_reff=0.666667
* inv__I__f_50_6 (combinational)
* n__O0__t_51_6 (state-holding): pup_reff=0.4; pdn_reff=2
* n__O0__f_51_6 (state-holding): pup_reff=0.4; pdn_reff=2
* O1_at_51_6 (state-holding): pup_reff=1.2; pdn_reff=0.666667
* inv__I__t_51_6 (combinational)
* O1_af_51_6 (state-holding): pup_reff=1.2; pdn_reff=0.666667
* inv__I__f_51_6 (combinational)
* n__O0__t_52_6 (state-holding): pup_reff=0.4; pdn_reff=2
* n__O0__f_52_6 (state-holding): pup_reff=0.4; pdn_reff=2
* O1_at_52_6 (state-holding): pup_reff=1.2; pdn_reff=0.666667
* inv__I__t_52_6 (combinational)
* O1_af_52_6 (state-holding): pup_reff=1.2; pdn_reff=0.666667
* inv__I__f_52_6 (combinational)
* n__O0__t_53_6 (state-holding): pup_reff=0.4; pdn_reff=2
* n__O0__f_53_6 (state-holding): pup_reff=0.4; pdn_reff=2
* O1_at_53_6 (state-holding): pup_reff=1.2; pdn_reff=0.666667
* inv__I__t_53_6 (combinational)
* O1_af_53_6 (state-holding): pup_reff=1.2; pdn_reff=0.666667
* inv__I__f_53_6 (combinational)
* n__O0__t_54_6 (state-holding): pup_reff=0.4; pdn_reff=2
* n__O0__f_54_6 (state-holding): pup_reff=0.4; pdn_reff=2
* O1_at_54_6 (state-holding): pup_reff=1.2; pdn_reff=0.666667
* inv__I__t_54_6 (combinational)
* O1_af_54_6 (state-holding): pup_reff=1.2; pdn_reff=0.666667
* inv__I__f_54_6 (combinational)
* n__O0__t_55_6 (state-holding): pup_reff=0.4; pdn_reff=2
* n__O0__f_55_6 (state-holding): pup_reff=0.4; pdn_reff=2
* O1_at_55_6 (state-holding): pup_reff=1.2; pdn_reff=0.666667
* inv__I__t_55_6 (combinational)
* O1_af_55_6 (state-holding): pup_reff=1.2; pdn_reff=0.666667
* inv__I__f_55_6 (combinational)
* n__O0__t_56_6 (state-holding): pup_reff=0.4; pdn_reff=2
* n__O0__f_56_6 (state-holding): pup_reff=0.4; pdn_reff=2
* O1_at_56_6 (state-holding): pup_reff=1.2; pdn_reff=0.666667
* inv__I__t_56_6 (combinational)
* O1_af_56_6 (state-holding): pup_reff=1.2; pdn_reff=0.666667
* inv__I__f_56_6 (combinational)
* n__O0__t_57_6 (state-holding): pup_reff=0.4; pdn_reff=2
* n__O0__f_57_6 (state-holding): pup_reff=0.4; pdn_reff=2
* O1_at_57_6 (state-holding): pup_reff=1.2; pdn_reff=0.666667
* inv__I__t_57_6 (combinational)
* O1_af_57_6 (state-holding): pup_reff=1.2; pdn_reff=0.666667
* inv__I__f_57_6 (combinational)
* n__O0__t_58_6 (state-holding): pup_reff=0.4; pdn_reff=2
* n__O0__f_58_6 (state-holding): pup_reff=0.4; pdn_reff=2
* O1_at_58_6 (state-holding): pup_reff=1.2; pdn_reff=0.666667
* inv__I__t_58_6 (combinational)
* O1_af_58_6 (state-holding): pup_reff=1.2; pdn_reff=0.666667
* inv__I__f_58_6 (combinational)
* n__O0__t_59_6 (state-holding): pup_reff=0.4; pdn_reff=2
* n__O0__f_59_6 (state-holding): pup_reff=0.4; pdn_reff=2
* O1_at_59_6 (state-holding): pup_reff=1.2; pdn_reff=0.666667
* inv__I__t_59_6 (combinational)
* O1_af_59_6 (state-holding): pup_reff=1.2; pdn_reff=0.666667
* inv__I__f_59_6 (combinational)
* n__O0__t_510_6 (state-holding): pup_reff=0.4; pdn_reff=2
* n__O0__f_510_6 (state-holding): pup_reff=0.4; pdn_reff=2
* O1_at_510_6 (state-holding): pup_reff=1.2; pdn_reff=0.666667
* inv__I__t_510_6 (combinational)
* O1_af_510_6 (state-holding): pup_reff=1.2; pdn_reff=0.666667
* inv__I__f_510_6 (combinational)
* n__O0__t_511_6 (state-holding): pup_reff=0.4; pdn_reff=2
* n__O0__f_511_6 (state-holding): pup_reff=0.4; pdn_reff=2
* O1_at_511_6 (state-holding): pup_reff=1.2; pdn_reff=0.666667
* inv__I__t_511_6 (combinational)
* O1_af_511_6 (state-holding): pup_reff=1.2; pdn_reff=0.666667
* inv__I__f_511_6 (combinational)
* n__O0__t_512_6 (state-holding): pup_reff=0.4; pdn_reff=2
* n__O0__f_512_6 (state-holding): pup_reff=0.4; pdn_reff=2
* O1_at_512_6 (state-holding): pup_reff=1.2; pdn_reff=0.666667
* inv__I__t_512_6 (combinational)
* O1_af_512_6 (state-holding): pup_reff=1.2; pdn_reff=0.666667
* inv__I__f_512_6 (combinational)
* n__O0__t_513_6 (state-holding): pup_reff=0.4; pdn_reff=2
* n__O0__f_513_6 (state-holding): pup_reff=0.4; pdn_reff=2
* O1_at_513_6 (state-holding): pup_reff=1.2; pdn_reff=0.666667
* O1_af_513_6 (state-holding): pup_reff=1.2; pdn_reff=0.666667
* n__O0__t_514_6 (state-holding): pup_reff=0.4; pdn_reff=2
* n__O0__f_514_6 (state-holding): pup_reff=0.4; pdn_reff=2
* O1_at_514_6 (state-holding): pup_reff=1.2; pdn_reff=0.666667
* O1_af_514_6 (state-holding): pup_reff=1.2; pdn_reff=0.666667
* n__O0__t_515_6 (state-holding): pup_reff=0.4; pdn_reff=2
* n__O0__f_515_6 (state-holding): pup_reff=0.4; pdn_reff=2
* O1_at_515_6 (state-holding): pup_reff=1.2; pdn_reff=0.666667
* O1_af_515_6 (state-holding): pup_reff=1.2; pdn_reff=0.666667
* n__O0__t_516_6 (state-holding): pup_reff=0.4; pdn_reff=2
* n__O0__f_516_6 (state-holding): pup_reff=0.4; pdn_reff=2
* O1_at_516_6 (state-holding): pup_reff=1.2; pdn_reff=0.666667
* O1_af_516_6 (state-holding): pup_reff=1.2; pdn_reff=0.666667
* n__O0__t_517_6 (state-holding): pup_reff=0.4; pdn_reff=2
* n__O0__f_517_6 (state-holding): pup_reff=0.4; pdn_reff=2
* O1_at_517_6 (state-holding): pup_reff=1.2; pdn_reff=0.666667
* O1_af_517_6 (state-holding): pup_reff=1.2; pdn_reff=0.666667
* n__O0__t_518_6 (state-holding): pup_reff=0.4; pdn_reff=2
* n__O0__f_518_6 (state-holding): pup_reff=0.4; pdn_reff=2
* O1_at_518_6 (state-holding): pup_reff=1.2; pdn_reff=0.666667
* O1_af_518_6 (state-holding): pup_reff=1.2; pdn_reff=0.666667
* n__O0__t_519_6 (state-holding): pup_reff=0.4; pdn_reff=2
* n__O0__f_519_6 (state-holding): pup_reff=0.4; pdn_reff=2
* O1_at_519_6 (state-holding): pup_reff=1.2; pdn_reff=0.666667
* O1_af_519_6 (state-holding): pup_reff=1.2; pdn_reff=0.666667
* n__O0__t_520_6 (state-holding): pup_reff=0.4; pdn_reff=2
* n__O0__f_520_6 (state-holding): pup_reff=0.4; pdn_reff=2
* O1_at_520_6 (state-holding): pup_reff=1.2; pdn_reff=0.666667
* O1_af_520_6 (state-holding): pup_reff=1.2; pdn_reff=0.666667
* n__O0__t_521_6 (state-holding): pup_reff=0.4; pdn_reff=2
* n__O0__f_521_6 (state-holding): pup_reff=0.4; pdn_reff=2
* O1_at_521_6 (state-holding): pup_reff=1.2; pdn_reff=0.666667
* O1_af_521_6 (state-holding): pup_reff=1.2; pdn_reff=0.666667
* n__O0__t_522_6 (state-holding): pup_reff=0.4; pdn_reff=2
* n__O0__f_522_6 (state-holding): pup_reff=0.4; pdn_reff=2
* O1_at_522_6 (state-holding): pup_reff=1.2; pdn_reff=0.666667
* O1_af_522_6 (state-holding): pup_reff=1.2; pdn_reff=0.666667
* n__O0__t_523_6 (state-holding): pup_reff=0.4; pdn_reff=2
* n__O0__f_523_6 (state-holding): pup_reff=0.4; pdn_reff=2
* O1_at_523_6 (state-holding): pup_reff=1.2; pdn_reff=0.666667
* O1_af_523_6 (state-holding): pup_reff=1.2; pdn_reff=0.666667
* n__O0__t_524_6 (state-holding): pup_reff=0.4; pdn_reff=2
* n__O0__f_524_6 (state-holding): pup_reff=0.4; pdn_reff=2
* O1_at_524_6 (state-holding): pup_reff=1.2; pdn_reff=0.666667
* O1_af_524_6 (state-holding): pup_reff=1.2; pdn_reff=0.666667
* n__O0__t_525_6 (state-holding): pup_reff=0.4; pdn_reff=2
* n__O0__f_525_6 (state-holding): pup_reff=0.4; pdn_reff=2
* O1_at_525_6 (state-holding): pup_reff=1.2; pdn_reff=0.666667
* O1_af_525_6 (state-holding): pup_reff=1.2; pdn_reff=0.666667
* n__O0__t_526_6 (state-holding): pup_reff=0.4; pdn_reff=2
* n__O0__f_526_6 (state-holding): pup_reff=0.4; pdn_reff=2
* O1_at_526_6 (state-holding): pup_reff=1.2; pdn_reff=0.666667
* O1_af_526_6 (state-holding): pup_reff=1.2; pdn_reff=0.666667
* n__O0__t_527_6 (state-holding): pup_reff=0.4; pdn_reff=2
* n__O0__f_527_6 (state-holding): pup_reff=0.4; pdn_reff=2
* O1_at_527_6 (state-holding): pup_reff=1.2; pdn_reff=0.666667
* O1_af_527_6 (state-holding): pup_reff=1.2; pdn_reff=0.666667
* n__O0__t_528_6 (state-holding): pup_reff=0.4; pdn_reff=2
* n__O0__f_528_6 (state-holding): pup_reff=0.4; pdn_reff=2
* O1_at_528_6 (state-holding): pup_reff=1.2; pdn_reff=0.666667
* O1_af_528_6 (state-holding): pup_reff=1.2; pdn_reff=0.666667
* n__O0__t_529_6 (state-holding): pup_reff=0.4; pdn_reff=2
* n__O0__f_529_6 (state-holding): pup_reff=0.4; pdn_reff=2
* O1_at_529_6 (state-holding): pup_reff=1.2; pdn_reff=0.666667
* O1_af_529_6 (state-holding): pup_reff=1.2; pdn_reff=0.666667
* n__O0__t_530_6 (state-holding): pup_reff=0.4; pdn_reff=2
* n__O0__f_530_6 (state-holding): pup_reff=0.4; pdn_reff=2
* O1_at_530_6 (state-holding): pup_reff=1.2; pdn_reff=0.666667
* O1_af_530_6 (state-holding): pup_reff=1.2; pdn_reff=0.666667
* n__O0__t_531_6 (state-holding): pup_reff=0.4; pdn_reff=2
* n__O0__f_531_6 (state-holding): pup_reff=0.4; pdn_reff=2
* O1_at_531_6 (state-holding): pup_reff=1.2; pdn_reff=0.666667
* O1_af_531_6 (state-holding): pup_reff=1.2; pdn_reff=0.666667
* inv__O0__a (combinational)
* inv__O1__a (combinational)
* I_aa (combinational)
* O0_at_50_6 (combinational)
* O0_af_50_6 (combinational)
* O0_at_51_6 (combinational)
* O0_af_51_6 (combinational)
* O0_at_52_6 (combinational)
* O0_af_52_6 (combinational)
* O0_at_53_6 (combinational)
* O0_af_53_6 (combinational)
* O0_at_54_6 (combinational)
* O0_af_54_6 (combinational)
* O0_at_55_6 (combinational)
* O0_af_55_6 (combinational)
* O0_at_56_6 (combinational)
* O0_af_56_6 (combinational)
* O0_at_57_6 (combinational)
* O0_af_57_6 (combinational)
* O0_at_58_6 (combinational)
* O0_af_58_6 (combinational)
* O0_at_59_6 (combinational)
* O0_af_59_6 (combinational)
* O0_at_510_6 (combinational)
* O0_af_510_6 (combinational)
* O0_at_511_6 (combinational)
* O0_af_511_6 (combinational)
* O0_at_512_6 (combinational)
* O0_af_512_6 (combinational)
* O0_at_513_6 (combinational)
* O0_af_513_6 (combinational)
* O0_at_514_6 (combinational)
* O0_af_514_6 (combinational)
* O0_at_515_6 (combinational)
* O0_af_515_6 (combinational)
* O0_at_516_6 (combinational)
* O0_af_516_6 (combinational)
* O0_at_517_6 (combinational)
* O0_af_517_6 (combinational)
* O0_at_518_6 (combinational)
* O0_af_518_6 (combinational)
* O0_at_519_6 (combinational)
* O0_af_519_6 (combinational)
* O0_at_520_6 (combinational)
* O0_af_520_6 (combinational)
* O0_at_521_6 (combinational)
* O0_af_521_6 (combinational)
* O0_at_522_6 (combinational)
* O0_af_522_6 (combinational)
* O0_at_523_6 (combinational)
* O0_af_523_6 (combinational)
* O0_at_524_6 (combinational)
* O0_af_524_6 (combinational)
* O0_at_525_6 (combinational)
* O0_af_525_6 (combinational)
* O0_at_526_6 (combinational)
* O0_af_526_6 (combinational)
* O0_at_527_6 (combinational)
* O0_af_527_6 (combinational)
* O0_at_528_6 (combinational)
* O0_af_528_6 (combinational)
* O0_at_529_6 (combinational)
* O0_af_529_6 (combinational)
* O0_at_530_6 (combinational)
* O0_af_530_6 (combinational)
* O0_at_531_6 (combinational)
* O0_af_531_6 (combinational)
*
* --- end node flags ---
*
M0_ Vdd w__0i #3 Vdd pmos W=0.1625U L=0.065U
M1_ Vdd inv__reset p Vdd pmos W=0.1625U L=0.065U
M2_ Vdd inv__s #68 Vdd pmos W=0.1625U L=0.065U
M3_ Vdd inv__w__0i #114 Vdd pmos W=0.1625U L=0.065U
M4_ Vdd s #226 Vdd pmos W=0.1625U L=0.065U
M5_ Vdd inv__reset n__w__0 Vdd pmos W=0.1625U L=0.065U
M6_ Vdd inv__s #232 Vdd pmos W=0.1625U L=0.065U
M7_ Vdd inv__reset n__w__1 Vdd pmos W=0.1625U L=0.065U
M8_ Vdd n__w__1 #235 Vdd pmos W=0.1625U L=0.065U
M9_ Vdd inv__reset s Vdd pmos W=0.1625U L=0.065U
M10_ Vdd O0_aa #248 Vdd pmos W=0.1625U L=0.065U
M11_ Vdd inv__reset n__v Vdd pmos W=0.1625U L=0.065U
M12_ Vdd w__0i #255 Vdd pmos W=0.1625U L=0.065U
M13_ Vdd inv__s #256 Vdd pmos W=0.1625U L=0.065U
M14_ Vdd inv__reset n__I__a Vdd pmos W=0.1625U L=0.065U
M15_ Vdd I_at_50_6 n__O0__t_50_6 Vdd pmos W=0.1625U L=0.065U
M16_ Vdd I_af_50_6 n__O0__f_50_6 Vdd pmos W=0.1625U L=0.065U
M17_ Vdd p #265 Vdd pmos W=0.1625U L=0.065U
M18_ Vdd p #269 Vdd pmos W=0.1625U L=0.065U
M19_ Vdd I_at_51_6 n__O0__t_51_6 Vdd pmos W=0.1625U L=0.065U
M20_ Vdd I_af_51_6 n__O0__f_51_6 Vdd pmos W=0.1625U L=0.065U
M21_ Vdd p #279 Vdd pmos W=0.1625U L=0.065U
M22_ Vdd p #283 Vdd pmos W=0.1625U L=0.065U
M23_ Vdd I_at_52_6 n__O0__t_52_6 Vdd pmos W=0.1625U L=0.065U
M24_ Vdd I_af_52_6 n__O0__f_52_6 Vdd pmos W=0.1625U L=0.065U
M25_ Vdd p #293 Vdd pmos W=0.1625U L=0.065U
M26_ Vdd p #297 Vdd pmos W=0.1625U L=0.065U
M27_ Vdd I_at_53_6 n__O0__t_53_6 Vdd pmos W=0.1625U L=0.065U
M28_ Vdd I_af_53_6 n__O0__f_53_6 Vdd pmos W=0.1625U L=0.065U
M29_ Vdd p #307 Vdd pmos W=0.1625U L=0.065U
M30_ Vdd p #311 Vdd pmos W=0.1625U L=0.065U
M31_ Vdd I_at_54_6 n__O0__t_54_6 Vdd pmos W=0.1625U L=0.065U
M32_ Vdd I_af_54_6 n__O0__f_54_6 Vdd pmos W=0.1625U L=0.065U
M33_ Vdd p #321 Vdd pmos W=0.1625U L=0.065U
M34_ Vdd p #325 Vdd pmos W=0.1625U L=0.065U
M35_ Vdd I_at_55_6 n__O0__t_55_6 Vdd pmos W=0.1625U L=0.065U
M36_ Vdd I_af_55_6 n__O0__f_55_6 Vdd pmos W=0.1625U L=0.065U
M37_ Vdd p #335 Vdd pmos W=0.1625U L=0.065U
M38_ Vdd p #339 Vdd pmos W=0.1625U L=0.065U
M39_ Vdd I_at_56_6 n__O0__t_56_6 Vdd pmos W=0.1625U L=0.065U
M40_ Vdd I_af_56_6 n__O0__f_56_6 Vdd pmos W=0.1625U L=0.065U
M41_ Vdd p #349 Vdd pmos W=0.1625U L=0.065U
M42_ Vdd p #353 Vdd pmos W=0.1625U L=0.065U
M43_ Vdd I_at_57_6 n__O0__t_57_6 Vdd pmos W=0.1625U L=0.065U
M44_ Vdd I_af_57_6 n__O0__f_57_6 Vdd pmos W=0.1625U L=0.065U
M45_ Vdd p #363 Vdd pmos W=0.1625U L=0.065U
M46_ Vdd p #367 Vdd pmos W=0.1625U L=0.065U
M47_ Vdd I_at_58_6 n__O0__t_58_6 Vdd pmos W=0.1625U L=0.065U
M48_ Vdd I_af_58_6 n__O0__f_58_6 Vdd pmos W=0.1625U L=0.065U
M49_ Vdd p #377 Vdd pmos W=0.1625U L=0.065U
M50_ Vdd p #381 Vdd pmos W=0.1625U L=0.065U
M51_ Vdd I_at_59_6 n__O0__t_59_6 Vdd pmos W=0.1625U L=0.065U
M52_ Vdd I_af_59_6 n__O0__f_59_6 Vdd pmos W=0.1625U L=0.065U
M53_ Vdd p #391 Vdd pmos W=0.1625U L=0.065U
M54_ Vdd p #395 Vdd pmos W=0.1625U L=0.065U
M55_ Vdd I_at_510_6 n__O0__t_510_6 Vdd pmos W=0.1625U L=0.065U
M56_ Vdd I_af_510_6 n__O0__f_510_6 Vdd pmos W=0.1625U L=0.065U
M57_ Vdd p #405 Vdd pmos W=0.1625U L=0.065U
M58_ Vdd p #409 Vdd pmos W=0.1625U L=0.065U
M59_ Vdd I_at_511_6 n__O0__t_511_6 Vdd pmos W=0.1625U L=0.065U
M60_ Vdd I_af_511_6 n__O0__f_511_6 Vdd pmos W=0.1625U L=0.065U
M61_ Vdd p #419 Vdd pmos W=0.1625U L=0.065U
M62_ Vdd p #423 Vdd pmos W=0.1625U L=0.065U
M63_ Vdd I_at_512_6 n__O0__t_512_6 Vdd pmos W=0.1625U L=0.065U
M64_ Vdd I_af_512_6 n__O0__f_512_6 Vdd pmos W=0.1625U L=0.065U
M65_ Vdd p #433 Vdd pmos W=0.1625U L=0.065U
M66_ Vdd p #437 Vdd pmos W=0.1625U L=0.065U
M67_ Vdd I_at_513_6 n__O0__t_513_6 Vdd pmos W=0.1625U L=0.065U
M68_ Vdd I_af_513_6 n__O0__f_513_6 Vdd pmos W=0.1625U L=0.065U
M69_ Vdd p #447 Vdd pmos W=0.1625U L=0.065U
M70_ Vdd p #450 Vdd pmos W=0.1625U L=0.065U
M71_ Vdd I_at_514_6 n__O0__t_514_6 Vdd pmos W=0.1625U L=0.065U
M72_ Vdd I_af_514_6 n__O0__f_514_6 Vdd pmos W=0.1625U L=0.065U
M73_ Vdd p #459 Vdd pmos W=0.1625U L=0.065U
M74_ Vdd p #462 Vdd pmos W=0.1625U L=0.065U
M75_ Vdd I_at_515_6 n__O0__t_515_6 Vdd pmos W=0.1625U L=0.065U
M76_ Vdd I_af_515_6 n__O0__f_515_6 Vdd pmos W=0.1625U L=0.065U
M77_ Vdd p #471 Vdd pmos W=0.1625U L=0.065U
M78_ Vdd p #474 Vdd pmos W=0.1625U L=0.065U
M79_ Vdd I_at_516_6 n__O0__t_516_6 Vdd pmos W=0.1625U L=0.065U
M80_ Vdd I_af_516_6 n__O0__f_516_6 Vdd pmos W=0.1625U L=0.065U
M81_ Vdd p #483 Vdd pmos W=0.1625U L=0.065U
M82_ Vdd p #486 Vdd pmos W=0.1625U L=0.065U
M83_ Vdd I_at_517_6 n__O0__t_517_6 Vdd pmos W=0.1625U L=0.065U
M84_ Vdd I_af_517_6 n__O0__f_517_6 Vdd pmos W=0.1625U L=0.065U
M85_ Vdd p #495 Vdd pmos W=0.1625U L=0.065U
M86_ Vdd p #498 Vdd pmos W=0.1625U L=0.065U
M87_ Vdd I_at_518_6 n__O0__t_518_6 Vdd pmos W=0.1625U L=0.065U
M88_ Vdd I_af_518_6 n__O0__f_518_6 Vdd pmos W=0.1625U L=0.065U
M89_ Vdd p #507 Vdd pmos W=0.1625U L=0.065U
M90_ Vdd p #510 Vdd pmos W=0.1625U L=0.065U
M91_ Vdd I_at_519_6 n__O0__t_519_6 Vdd pmos W=0.1625U L=0.065U
M92_ Vdd I_af_519_6 n__O0__f_519_6 Vdd pmos W=0.1625U L=0.065U
M93_ Vdd p #519 Vdd pmos W=0.1625U L=0.065U
M94_ Vdd p #522 Vdd pmos W=0.1625U L=0.065U
M95_ Vdd I_at_520_6 n__O0__t_520_6 Vdd pmos W=0.1625U L=0.065U
M96_ Vdd I_af_520_6 n__O0__f_520_6 Vdd pmos W=0.1625U L=0.065U
M97_ Vdd p #531 Vdd pmos W=0.1625U L=0.065U
M98_ Vdd p #534 Vdd pmos W=0.1625U L=0.065U
M99_ Vdd I_at_521_6 n__O0__t_521_6 Vdd pmos W=0.1625U L=0.065U
M100_ Vdd I_af_521_6 n__O0__f_521_6 Vdd pmos W=0.1625U L=0.065U
M101_ Vdd p #543 Vdd pmos W=0.1625U L=0.065U
M102_ Vdd p #546 Vdd pmos W=0.1625U L=0.065U
M103_ Vdd I_at_522_6 n__O0__t_522_6 Vdd pmos W=0.1625U L=0.065U
M104_ Vdd I_af_522_6 n__O0__f_522_6 Vdd pmos W=0.1625U L=0.065U
M105_ Vdd p #555 Vdd pmos W=0.1625U L=0.065U
M106_ Vdd p #558 Vdd pmos W=0.1625U L=0.065U
M107_ Vdd I_at_523_6 n__O0__t_523_6 Vdd pmos W=0.1625U L=0.065U
M108_ Vdd I_af_523_6 n__O0__f_523_6 Vdd pmos W=0.1625U L=0.065U
M109_ Vdd p #567 Vdd pmos W=0.1625U L=0.065U
M110_ Vdd p #570 Vdd pmos W=0.1625U L=0.065U
M111_ Vdd I_at_524_6 n__O0__t_524_6 Vdd pmos W=0.1625U L=0.065U
M112_ Vdd I_af_524_6 n__O0__f_524_6 Vdd pmos W=0.1625U L=0.065U
M113_ Vdd p #579 Vdd pmos W=0.1625U L=0.065U
M114_ Vdd p #582 Vdd pmos W=0.1625U L=0.065U
M115_ Vdd I_at_525_6 n__O0__t_525_6 Vdd pmos W=0.1625U L=0.065U
M116_ Vdd I_af_525_6 n__O0__f_525_6 Vdd pmos W=0.1625U L=0.065U
M117_ Vdd p #591 Vdd pmos W=0.1625U L=0.065U
M118_ Vdd p #594 Vdd pmos W=0.1625U L=0.065U
M119_ Vdd I_at_526_6 n__O0__t_526_6 Vdd pmos W=0.1625U L=0.065U
M120_ Vdd I_af_526_6 n__O0__f_526_6 Vdd pmos W=0.1625U L=0.065U
M121_ Vdd p #603 Vdd pmos W=0.1625U L=0.065U
M122_ Vdd p #606 Vdd pmos W=0.1625U L=0.065U
M123_ Vdd I_at_527_6 n__O0__t_527_6 Vdd pmos W=0.1625U L=0.065U
M124_ Vdd I_af_527_6 n__O0__f_527_6 Vdd pmos W=0.1625U L=0.065U
M125_ Vdd p #615 Vdd pmos W=0.1625U L=0.065U
M126_ Vdd p #618 Vdd pmos W=0.1625U L=0.065U
M127_ Vdd I_at_528_6 n__O0__t_528_6 Vdd pmos W=0.1625U L=0.065U
M128_ Vdd I_af_528_6 n__O0__f_528_6 Vdd pmos W=0.1625U L=0.065U
M129_ Vdd p #627 Vdd pmos W=0.1625U L=0.065U
M130_ Vdd p #630 Vdd pmos W=0.1625U L=0.065U
M131_ Vdd I_at_529_6 n__O0__t_529_6 Vdd pmos W=0.1625U L=0.065U
M132_ Vdd I_af_529_6 n__O0__f_529_6 Vdd pmos W=0.1625U L=0.065U
M133_ Vdd p #639 Vdd pmos W=0.1625U L=0.065U
M134_ Vdd p #642 Vdd pmos W=0.1625U L=0.065U
M135_ Vdd I_at_530_6 n__O0__t_530_6 Vdd pmos W=0.1625U L=0.065U
M136_ Vdd I_af_530_6 n__O0__f_530_6 Vdd pmos W=0.1625U L=0.065U
M137_ Vdd p #651 Vdd pmos W=0.1625U L=0.065U
M138_ Vdd p #654 Vdd pmos W=0.1625U L=0.065U
M139_ Vdd I_at_531_6 n__O0__t_531_6 Vdd pmos W=0.1625U L=0.065U
M140_ Vdd I_af_531_6 n__O0__f_531_6 Vdd pmos W=0.1625U L=0.065U
M141_ Vdd p #663 Vdd pmos W=0.1625U L=0.065U
M142_ Vdd p #666 Vdd pmos W=0.1625U L=0.065U
M143_ Vdd w__0i inv__w__0i Vdd pmos W=0.1625U L=0.065U
M144_ Vdd s inv__s Vdd pmos W=0.1625U L=0.065U
M145_ Vdd reset inv__reset Vdd pmos W=0.1625U L=0.065U
M146_ Vdd p inv__p Vdd pmos W=0.1625U L=0.065U
M147_ Vdd O0_aa inv__O0__a Vdd pmos W=0.1625U L=0.065U
M148_ Vdd O1_aa inv__O1__a Vdd pmos W=0.1625U L=0.065U
M149_ Vdd n__w__0 w__0 Vdd pmos W=0.1625U L=0.065U
M150_ Vdd n__w__1 w__1 Vdd pmos W=0.1625U L=0.065U
M151_ Vdd n__v v Vdd pmos W=0.1625U L=0.065U
M152_ Vdd f inv__f Vdd pmos W=0.1625U L=0.065U
M153_ Vdd I_at_50_6 inv__I__t_50_6 Vdd pmos W=0.1625U L=0.065U
M154_ Vdd I_af_50_6 inv__I__f_50_6 Vdd pmos W=0.1625U L=0.065U
M155_ Vdd I_at_51_6 inv__I__t_51_6 Vdd pmos W=0.1625U L=0.065U
M156_ Vdd I_af_51_6 inv__I__f_51_6 Vdd pmos W=0.1625U L=0.065U
M157_ Vdd I_at_52_6 inv__I__t_52_6 Vdd pmos W=0.1625U L=0.065U
M158_ Vdd I_af_52_6 inv__I__f_52_6 Vdd pmos W=0.1625U L=0.065U
M159_ Vdd I_at_53_6 inv__I__t_53_6 Vdd pmos W=0.1625U L=0.065U
M160_ Vdd I_af_53_6 inv__I__f_53_6 Vdd pmos W=0.1625U L=0.065U
M161_ Vdd I_at_54_6 inv__I__t_54_6 Vdd pmos W=0.1625U L=0.065U
M162_ Vdd I_af_54_6 inv__I__f_54_6 Vdd pmos W=0.1625U L=0.065U
M163_ Vdd I_at_55_6 inv__I__t_55_6 Vdd pmos W=0.1625U L=0.065U
M164_ Vdd I_af_55_6 inv__I__f_55_6 Vdd pmos W=0.1625U L=0.065U
M165_ Vdd I_at_56_6 inv__I__t_56_6 Vdd pmos W=0.1625U L=0.065U
M166_ Vdd I_af_56_6 inv__I__f_56_6 Vdd pmos W=0.1625U L=0.065U
M167_ Vdd I_at_57_6 inv__I__t_57_6 Vdd pmos W=0.1625U L=0.065U
M168_ Vdd I_af_57_6 inv__I__f_57_6 Vdd pmos W=0.1625U L=0.065U
M169_ Vdd I_at_58_6 inv__I__t_58_6 Vdd pmos W=0.1625U L=0.065U
M170_ Vdd I_af_58_6 inv__I__f_58_6 Vdd pmos W=0.1625U L=0.065U
M171_ Vdd I_at_59_6 inv__I__t_59_6 Vdd pmos W=0.1625U L=0.065U
M172_ Vdd I_af_59_6 inv__I__f_59_6 Vdd pmos W=0.1625U L=0.065U
M173_ Vdd I_at_510_6 inv__I__t_510_6 Vdd pmos W=0.1625U L=0.065U
M174_ Vdd I_af_510_6 inv__I__f_510_6 Vdd pmos W=0.1625U L=0.065U
M175_ Vdd I_at_511_6 inv__I__t_511_6 Vdd pmos W=0.1625U L=0.065U
M176_ Vdd I_af_511_6 inv__I__f_511_6 Vdd pmos W=0.1625U L=0.065U
M177_ Vdd I_at_512_6 inv__I__t_512_6 Vdd pmos W=0.1625U L=0.065U
M178_ Vdd I_af_512_6 inv__I__f_512_6 Vdd pmos W=0.1625U L=0.065U
M179_ Vdd I_at_513_6 inv__I__t_513_6 Vdd pmos W=0.1625U L=0.065U
M180_ Vdd I_af_513_6 inv__I__f_513_6 Vdd pmos W=0.1625U L=0.065U
M181_ Vdd I_at_514_6 inv__I__t_514_6 Vdd pmos W=0.1625U L=0.065U
M182_ Vdd I_af_514_6 inv__I__f_514_6 Vdd pmos W=0.1625U L=0.065U
M183_ Vdd I_at_515_6 inv__I__t_515_6 Vdd pmos W=0.1625U L=0.065U
M184_ Vdd I_af_515_6 inv__I__f_515_6 Vdd pmos W=0.1625U L=0.065U
M185_ Vdd I_at_516_6 inv__I__t_516_6 Vdd pmos W=0.1625U L=0.065U
M186_ Vdd I_af_516_6 inv__I__f_516_6 Vdd pmos W=0.1625U L=0.065U
M187_ Vdd I_at_517_6 inv__I__t_517_6 Vdd pmos W=0.1625U L=0.065U
M188_ Vdd I_af_517_6 inv__I__f_517_6 Vdd pmos W=0.1625U L=0.065U
M189_ Vdd I_at_518_6 inv__I__t_518_6 Vdd pmos W=0.1625U L=0.065U
M190_ Vdd I_af_518_6 inv__I__f_518_6 Vdd pmos W=0.1625U L=0.065U
M191_ Vdd I_at_519_6 inv__I__t_519_6 Vdd pmos W=0.1625U L=0.065U
M192_ Vdd I_af_519_6 inv__I__f_519_6 Vdd pmos W=0.1625U L=0.065U
M193_ Vdd I_at_520_6 inv__I__t_520_6 Vdd pmos W=0.1625U L=0.065U
M194_ Vdd I_af_520_6 inv__I__f_520_6 Vdd pmos W=0.1625U L=0.065U
M195_ Vdd I_at_521_6 inv__I__t_521_6 Vdd pmos W=0.1625U L=0.065U
M196_ Vdd I_af_521_6 inv__I__f_521_6 Vdd pmos W=0.1625U L=0.065U
M197_ Vdd I_at_522_6 inv__I__t_522_6 Vdd pmos W=0.1625U L=0.065U
M198_ Vdd I_af_522_6 inv__I__f_522_6 Vdd pmos W=0.1625U L=0.065U
M199_ Vdd I_at_523_6 inv__I__t_523_6 Vdd pmos W=0.1625U L=0.065U
M200_ Vdd I_af_523_6 inv__I__f_523_6 Vdd pmos W=0.1625U L=0.065U
M201_ Vdd I_at_524_6 inv__I__t_524_6 Vdd pmos W=0.1625U L=0.065U
M202_ Vdd I_af_524_6 inv__I__f_524_6 Vdd pmos W=0.1625U L=0.065U
M203_ Vdd I_at_525_6 inv__I__t_525_6 Vdd pmos W=0.1625U L=0.065U
M204_ Vdd I_af_525_6 inv__I__f_525_6 Vdd pmos W=0.1625U L=0.065U
M205_ Vdd I_at_526_6 inv__I__t_526_6 Vdd pmos W=0.1625U L=0.065U
M206_ Vdd I_af_526_6 inv__I__f_526_6 Vdd pmos W=0.1625U L=0.065U
M207_ Vdd I_at_527_6 inv__I__t_527_6 Vdd pmos W=0.1625U L=0.065U
M208_ Vdd I_af_527_6 inv__I__f_527_6 Vdd pmos W=0.1625U L=0.065U
M209_ Vdd I_at_528_6 inv__I__t_528_6 Vdd pmos W=0.1625U L=0.065U
M210_ Vdd I_af_528_6 inv__I__f_528_6 Vdd pmos W=0.1625U L=0.065U
M211_ Vdd I_at_529_6 inv__I__t_529_6 Vdd pmos W=0.1625U L=0.065U
M212_ Vdd I_af_529_6 inv__I__f_529_6 Vdd pmos W=0.1625U L=0.065U
M213_ Vdd I_at_530_6 inv__I__t_530_6 Vdd pmos W=0.1625U L=0.065U
M214_ Vdd I_af_530_6 inv__I__f_530_6 Vdd pmos W=0.1625U L=0.065U
M215_ Vdd I_at_531_6 inv__I__t_531_6 Vdd pmos W=0.1625U L=0.065U
M216_ Vdd I_af_531_6 inv__I__f_531_6 Vdd pmos W=0.1625U L=0.065U
M217_ Vdd n__I__a I_aa Vdd pmos W=0.1625U L=0.065U
M218_ Vdd n__O0__t_50_6 O0_at_50_6 Vdd pmos W=0.1625U L=0.065U
M219_ Vdd n__O0__f_50_6 O0_af_50_6 Vdd pmos W=0.1625U L=0.065U
M220_ Vdd n__O0__t_51_6 O0_at_51_6 Vdd pmos W=0.1625U L=0.065U
M221_ Vdd n__O0__f_51_6 O0_af_51_6 Vdd pmos W=0.1625U L=0.065U
M222_ Vdd n__O0__t_52_6 O0_at_52_6 Vdd pmos W=0.1625U L=0.065U
M223_ Vdd n__O0__f_52_6 O0_af_52_6 Vdd pmos W=0.1625U L=0.065U
M224_ Vdd n__O0__t_53_6 O0_at_53_6 Vdd pmos W=0.1625U L=0.065U
M225_ Vdd n__O0__f_53_6 O0_af_53_6 Vdd pmos W=0.1625U L=0.065U
M226_ Vdd n__O0__t_54_6 O0_at_54_6 Vdd pmos W=0.1625U L=0.065U
M227_ Vdd n__O0__f_54_6 O0_af_54_6 Vdd pmos W=0.1625U L=0.065U
M228_ Vdd n__O0__t_55_6 O0_at_55_6 Vdd pmos W=0.1625U L=0.065U
M229_ Vdd n__O0__f_55_6 O0_af_55_6 Vdd pmos W=0.1625U L=0.065U
M230_ Vdd n__O0__t_56_6 O0_at_56_6 Vdd pmos W=0.1625U L=0.065U
M231_ Vdd n__O0__f_56_6 O0_af_56_6 Vdd pmos W=0.1625U L=0.065U
M232_ Vdd n__O0__t_57_6 O0_at_57_6 Vdd pmos W=0.1625U L=0.065U
M233_ Vdd n__O0__f_57_6 O0_af_57_6 Vdd pmos W=0.1625U L=0.065U
M234_ Vdd n__O0__t_58_6 O0_at_58_6 Vdd pmos W=0.1625U L=0.065U
M235_ Vdd n__O0__f_58_6 O0_af_58_6 Vdd pmos W=0.1625U L=0.065U
M236_ Vdd n__O0__t_59_6 O0_at_59_6 Vdd pmos W=0.1625U L=0.065U
M237_ Vdd n__O0__f_59_6 O0_af_59_6 Vdd pmos W=0.1625U L=0.065U
M238_ Vdd n__O0__t_510_6 O0_at_510_6 Vdd pmos W=0.1625U L=0.065U
M239_ Vdd n__O0__f_510_6 O0_af_510_6 Vdd pmos W=0.1625U L=0.065U
M240_ Vdd n__O0__t_511_6 O0_at_511_6 Vdd pmos W=0.1625U L=0.065U
M241_ Vdd n__O0__f_511_6 O0_af_511_6 Vdd pmos W=0.1625U L=0.065U
M242_ Vdd n__O0__t_512_6 O0_at_512_6 Vdd pmos W=0.1625U L=0.065U
M243_ Vdd n__O0__f_512_6 O0_af_512_6 Vdd pmos W=0.1625U L=0.065U
M244_ Vdd n__O0__t_513_6 O0_at_513_6 Vdd pmos W=0.1625U L=0.065U
M245_ Vdd n__O0__f_513_6 O0_af_513_6 Vdd pmos W=0.1625U L=0.065U
M246_ Vdd n__O0__t_514_6 O0_at_514_6 Vdd pmos W=0.1625U L=0.065U
M247_ Vdd n__O0__f_514_6 O0_af_514_6 Vdd pmos W=0.1625U L=0.065U
M248_ Vdd n__O0__t_515_6 O0_at_515_6 Vdd pmos W=0.1625U L=0.065U
M249_ Vdd n__O0__f_515_6 O0_af_515_6 Vdd pmos W=0.1625U L=0.065U
M250_ Vdd n__O0__t_516_6 O0_at_516_6 Vdd pmos W=0.1625U L=0.065U
M251_ Vdd n__O0__f_516_6 O0_af_516_6 Vdd pmos W=0.1625U L=0.065U
M252_ Vdd n__O0__t_517_6 O0_at_517_6 Vdd pmos W=0.1625U L=0.065U
M253_ Vdd n__O0__f_517_6 O0_af_517_6 Vdd pmos W=0.1625U L=0.065U
M254_ Vdd n__O0__t_518_6 O0_at_518_6 Vdd pmos W=0.1625U L=0.065U
M255_ Vdd n__O0__f_518_6 O0_af_518_6 Vdd pmos W=0.1625U L=0.065U
M256_ Vdd n__O0__t_519_6 O0_at_519_6 Vdd pmos W=0.1625U L=0.065U
M257_ Vdd n__O0__f_519_6 O0_af_519_6 Vdd pmos W=0.1625U L=0.065U
M258_ Vdd n__O0__t_520_6 O0_at_520_6 Vdd pmos W=0.1625U L=0.065U
M259_ Vdd n__O0__f_520_6 O0_af_520_6 Vdd pmos W=0.1625U L=0.065U
M260_ Vdd n__O0__t_521_6 O0_at_521_6 Vdd pmos W=0.1625U L=0.065U
M261_ Vdd n__O0__f_521_6 O0_af_521_6 Vdd pmos W=0.1625U L=0.065U
M262_ Vdd n__O0__t_522_6 O0_at_522_6 Vdd pmos W=0.1625U L=0.065U
M263_ Vdd n__O0__f_522_6 O0_af_522_6 Vdd pmos W=0.1625U L=0.065U
M264_ Vdd n__O0__t_523_6 O0_at_523_6 Vdd pmos W=0.1625U L=0.065U
M265_ Vdd n__O0__f_523_6 O0_af_523_6 Vdd pmos W=0.1625U L=0.065U
M266_ Vdd n__O0__t_524_6 O0_at_524_6 Vdd pmos W=0.1625U L=0.065U
M267_ Vdd n__O0__f_524_6 O0_af_524_6 Vdd pmos W=0.1625U L=0.065U
M268_ Vdd n__O0__t_525_6 O0_at_525_6 Vdd pmos W=0.1625U L=0.065U
M269_ Vdd n__O0__f_525_6 O0_af_525_6 Vdd pmos W=0.1625U L=0.065U
M270_ Vdd n__O0__t_526_6 O0_at_526_6 Vdd pmos W=0.1625U L=0.065U
M271_ Vdd n__O0__f_526_6 O0_af_526_6 Vdd pmos W=0.1625U L=0.065U
M272_ Vdd n__O0__t_527_6 O0_at_527_6 Vdd pmos W=0.1625U L=0.065U
M273_ Vdd n__O0__f_527_6 O0_af_527_6 Vdd pmos W=0.1625U L=0.065U
M274_ Vdd n__O0__t_528_6 O0_at_528_6 Vdd pmos W=0.1625U L=0.065U
M275_ Vdd n__O0__f_528_6 O0_af_528_6 Vdd pmos W=0.1625U L=0.065U
M276_ Vdd n__O0__t_529_6 O0_at_529_6 Vdd pmos W=0.1625U L=0.065U
M277_ Vdd n__O0__f_529_6 O0_af_529_6 Vdd pmos W=0.1625U L=0.065U
M278_ Vdd n__O0__t_530_6 O0_at_530_6 Vdd pmos W=0.1625U L=0.065U
M279_ Vdd n__O0__f_530_6 O0_af_530_6 Vdd pmos W=0.1625U L=0.065U
M280_ Vdd n__O0__t_531_6 O0_at_531_6 Vdd pmos W=0.1625U L=0.065U
M281_ Vdd n__O0__f_531_6 O0_af_531_6 Vdd pmos W=0.1625U L=0.065U
M282_ Vdd p #fb734# Vdd pmos W=0.1625U L=0.13U
M283_ Vdd w__0i #fb737# Vdd pmos W=0.1625U L=0.13U
M284_keeper Vdd GND #735 Vdd pmos W=0.0975U L=0.91U
M285_ Vdd s #fb740# Vdd pmos W=0.1625U L=0.13U
M286_keeper Vdd GND #738 Vdd pmos W=0.0975U L=0.585U
M287_ Vdd f #fb743# Vdd pmos W=0.1625U L=0.13U
M288_keeper Vdd GND #741 Vdd pmos W=0.0975U L=1.235U
M289_ Vdd n__w__0 #fb746# Vdd pmos W=0.1625U L=0.13U
M290_keeper Vdd GND #744 Vdd pmos W=0.0975U L=0.26U
M291_ Vdd n__I__a #fb749# Vdd pmos W=0.1625U L=0.13U
M292_keeper Vdd GND #747 Vdd pmos W=0.0975U L=0.585U
M293_ Vdd n__w__1 #fb752# Vdd pmos W=0.1625U L=0.13U
M294_keeper Vdd GND #750 Vdd pmos W=0.0975U L=1.235U
M295_ Vdd n__v #fb755# Vdd pmos W=0.1625U L=0.13U
M296_keeper Vdd GND #753 Vdd pmos W=0.0975U L=0.585U
M297_ Vdd n__O0__t_50_6 #fb758# Vdd pmos W=0.1625U L=0.13U
M298_keeper Vdd GND #756 Vdd pmos W=0.0975U L=1.235U
M299_ Vdd n__O0__f_50_6 #fb761# Vdd pmos W=0.1625U L=0.13U
M300_keeper Vdd GND #759 Vdd pmos W=0.0975U L=0.91U
M301_ Vdd O1_at_50_6 #fb764# Vdd pmos W=0.1625U L=0.13U
M302_keeper Vdd GND #762 Vdd pmos W=0.0975U L=0.91U
M303_ Vdd O1_af_50_6 #fb767# Vdd pmos W=0.1625U L=0.13U
M304_keeper Vdd GND #765 Vdd pmos W=0.0975U L=0.26U
M305_ Vdd n__O0__t_51_6 #fb770# Vdd pmos W=0.1625U L=0.13U
M306_keeper Vdd GND #768 Vdd pmos W=0.0975U L=0.26U
M307_ Vdd n__O0__f_51_6 #fb773# Vdd pmos W=0.1625U L=0.13U
M308_keeper Vdd GND #771 Vdd pmos W=0.0975U L=0.91U
M309_ Vdd O1_at_51_6 #fb776# Vdd pmos W=0.1625U L=0.13U
M310_keeper Vdd GND #774 Vdd pmos W=0.0975U L=0.91U
M311_ Vdd O1_af_51_6 #fb779# Vdd pmos W=0.1625U L=0.13U
M312_keeper Vdd GND #777 Vdd pmos W=0.0975U L=0.26U
M313_ Vdd n__O0__t_52_6 #fb782# Vdd pmos W=0.1625U L=0.13U
M314_keeper Vdd GND #780 Vdd pmos W=0.0975U L=0.26U
M315_ Vdd n__O0__f_52_6 #fb785# Vdd pmos W=0.1625U L=0.13U
M316_keeper Vdd GND #783 Vdd pmos W=0.0975U L=0.91U
M317_ Vdd O1_at_52_6 #fb788# Vdd pmos W=0.1625U L=0.13U
M318_keeper Vdd GND #786 Vdd pmos W=0.0975U L=0.91U
M319_ Vdd O1_af_52_6 #fb791# Vdd pmos W=0.1625U L=0.13U
M320_keeper Vdd GND #789 Vdd pmos W=0.0975U L=0.26U
M321_ Vdd n__O0__t_53_6 #fb794# Vdd pmos W=0.1625U L=0.13U
M322_keeper Vdd GND #792 Vdd pmos W=0.0975U L=0.26U
M323_ Vdd n__O0__f_53_6 #fb797# Vdd pmos W=0.1625U L=0.13U
M324_keeper Vdd GND #795 Vdd pmos W=0.0975U L=0.91U
M325_ Vdd O1_at_53_6 #fb800# Vdd pmos W=0.1625U L=0.13U
M326_keeper Vdd GND #798 Vdd pmos W=0.0975U L=0.91U
M327_ Vdd O1_af_53_6 #fb803# Vdd pmos W=0.1625U L=0.13U
M328_keeper Vdd GND #801 Vdd pmos W=0.0975U L=0.26U
M329_ Vdd n__O0__t_54_6 #fb806# Vdd pmos W=0.1625U L=0.13U
M330_keeper Vdd GND #804 Vdd pmos W=0.0975U L=0.26U
M331_ Vdd n__O0__f_54_6 #fb809# Vdd pmos W=0.1625U L=0.13U
M332_keeper Vdd GND #807 Vdd pmos W=0.0975U L=0.91U
M333_ Vdd O1_at_54_6 #fb812# Vdd pmos W=0.1625U L=0.13U
M334_keeper Vdd GND #810 Vdd pmos W=0.0975U L=0.91U
M335_ Vdd O1_af_54_6 #fb815# Vdd pmos W=0.1625U L=0.13U
M336_keeper Vdd GND #813 Vdd pmos W=0.0975U L=0.26U
M337_ Vdd n__O0__t_55_6 #fb818# Vdd pmos W=0.1625U L=0.13U
M338_keeper Vdd GND #816 Vdd pmos W=0.0975U L=0.26U
M339_ Vdd n__O0__f_55_6 #fb821# Vdd pmos W=0.1625U L=0.13U
M340_keeper Vdd GND #819 Vdd pmos W=0.0975U L=0.91U
M341_ Vdd O1_at_55_6 #fb824# Vdd pmos W=0.1625U L=0.13U
M342_keeper Vdd GND #822 Vdd pmos W=0.0975U L=0.91U
M343_ Vdd O1_af_55_6 #fb827# Vdd pmos W=0.1625U L=0.13U
M344_keeper Vdd GND #825 Vdd pmos W=0.0975U L=0.26U
M345_ Vdd n__O0__t_56_6 #fb830# Vdd pmos W=0.1625U L=0.13U
M346_keeper Vdd GND #828 Vdd pmos W=0.0975U L=0.26U
M347_ Vdd n__O0__f_56_6 #fb833# Vdd pmos W=0.1625U L=0.13U
M348_keeper Vdd GND #831 Vdd pmos W=0.0975U L=0.91U
M349_ Vdd O1_at_56_6 #fb836# Vdd pmos W=0.1625U L=0.13U
M350_keeper Vdd GND #834 Vdd pmos W=0.0975U L=0.91U
M351_ Vdd O1_af_56_6 #fb839# Vdd pmos W=0.1625U L=0.13U
M352_keeper Vdd GND #837 Vdd pmos W=0.0975U L=0.26U
M353_ Vdd n__O0__t_57_6 #fb842# Vdd pmos W=0.1625U L=0.13U
M354_keeper Vdd GND #840 Vdd pmos W=0.0975U L=0.26U
M355_ Vdd n__O0__f_57_6 #fb845# Vdd pmos W=0.1625U L=0.13U
M356_keeper Vdd GND #843 Vdd pmos W=0.0975U L=0.91U
M357_ Vdd O1_at_57_6 #fb848# Vdd pmos W=0.1625U L=0.13U
M358_keeper Vdd GND #846 Vdd pmos W=0.0975U L=0.91U
M359_ Vdd O1_af_57_6 #fb851# Vdd pmos W=0.1625U L=0.13U
M360_keeper Vdd GND #849 Vdd pmos W=0.0975U L=0.26U
M361_ Vdd n__O0__t_58_6 #fb854# Vdd pmos W=0.1625U L=0.13U
M362_keeper Vdd GND #852 Vdd pmos W=0.0975U L=0.26U
M363_ Vdd n__O0__f_58_6 #fb857# Vdd pmos W=0.1625U L=0.13U
M364_keeper Vdd GND #855 Vdd pmos W=0.0975U L=0.91U
M365_ Vdd O1_at_58_6 #fb860# Vdd pmos W=0.1625U L=0.13U
M366_keeper Vdd GND #858 Vdd pmos W=0.0975U L=0.91U
M367_ Vdd O1_af_58_6 #fb863# Vdd pmos W=0.1625U L=0.13U
M368_keeper Vdd GND #861 Vdd pmos W=0.0975U L=0.26U
M369_ Vdd n__O0__t_59_6 #fb866# Vdd pmos W=0.1625U L=0.13U
M370_keeper Vdd GND #864 Vdd pmos W=0.0975U L=0.26U
M371_ Vdd n__O0__f_59_6 #fb869# Vdd pmos W=0.1625U L=0.13U
M372_keeper Vdd GND #867 Vdd pmos W=0.0975U L=0.91U
M373_ Vdd O1_at_59_6 #fb872# Vdd pmos W=0.1625U L=0.13U
M374_keeper Vdd GND #870 Vdd pmos W=0.0975U L=0.91U
M375_ Vdd O1_af_59_6 #fb875# Vdd pmos W=0.1625U L=0.13U
M376_keeper Vdd GND #873 Vdd pmos W=0.0975U L=0.26U
M377_ Vdd n__O0__t_510_6 #fb878# Vdd pmos W=0.1625U L=0.13U
M378_keeper Vdd GND #876 Vdd pmos W=0.0975U L=0.26U
M379_ Vdd n__O0__f_510_6 #fb881# Vdd pmos W=0.1625U L=0.13U
M380_keeper Vdd GND #879 Vdd pmos W=0.0975U L=0.91U
M381_ Vdd O1_at_510_6 #fb884# Vdd pmos W=0.1625U L=0.13U
M382_keeper Vdd GND #882 Vdd pmos W=0.0975U L=0.91U
M383_ Vdd O1_af_510_6 #fb887# Vdd pmos W=0.1625U L=0.13U
M384_keeper Vdd GND #885 Vdd pmos W=0.0975U L=0.26U
M385_ Vdd n__O0__t_511_6 #fb890# Vdd pmos W=0.1625U L=0.13U
M386_keeper Vdd GND #888 Vdd pmos W=0.0975U L=0.26U
M387_ Vdd n__O0__f_511_6 #fb893# Vdd pmos W=0.1625U L=0.13U
M388_keeper Vdd GND #891 Vdd pmos W=0.0975U L=0.91U
M389_ Vdd O1_at_511_6 #fb896# Vdd pmos W=0.1625U L=0.13U
M390_keeper Vdd GND #894 Vdd pmos W=0.0975U L=0.91U
M391_ Vdd O1_af_511_6 #fb899# Vdd pmos W=0.1625U L=0.13U
M392_keeper Vdd GND #897 Vdd pmos W=0.0975U L=0.26U
M393_ Vdd n__O0__t_512_6 #fb902# Vdd pmos W=0.1625U L=0.13U
M394_keeper Vdd GND #900 Vdd pmos W=0.0975U L=0.26U
M395_ Vdd n__O0__f_512_6 #fb905# Vdd pmos W=0.1625U L=0.13U
M396_keeper Vdd GND #903 Vdd pmos W=0.0975U L=0.91U
M397_ Vdd O1_at_512_6 #fb908# Vdd pmos W=0.1625U L=0.13U
M398_keeper Vdd GND #906 Vdd pmos W=0.0975U L=0.91U
M399_ Vdd O1_af_512_6 #fb911# Vdd pmos W=0.1625U L=0.13U
M400_keeper Vdd GND #909 Vdd pmos W=0.0975U L=0.26U
M401_ Vdd n__O0__t_513_6 #fb914# Vdd pmos W=0.1625U L=0.13U
M402_keeper Vdd GND #912 Vdd pmos W=0.0975U L=0.26U
M403_ Vdd n__O0__f_513_6 #fb917# Vdd pmos W=0.1625U L=0.13U
M404_keeper Vdd GND #915 Vdd pmos W=0.0975U L=0.91U
M405_ Vdd O1_at_513_6 #fb920# Vdd pmos W=0.1625U L=0.13U
M406_keeper Vdd GND #918 Vdd pmos W=0.0975U L=0.91U
M407_ Vdd O1_af_513_6 #fb923# Vdd pmos W=0.1625U L=0.13U
M408_keeper Vdd GND #921 Vdd pmos W=0.0975U L=0.26U
M409_ Vdd n__O0__t_514_6 #fb926# Vdd pmos W=0.1625U L=0.13U
M410_keeper Vdd GND #924 Vdd pmos W=0.0975U L=0.26U
M411_ Vdd n__O0__f_514_6 #fb929# Vdd pmos W=0.1625U L=0.13U
M412_keeper Vdd GND #927 Vdd pmos W=0.0975U L=0.91U
M413_ Vdd O1_at_514_6 #fb932# Vdd pmos W=0.1625U L=0.13U
M414_keeper Vdd GND #930 Vdd pmos W=0.0975U L=0.91U
M415_ Vdd O1_af_514_6 #fb935# Vdd pmos W=0.1625U L=0.13U
M416_keeper Vdd GND #933 Vdd pmos W=0.0975U L=0.26U
M417_ Vdd n__O0__t_515_6 #fb938# Vdd pmos W=0.1625U L=0.13U
M418_keeper Vdd GND #936 Vdd pmos W=0.0975U L=0.26U
M419_ Vdd n__O0__f_515_6 #fb941# Vdd pmos W=0.1625U L=0.13U
M420_keeper Vdd GND #939 Vdd pmos W=0.0975U L=0.91U
M421_ Vdd O1_at_515_6 #fb944# Vdd pmos W=0.1625U L=0.13U
M422_keeper Vdd GND #942 Vdd pmos W=0.0975U L=0.91U
M423_ Vdd O1_af_515_6 #fb947# Vdd pmos W=0.1625U L=0.13U
M424_keeper Vdd GND #945 Vdd pmos W=0.0975U L=0.26U
M425_ Vdd n__O0__t_516_6 #fb950# Vdd pmos W=0.1625U L=0.13U
M426_keeper Vdd GND #948 Vdd pmos W=0.0975U L=0.26U
M427_ Vdd n__O0__f_516_6 #fb953# Vdd pmos W=0.1625U L=0.13U
M428_keeper Vdd GND #951 Vdd pmos W=0.0975U L=0.91U
M429_ Vdd O1_at_516_6 #fb956# Vdd pmos W=0.1625U L=0.13U
M430_keeper Vdd GND #954 Vdd pmos W=0.0975U L=0.91U
M431_ Vdd O1_af_516_6 #fb959# Vdd pmos W=0.1625U L=0.13U
M432_keeper Vdd GND #957 Vdd pmos W=0.0975U L=0.26U
M433_ Vdd n__O0__t_517_6 #fb962# Vdd pmos W=0.1625U L=0.13U
M434_keeper Vdd GND #960 Vdd pmos W=0.0975U L=0.26U
M435_ Vdd n__O0__f_517_6 #fb965# Vdd pmos W=0.1625U L=0.13U
M436_keeper Vdd GND #963 Vdd pmos W=0.0975U L=0.91U
M437_ Vdd O1_at_517_6 #fb968# Vdd pmos W=0.1625U L=0.13U
M438_keeper Vdd GND #966 Vdd pmos W=0.0975U L=0.91U
M439_ Vdd O1_af_517_6 #fb971# Vdd pmos W=0.1625U L=0.13U
M440_keeper Vdd GND #969 Vdd pmos W=0.0975U L=0.26U
M441_ Vdd n__O0__t_518_6 #fb974# Vdd pmos W=0.1625U L=0.13U
M442_keeper Vdd GND #972 Vdd pmos W=0.0975U L=0.26U
M443_ Vdd n__O0__f_518_6 #fb977# Vdd pmos W=0.1625U L=0.13U
M444_keeper Vdd GND #975 Vdd pmos W=0.0975U L=0.91U
M445_ Vdd O1_at_518_6 #fb980# Vdd pmos W=0.1625U L=0.13U
M446_keeper Vdd GND #978 Vdd pmos W=0.0975U L=0.91U
M447_ Vdd O1_af_518_6 #fb983# Vdd pmos W=0.1625U L=0.13U
M448_keeper Vdd GND #981 Vdd pmos W=0.0975U L=0.26U
M449_ Vdd n__O0__t_519_6 #fb986# Vdd pmos W=0.1625U L=0.13U
M450_keeper Vdd GND #984 Vdd pmos W=0.0975U L=0.26U
M451_ Vdd n__O0__f_519_6 #fb989# Vdd pmos W=0.1625U L=0.13U
M452_keeper Vdd GND #987 Vdd pmos W=0.0975U L=0.91U
M453_ Vdd O1_at_519_6 #fb992# Vdd pmos W=0.1625U L=0.13U
M454_keeper Vdd GND #990 Vdd pmos W=0.0975U L=0.91U
M455_ Vdd O1_af_519_6 #fb995# Vdd pmos W=0.1625U L=0.13U
M456_keeper Vdd GND #993 Vdd pmos W=0.0975U L=0.26U
M457_ Vdd n__O0__t_520_6 #fb998# Vdd pmos W=0.1625U L=0.13U
M458_keeper Vdd GND #996 Vdd pmos W=0.0975U L=0.26U
M459_ Vdd n__O0__f_520_6 #fb1001# Vdd pmos W=0.1625U L=0.13U
M460_keeper Vdd GND #999 Vdd pmos W=0.0975U L=0.91U
M461_ Vdd O1_at_520_6 #fb1004# Vdd pmos W=0.1625U L=0.13U
M462_keeper Vdd GND #1002 Vdd pmos W=0.0975U L=0.91U
M463_ Vdd O1_af_520_6 #fb1007# Vdd pmos W=0.1625U L=0.13U
M464_keeper Vdd GND #1005 Vdd pmos W=0.0975U L=0.26U
M465_ Vdd n__O0__t_521_6 #fb1010# Vdd pmos W=0.1625U L=0.13U
M466_keeper Vdd GND #1008 Vdd pmos W=0.0975U L=0.26U
M467_ Vdd n__O0__f_521_6 #fb1013# Vdd pmos W=0.1625U L=0.13U
M468_keeper Vdd GND #1011 Vdd pmos W=0.0975U L=0.91U
M469_ Vdd O1_at_521_6 #fb1016# Vdd pmos W=0.1625U L=0.13U
M470_keeper Vdd GND #1014 Vdd pmos W=0.0975U L=0.91U
M471_ Vdd O1_af_521_6 #fb1019# Vdd pmos W=0.1625U L=0.13U
M472_keeper Vdd GND #1017 Vdd pmos W=0.0975U L=0.26U
M473_ Vdd n__O0__t_522_6 #fb1022# Vdd pmos W=0.1625U L=0.13U
M474_keeper Vdd GND #1020 Vdd pmos W=0.0975U L=0.26U
M475_ Vdd n__O0__f_522_6 #fb1025# Vdd pmos W=0.1625U L=0.13U
M476_keeper Vdd GND #1023 Vdd pmos W=0.0975U L=0.91U
M477_ Vdd O1_at_522_6 #fb1028# Vdd pmos W=0.1625U L=0.13U
M478_keeper Vdd GND #1026 Vdd pmos W=0.0975U L=0.91U
M479_ Vdd O1_af_522_6 #fb1031# Vdd pmos W=0.1625U L=0.13U
M480_keeper Vdd GND #1029 Vdd pmos W=0.0975U L=0.26U
M481_ Vdd n__O0__t_523_6 #fb1034# Vdd pmos W=0.1625U L=0.13U
M482_keeper Vdd GND #1032 Vdd pmos W=0.0975U L=0.26U
M483_ Vdd n__O0__f_523_6 #fb1037# Vdd pmos W=0.1625U L=0.13U
M484_keeper Vdd GND #1035 Vdd pmos W=0.0975U L=0.91U
M485_ Vdd O1_at_523_6 #fb1040# Vdd pmos W=0.1625U L=0.13U
M486_keeper Vdd GND #1038 Vdd pmos W=0.0975U L=0.91U
M487_ Vdd O1_af_523_6 #fb1043# Vdd pmos W=0.1625U L=0.13U
M488_keeper Vdd GND #1041 Vdd pmos W=0.0975U L=0.26U
M489_ Vdd n__O0__t_524_6 #fb1046# Vdd pmos W=0.1625U L=0.13U
M490_keeper Vdd GND #1044 Vdd pmos W=0.0975U L=0.26U
M491_ Vdd n__O0__f_524_6 #fb1049# Vdd pmos W=0.1625U L=0.13U
M492_keeper Vdd GND #1047 Vdd pmos W=0.0975U L=0.91U
M493_ Vdd O1_at_524_6 #fb1052# Vdd pmos W=0.1625U L=0.13U
M494_keeper Vdd GND #1050 Vdd pmos W=0.0975U L=0.91U
M495_ Vdd O1_af_524_6 #fb1055# Vdd pmos W=0.1625U L=0.13U
M496_keeper Vdd GND #1053 Vdd pmos W=0.0975U L=0.26U
M497_ Vdd n__O0__t_525_6 #fb1058# Vdd pmos W=0.1625U L=0.13U
M498_keeper Vdd GND #1056 Vdd pmos W=0.0975U L=0.26U
M499_ Vdd n__O0__f_525_6 #fb1061# Vdd pmos W=0.1625U L=0.13U
M500_keeper Vdd GND #1059 Vdd pmos W=0.0975U L=0.91U
M501_ Vdd O1_at_525_6 #fb1064# Vdd pmos W=0.1625U L=0.13U
M502_keeper Vdd GND #1062 Vdd pmos W=0.0975U L=0.91U
M503_ Vdd O1_af_525_6 #fb1067# Vdd pmos W=0.1625U L=0.13U
M504_keeper Vdd GND #1065 Vdd pmos W=0.0975U L=0.26U
M505_ Vdd n__O0__t_526_6 #fb1070# Vdd pmos W=0.1625U L=0.13U
M506_keeper Vdd GND #1068 Vdd pmos W=0.0975U L=0.26U
M507_ Vdd n__O0__f_526_6 #fb1073# Vdd pmos W=0.1625U L=0.13U
M508_keeper Vdd GND #1071 Vdd pmos W=0.0975U L=0.91U
M509_ Vdd O1_at_526_6 #fb1076# Vdd pmos W=0.1625U L=0.13U
M510_keeper Vdd GND #1074 Vdd pmos W=0.0975U L=0.91U
M511_ Vdd O1_af_526_6 #fb1079# Vdd pmos W=0.1625U L=0.13U
M512_keeper Vdd GND #1077 Vdd pmos W=0.0975U L=0.26U
M513_ Vdd n__O0__t_527_6 #fb1082# Vdd pmos W=0.1625U L=0.13U
M514_keeper Vdd GND #1080 Vdd pmos W=0.0975U L=0.26U
M515_ Vdd n__O0__f_527_6 #fb1085# Vdd pmos W=0.1625U L=0.13U
M516_keeper Vdd GND #1083 Vdd pmos W=0.0975U L=0.91U
M517_ Vdd O1_at_527_6 #fb1088# Vdd pmos W=0.1625U L=0.13U
M518_keeper Vdd GND #1086 Vdd pmos W=0.0975U L=0.91U
M519_ Vdd O1_af_527_6 #fb1091# Vdd pmos W=0.1625U L=0.13U
M520_keeper Vdd GND #1089 Vdd pmos W=0.0975U L=0.26U
M521_ Vdd n__O0__t_528_6 #fb1094# Vdd pmos W=0.1625U L=0.13U
M522_keeper Vdd GND #1092 Vdd pmos W=0.0975U L=0.26U
M523_ Vdd n__O0__f_528_6 #fb1097# Vdd pmos W=0.1625U L=0.13U
M524_keeper Vdd GND #1095 Vdd pmos W=0.0975U L=0.91U
M525_ Vdd O1_at_528_6 #fb1100# Vdd pmos W=0.1625U L=0.13U
M526_keeper Vdd GND #1098 Vdd pmos W=0.0975U L=0.91U
M527_ Vdd O1_af_528_6 #fb1103# Vdd pmos W=0.1625U L=0.13U
M528_keeper Vdd GND #1101 Vdd pmos W=0.0975U L=0.26U
M529_ Vdd n__O0__t_529_6 #fb1106# Vdd pmos W=0.1625U L=0.13U
M530_keeper Vdd GND #1104 Vdd pmos W=0.0975U L=0.26U
M531_ Vdd n__O0__f_529_6 #fb1109# Vdd pmos W=0.1625U L=0.13U
M532_keeper Vdd GND #1107 Vdd pmos W=0.0975U L=0.91U
M533_ Vdd O1_at_529_6 #fb1112# Vdd pmos W=0.1625U L=0.13U
M534_keeper Vdd GND #1110 Vdd pmos W=0.0975U L=0.91U
M535_ Vdd O1_af_529_6 #fb1115# Vdd pmos W=0.1625U L=0.13U
M536_keeper Vdd GND #1113 Vdd pmos W=0.0975U L=0.26U
M537_ Vdd n__O0__t_530_6 #fb1118# Vdd pmos W=0.1625U L=0.13U
M538_keeper Vdd GND #1116 Vdd pmos W=0.0975U L=0.26U
M539_ Vdd n__O0__f_530_6 #fb1121# Vdd pmos W=0.1625U L=0.13U
M540_keeper Vdd GND #1119 Vdd pmos W=0.0975U L=0.91U
M541_ Vdd O1_at_530_6 #fb1124# Vdd pmos W=0.1625U L=0.13U
M542_keeper Vdd GND #1122 Vdd pmos W=0.0975U L=0.91U
M543_ Vdd O1_af_530_6 #fb1127# Vdd pmos W=0.1625U L=0.13U
M544_keeper Vdd GND #1125 Vdd pmos W=0.0975U L=0.26U
M545_ Vdd n__O0__t_531_6 #fb1130# Vdd pmos W=0.1625U L=0.13U
M546_keeper Vdd GND #1128 Vdd pmos W=0.0975U L=0.26U
M547_ Vdd n__O0__f_531_6 #fb1133# Vdd pmos W=0.1625U L=0.13U
M548_keeper Vdd GND #1131 Vdd pmos W=0.0975U L=0.91U
M549_ Vdd O1_at_531_6 #fb1136# Vdd pmos W=0.1625U L=0.13U
M550_keeper Vdd GND #1134 Vdd pmos W=0.0975U L=0.91U
M551_ Vdd O1_af_531_6 #fb1139# Vdd pmos W=0.1625U L=0.13U
M552_keeper Vdd GND #1137 Vdd pmos W=0.0975U L=0.26U
M553_keeper Vdd GND #1140 Vdd pmos W=0.0975U L=0.26U
M554_ GND inv__w__0i #46 GND nmos W=0.0975U L=0.065U
M555_ GND inv__s #109 GND nmos W=0.0975U L=0.065U
M556_ GND reset w__0i GND nmos W=0.0975U L=0.065U
M557_ GND inv__w__0i f GND nmos W=0.0975U L=0.065U
M558_ GND reset f GND nmos W=0.0975U L=0.065U
M559_ GND inv__s #224 GND nmos W=0.0975U L=0.065U
M560_ GND inv__s #230 GND nmos W=0.0975U L=0.065U
M561_ GND w__0i #237 GND nmos W=0.0975U L=0.065U
M562_ GND O0_aa #243 GND nmos W=0.0975U L=0.065U
M563_ GND O1_aa #243 GND nmos W=0.0975U L=0.065U
M564_ GND inv__s #250 GND nmos W=0.0975U L=0.065U
M565_ GND s #254 GND nmos W=0.0975U L=0.065U
M566_ GND p #259 GND nmos W=0.0975U L=0.065U
M567_ GND p #262 GND nmos W=0.0975U L=0.065U
M568_ GND inv__I__t_50_6 O1_at_50_6 GND nmos W=0.0975U L=0.065U
M569_ GND inv__I__f_50_6 O1_af_50_6 GND nmos W=0.0975U L=0.065U
M570_ GND p #273 GND nmos W=0.0975U L=0.065U
M571_ GND p #276 GND nmos W=0.0975U L=0.065U
M572_ GND inv__I__t_51_6 O1_at_51_6 GND nmos W=0.0975U L=0.065U
M573_ GND inv__I__f_51_6 O1_af_51_6 GND nmos W=0.0975U L=0.065U
M574_ GND p #287 GND nmos W=0.0975U L=0.065U
M575_ GND p #290 GND nmos W=0.0975U L=0.065U
M576_ GND inv__I__t_52_6 O1_at_52_6 GND nmos W=0.0975U L=0.065U
M577_ GND inv__I__f_52_6 O1_af_52_6 GND nmos W=0.0975U L=0.065U
M578_ GND p #301 GND nmos W=0.0975U L=0.065U
M579_ GND p #304 GND nmos W=0.0975U L=0.065U
M580_ GND inv__I__t_53_6 O1_at_53_6 GND nmos W=0.0975U L=0.065U
M581_ GND inv__I__f_53_6 O1_af_53_6 GND nmos W=0.0975U L=0.065U
M582_ GND p #315 GND nmos W=0.0975U L=0.065U
M583_ GND p #318 GND nmos W=0.0975U L=0.065U
M584_ GND inv__I__t_54_6 O1_at_54_6 GND nmos W=0.0975U L=0.065U
M585_ GND inv__I__f_54_6 O1_af_54_6 GND nmos W=0.0975U L=0.065U
M586_ GND p #329 GND nmos W=0.0975U L=0.065U
M587_ GND p #332 GND nmos W=0.0975U L=0.065U
M588_ GND inv__I__t_55_6 O1_at_55_6 GND nmos W=0.0975U L=0.065U
M589_ GND inv__I__f_55_6 O1_af_55_6 GND nmos W=0.0975U L=0.065U
M590_ GND p #343 GND nmos W=0.0975U L=0.065U
M591_ GND p #346 GND nmos W=0.0975U L=0.065U
M592_ GND inv__I__t_56_6 O1_at_56_6 GND nmos W=0.0975U L=0.065U
M593_ GND inv__I__f_56_6 O1_af_56_6 GND nmos W=0.0975U L=0.065U
M594_ GND p #357 GND nmos W=0.0975U L=0.065U
M595_ GND p #360 GND nmos W=0.0975U L=0.065U
M596_ GND inv__I__t_57_6 O1_at_57_6 GND nmos W=0.0975U L=0.065U
M597_ GND inv__I__f_57_6 O1_af_57_6 GND nmos W=0.0975U L=0.065U
M598_ GND p #371 GND nmos W=0.0975U L=0.065U
M599_ GND p #374 GND nmos W=0.0975U L=0.065U
M600_ GND inv__I__t_58_6 O1_at_58_6 GND nmos W=0.0975U L=0.065U
M601_ GND inv__I__f_58_6 O1_af_58_6 GND nmos W=0.0975U L=0.065U
M602_ GND p #385 GND nmos W=0.0975U L=0.065U
M603_ GND p #388 GND nmos W=0.0975U L=0.065U
M604_ GND inv__I__t_59_6 O1_at_59_6 GND nmos W=0.0975U L=0.065U
M605_ GND inv__I__f_59_6 O1_af_59_6 GND nmos W=0.0975U L=0.065U
M606_ GND p #399 GND nmos W=0.0975U L=0.065U
M607_ GND p #402 GND nmos W=0.0975U L=0.065U
M608_ GND inv__I__t_510_6 O1_at_510_6 GND nmos W=0.0975U L=0.065U
M609_ GND inv__I__f_510_6 O1_af_510_6 GND nmos W=0.0975U L=0.065U
M610_ GND p #413 GND nmos W=0.0975U L=0.065U
M611_ GND p #416 GND nmos W=0.0975U L=0.065U
M612_ GND inv__I__t_511_6 O1_at_511_6 GND nmos W=0.0975U L=0.065U
M613_ GND inv__I__f_511_6 O1_af_511_6 GND nmos W=0.0975U L=0.065U
M614_ GND p #427 GND nmos W=0.0975U L=0.065U
M615_ GND p #430 GND nmos W=0.0975U L=0.065U
M616_ GND inv__I__t_512_6 O1_at_512_6 GND nmos W=0.0975U L=0.065U
M617_ GND inv__I__f_512_6 O1_af_512_6 GND nmos W=0.0975U L=0.065U
M618_ GND p #441 GND nmos W=0.0975U L=0.065U
M619_ GND p #444 GND nmos W=0.0975U L=0.065U
M620_ GND inv__I__t_513_6 O1_at_513_6 GND nmos W=0.0975U L=0.065U
M621_ GND inv__I__f_513_6 O1_af_513_6 GND nmos W=0.0975U L=0.065U
M622_ GND p #453 GND nmos W=0.0975U L=0.065U
M623_ GND p #456 GND nmos W=0.0975U L=0.065U
M624_ GND inv__I__t_514_6 O1_at_514_6 GND nmos W=0.0975U L=0.065U
M625_ GND inv__I__f_514_6 O1_af_514_6 GND nmos W=0.0975U L=0.065U
M626_ GND p #465 GND nmos W=0.0975U L=0.065U
M627_ GND p #468 GND nmos W=0.0975U L=0.065U
M628_ GND inv__I__t_515_6 O1_at_515_6 GND nmos W=0.0975U L=0.065U
M629_ GND inv__I__f_515_6 O1_af_515_6 GND nmos W=0.0975U L=0.065U
M630_ GND p #477 GND nmos W=0.0975U L=0.065U
M631_ GND p #480 GND nmos W=0.0975U L=0.065U
M632_ GND inv__I__t_516_6 O1_at_516_6 GND nmos W=0.0975U L=0.065U
M633_ GND inv__I__f_516_6 O1_af_516_6 GND nmos W=0.0975U L=0.065U
M634_ GND p #489 GND nmos W=0.0975U L=0.065U
M635_ GND p #492 GND nmos W=0.0975U L=0.065U
M636_ GND inv__I__t_517_6 O1_at_517_6 GND nmos W=0.0975U L=0.065U
M637_ GND inv__I__f_517_6 O1_af_517_6 GND nmos W=0.0975U L=0.065U
M638_ GND p #501 GND nmos W=0.0975U L=0.065U
M639_ GND p #504 GND nmos W=0.0975U L=0.065U
M640_ GND inv__I__t_518_6 O1_at_518_6 GND nmos W=0.0975U L=0.065U
M641_ GND inv__I__f_518_6 O1_af_518_6 GND nmos W=0.0975U L=0.065U
M642_ GND p #513 GND nmos W=0.0975U L=0.065U
M643_ GND p #516 GND nmos W=0.0975U L=0.065U
M644_ GND inv__I__t_519_6 O1_at_519_6 GND nmos W=0.0975U L=0.065U
M645_ GND inv__I__f_519_6 O1_af_519_6 GND nmos W=0.0975U L=0.065U
M646_ GND p #525 GND nmos W=0.0975U L=0.065U
M647_ GND p #528 GND nmos W=0.0975U L=0.065U
M648_ GND inv__I__t_520_6 O1_at_520_6 GND nmos W=0.0975U L=0.065U
M649_ GND inv__I__f_520_6 O1_af_520_6 GND nmos W=0.0975U L=0.065U
M650_ GND p #537 GND nmos W=0.0975U L=0.065U
M651_ GND p #540 GND nmos W=0.0975U L=0.065U
M652_ GND inv__I__t_521_6 O1_at_521_6 GND nmos W=0.0975U L=0.065U
M653_ GND inv__I__f_521_6 O1_af_521_6 GND nmos W=0.0975U L=0.065U
M654_ GND p #549 GND nmos W=0.0975U L=0.065U
M655_ GND p #552 GND nmos W=0.0975U L=0.065U
M656_ GND inv__I__t_522_6 O1_at_522_6 GND nmos W=0.0975U L=0.065U
M657_ GND inv__I__f_522_6 O1_af_522_6 GND nmos W=0.0975U L=0.065U
M658_ GND p #561 GND nmos W=0.0975U L=0.065U
M659_ GND p #564 GND nmos W=0.0975U L=0.065U
M660_ GND inv__I__t_523_6 O1_at_523_6 GND nmos W=0.0975U L=0.065U
M661_ GND inv__I__f_523_6 O1_af_523_6 GND nmos W=0.0975U L=0.065U
M662_ GND p #573 GND nmos W=0.0975U L=0.065U
M663_ GND p #576 GND nmos W=0.0975U L=0.065U
M664_ GND inv__I__t_524_6 O1_at_524_6 GND nmos W=0.0975U L=0.065U
M665_ GND inv__I__f_524_6 O1_af_524_6 GND nmos W=0.0975U L=0.065U
M666_ GND p #585 GND nmos W=0.0975U L=0.065U
M667_ GND p #588 GND nmos W=0.0975U L=0.065U
M668_ GND inv__I__t_525_6 O1_at_525_6 GND nmos W=0.0975U L=0.065U
M669_ GND inv__I__f_525_6 O1_af_525_6 GND nmos W=0.0975U L=0.065U
M670_ GND p #597 GND nmos W=0.0975U L=0.065U
M671_ GND p #600 GND nmos W=0.0975U L=0.065U
M672_ GND inv__I__t_526_6 O1_at_526_6 GND nmos W=0.0975U L=0.065U
M673_ GND inv__I__f_526_6 O1_af_526_6 GND nmos W=0.0975U L=0.065U
M674_ GND p #609 GND nmos W=0.0975U L=0.065U
M675_ GND p #612 GND nmos W=0.0975U L=0.065U
M676_ GND inv__I__t_527_6 O1_at_527_6 GND nmos W=0.0975U L=0.065U
M677_ GND inv__I__f_527_6 O1_af_527_6 GND nmos W=0.0975U L=0.065U
M678_ GND p #621 GND nmos W=0.0975U L=0.065U
M679_ GND p #624 GND nmos W=0.0975U L=0.065U
M680_ GND inv__I__t_528_6 O1_at_528_6 GND nmos W=0.0975U L=0.065U
M681_ GND inv__I__f_528_6 O1_af_528_6 GND nmos W=0.0975U L=0.065U
M682_ GND p #633 GND nmos W=0.0975U L=0.065U
M683_ GND p #636 GND nmos W=0.0975U L=0.065U
M684_ GND inv__I__t_529_6 O1_at_529_6 GND nmos W=0.0975U L=0.065U
M685_ GND inv__I__f_529_6 O1_af_529_6 GND nmos W=0.0975U L=0.065U
M686_ GND p #645 GND nmos W=0.0975U L=0.065U
M687_ GND p #648 GND nmos W=0.0975U L=0.065U
M688_ GND inv__I__t_530_6 O1_at_530_6 GND nmos W=0.0975U L=0.065U
M689_ GND inv__I__f_530_6 O1_af_530_6 GND nmos W=0.0975U L=0.065U
M690_ GND p #657 GND nmos W=0.0975U L=0.065U
M691_ GND p #660 GND nmos W=0.0975U L=0.065U
M692_ GND inv__I__t_531_6 O1_at_531_6 GND nmos W=0.0975U L=0.065U
M693_ GND inv__I__f_531_6 O1_af_531_6 GND nmos W=0.0975U L=0.065U
M694_ GND w__0i inv__w__0i GND nmos W=0.0975U L=0.065U
M695_ GND s inv__s GND nmos W=0.0975U L=0.065U
M696_ GND reset inv__reset GND nmos W=0.0975U L=0.065U
M697_ GND p inv__p GND nmos W=0.0975U L=0.065U
M698_ GND O0_aa inv__O0__a GND nmos W=0.0975U L=0.065U
M699_ GND O1_aa inv__O1__a GND nmos W=0.0975U L=0.065U
M700_ GND n__w__0 w__0 GND nmos W=0.0975U L=0.065U
M701_ GND n__w__1 w__1 GND nmos W=0.0975U L=0.065U
M702_ GND n__v v GND nmos W=0.0975U L=0.065U
M703_ GND f inv__f GND nmos W=0.0975U L=0.065U
M704_ GND I_at_50_6 inv__I__t_50_6 GND nmos W=0.0975U L=0.065U
M705_ GND I_af_50_6 inv__I__f_50_6 GND nmos W=0.0975U L=0.065U
M706_ GND I_at_51_6 inv__I__t_51_6 GND nmos W=0.0975U L=0.065U
M707_ GND I_af_51_6 inv__I__f_51_6 GND nmos W=0.0975U L=0.065U
M708_ GND I_at_52_6 inv__I__t_52_6 GND nmos W=0.0975U L=0.065U
M709_ GND I_af_52_6 inv__I__f_52_6 GND nmos W=0.0975U L=0.065U
M710_ GND I_at_53_6 inv__I__t_53_6 GND nmos W=0.0975U L=0.065U
M711_ GND I_af_53_6 inv__I__f_53_6 GND nmos W=0.0975U L=0.065U
M712_ GND I_at_54_6 inv__I__t_54_6 GND nmos W=0.0975U L=0.065U
M713_ GND I_af_54_6 inv__I__f_54_6 GND nmos W=0.0975U L=0.065U
M714_ GND I_at_55_6 inv__I__t_55_6 GND nmos W=0.0975U L=0.065U
M715_ GND I_af_55_6 inv__I__f_55_6 GND nmos W=0.0975U L=0.065U
M716_ GND I_at_56_6 inv__I__t_56_6 GND nmos W=0.0975U L=0.065U
M717_ GND I_af_56_6 inv__I__f_56_6 GND nmos W=0.0975U L=0.065U
M718_ GND I_at_57_6 inv__I__t_57_6 GND nmos W=0.0975U L=0.065U
M719_ GND I_af_57_6 inv__I__f_57_6 GND nmos W=0.0975U L=0.065U
M720_ GND I_at_58_6 inv__I__t_58_6 GND nmos W=0.0975U L=0.065U
M721_ GND I_af_58_6 inv__I__f_58_6 GND nmos W=0.0975U L=0.065U
M722_ GND I_at_59_6 inv__I__t_59_6 GND nmos W=0.0975U L=0.065U
M723_ GND I_af_59_6 inv__I__f_59_6 GND nmos W=0.0975U L=0.065U
M724_ GND I_at_510_6 inv__I__t_510_6 GND nmos W=0.0975U L=0.065U
M725_ GND I_af_510_6 inv__I__f_510_6 GND nmos W=0.0975U L=0.065U
M726_ GND I_at_511_6 inv__I__t_511_6 GND nmos W=0.0975U L=0.065U
M727_ GND I_af_511_6 inv__I__f_511_6 GND nmos W=0.0975U L=0.065U
M728_ GND I_at_512_6 inv__I__t_512_6 GND nmos W=0.0975U L=0.065U
M729_ GND I_af_512_6 inv__I__f_512_6 GND nmos W=0.0975U L=0.065U
M730_ GND I_at_513_6 inv__I__t_513_6 GND nmos W=0.0975U L=0.065U
M731_ GND I_af_513_6 inv__I__f_513_6 GND nmos W=0.0975U L=0.065U
M732_ GND I_at_514_6 inv__I__t_514_6 GND nmos W=0.0975U L=0.065U
M733_ GND I_af_514_6 inv__I__f_514_6 GND nmos W=0.0975U L=0.065U
M734_ GND I_at_515_6 inv__I__t_515_6 GND nmos W=0.0975U L=0.065U
M735_ GND I_af_515_6 inv__I__f_515_6 GND nmos W=0.0975U L=0.065U
M736_ GND I_at_516_6 inv__I__t_516_6 GND nmos W=0.0975U L=0.065U
M737_ GND I_af_516_6 inv__I__f_516_6 GND nmos W=0.0975U L=0.065U
M738_ GND I_at_517_6 inv__I__t_517_6 GND nmos W=0.0975U L=0.065U
M739_ GND I_af_517_6 inv__I__f_517_6 GND nmos W=0.0975U L=0.065U
M740_ GND I_at_518_6 inv__I__t_518_6 GND nmos W=0.0975U L=0.065U
M741_ GND I_af_518_6 inv__I__f_518_6 GND nmos W=0.0975U L=0.065U
M742_ GND I_at_519_6 inv__I__t_519_6 GND nmos W=0.0975U L=0.065U
M743_ GND I_af_519_6 inv__I__f_519_6 GND nmos W=0.0975U L=0.065U
M744_ GND I_at_520_6 inv__I__t_520_6 GND nmos W=0.0975U L=0.065U
M745_ GND I_af_520_6 inv__I__f_520_6 GND nmos W=0.0975U L=0.065U
M746_ GND I_at_521_6 inv__I__t_521_6 GND nmos W=0.0975U L=0.065U
M747_ GND I_af_521_6 inv__I__f_521_6 GND nmos W=0.0975U L=0.065U
M748_ GND I_at_522_6 inv__I__t_522_6 GND nmos W=0.0975U L=0.065U
M749_ GND I_af_522_6 inv__I__f_522_6 GND nmos W=0.0975U L=0.065U
M750_ GND I_at_523_6 inv__I__t_523_6 GND nmos W=0.0975U L=0.065U
M751_ GND I_af_523_6 inv__I__f_523_6 GND nmos W=0.0975U L=0.065U
M752_ GND I_at_524_6 inv__I__t_524_6 GND nmos W=0.0975U L=0.065U
M753_ GND I_af_524_6 inv__I__f_524_6 GND nmos W=0.0975U L=0.065U
M754_ GND I_at_525_6 inv__I__t_525_6 GND nmos W=0.0975U L=0.065U
M755_ GND I_af_525_6 inv__I__f_525_6 GND nmos W=0.0975U L=0.065U
M756_ GND I_at_526_6 inv__I__t_526_6 GND nmos W=0.0975U L=0.065U
M757_ GND I_af_526_6 inv__I__f_526_6 GND nmos W=0.0975U L=0.065U
M758_ GND I_at_527_6 inv__I__t_527_6 GND nmos W=0.0975U L=0.065U
M759_ GND I_af_527_6 inv__I__f_527_6 GND nmos W=0.0975U L=0.065U
M760_ GND I_at_528_6 inv__I__t_528_6 GND nmos W=0.0975U L=0.065U
M761_ GND I_af_528_6 inv__I__f_528_6 GND nmos W=0.0975U L=0.065U
M762_ GND I_at_529_6 inv__I__t_529_6 GND nmos W=0.0975U L=0.065U
M763_ GND I_af_529_6 inv__I__f_529_6 GND nmos W=0.0975U L=0.065U
M764_ GND I_at_530_6 inv__I__t_530_6 GND nmos W=0.0975U L=0.065U
M765_ GND I_af_530_6 inv__I__f_530_6 GND nmos W=0.0975U L=0.065U
M766_ GND I_at_531_6 inv__I__t_531_6 GND nmos W=0.0975U L=0.065U
M767_ GND I_af_531_6 inv__I__f_531_6 GND nmos W=0.0975U L=0.065U
M768_ GND n__I__a I_aa GND nmos W=0.0975U L=0.065U
M769_ GND n__O0__t_50_6 O0_at_50_6 GND nmos W=0.0975U L=0.065U
M770_ GND n__O0__f_50_6 O0_af_50_6 GND nmos W=0.0975U L=0.065U
M771_ GND n__O0__t_51_6 O0_at_51_6 GND nmos W=0.0975U L=0.065U
M772_ GND n__O0__f_51_6 O0_af_51_6 GND nmos W=0.0975U L=0.065U
M773_ GND n__O0__t_52_6 O0_at_52_6 GND nmos W=0.0975U L=0.065U
M774_ GND n__O0__f_52_6 O0_af_52_6 GND nmos W=0.0975U L=0.065U
M775_ GND n__O0__t_53_6 O0_at_53_6 GND nmos W=0.0975U L=0.065U
M776_ GND n__O0__f_53_6 O0_af_53_6 GND nmos W=0.0975U L=0.065U
M777_ GND n__O0__t_54_6 O0_at_54_6 GND nmos W=0.0975U L=0.065U
M778_ GND n__O0__f_54_6 O0_af_54_6 GND nmos W=0.0975U L=0.065U
M779_ GND n__O0__t_55_6 O0_at_55_6 GND nmos W=0.0975U L=0.065U
M780_ GND n__O0__f_55_6 O0_af_55_6 GND nmos W=0.0975U L=0.065U
M781_ GND n__O0__t_56_6 O0_at_56_6 GND nmos W=0.0975U L=0.065U
M782_ GND n__O0__f_56_6 O0_af_56_6 GND nmos W=0.0975U L=0.065U
M783_ GND n__O0__t_57_6 O0_at_57_6 GND nmos W=0.0975U L=0.065U
M784_ GND n__O0__f_57_6 O0_af_57_6 GND nmos W=0.0975U L=0.065U
M785_ GND n__O0__t_58_6 O0_at_58_6 GND nmos W=0.0975U L=0.065U
M786_ GND n__O0__f_58_6 O0_af_58_6 GND nmos W=0.0975U L=0.065U
M787_ GND n__O0__t_59_6 O0_at_59_6 GND nmos W=0.0975U L=0.065U
M788_ GND n__O0__f_59_6 O0_af_59_6 GND nmos W=0.0975U L=0.065U
M789_ GND n__O0__t_510_6 O0_at_510_6 GND nmos W=0.0975U L=0.065U
M790_ GND n__O0__f_510_6 O0_af_510_6 GND nmos W=0.0975U L=0.065U
M791_ GND n__O0__t_511_6 O0_at_511_6 GND nmos W=0.0975U L=0.065U
M792_ GND n__O0__f_511_6 O0_af_511_6 GND nmos W=0.0975U L=0.065U
M793_ GND n__O0__t_512_6 O0_at_512_6 GND nmos W=0.0975U L=0.065U
M794_ GND n__O0__f_512_6 O0_af_512_6 GND nmos W=0.0975U L=0.065U
M795_ GND n__O0__t_513_6 O0_at_513_6 GND nmos W=0.0975U L=0.065U
M796_ GND n__O0__f_513_6 O0_af_513_6 GND nmos W=0.0975U L=0.065U
M797_ GND n__O0__t_514_6 O0_at_514_6 GND nmos W=0.0975U L=0.065U
M798_ GND n__O0__f_514_6 O0_af_514_6 GND nmos W=0.0975U L=0.065U
M799_ GND n__O0__t_515_6 O0_at_515_6 GND nmos W=0.0975U L=0.065U
M800_ GND n__O0__f_515_6 O0_af_515_6 GND nmos W=0.0975U L=0.065U
M801_ GND n__O0__t_516_6 O0_at_516_6 GND nmos W=0.0975U L=0.065U
M802_ GND n__O0__f_516_6 O0_af_516_6 GND nmos W=0.0975U L=0.065U
M803_ GND n__O0__t_517_6 O0_at_517_6 GND nmos W=0.0975U L=0.065U
M804_ GND n__O0__f_517_6 O0_af_517_6 GND nmos W=0.0975U L=0.065U
M805_ GND n__O0__t_518_6 O0_at_518_6 GND nmos W=0.0975U L=0.065U
M806_ GND n__O0__f_518_6 O0_af_518_6 GND nmos W=0.0975U L=0.065U
M807_ GND n__O0__t_519_6 O0_at_519_6 GND nmos W=0.0975U L=0.065U
M808_ GND n__O0__f_519_6 O0_af_519_6 GND nmos W=0.0975U L=0.065U
M809_ GND n__O0__t_520_6 O0_at_520_6 GND nmos W=0.0975U L=0.065U
M810_ GND n__O0__f_520_6 O0_af_520_6 GND nmos W=0.0975U L=0.065U
M811_ GND n__O0__t_521_6 O0_at_521_6 GND nmos W=0.0975U L=0.065U
M812_ GND n__O0__f_521_6 O0_af_521_6 GND nmos W=0.0975U L=0.065U
M813_ GND n__O0__t_522_6 O0_at_522_6 GND nmos W=0.0975U L=0.065U
M814_ GND n__O0__f_522_6 O0_af_522_6 GND nmos W=0.0975U L=0.065U
M815_ GND n__O0__t_523_6 O0_at_523_6 GND nmos W=0.0975U L=0.065U
M816_ GND n__O0__f_523_6 O0_af_523_6 GND nmos W=0.0975U L=0.065U
M817_ GND n__O0__t_524_6 O0_at_524_6 GND nmos W=0.0975U L=0.065U
M818_ GND n__O0__f_524_6 O0_af_524_6 GND nmos W=0.0975U L=0.065U
M819_ GND n__O0__t_525_6 O0_at_525_6 GND nmos W=0.0975U L=0.065U
M820_ GND n__O0__f_525_6 O0_af_525_6 GND nmos W=0.0975U L=0.065U
M821_ GND n__O0__t_526_6 O0_at_526_6 GND nmos W=0.0975U L=0.065U
M822_ GND n__O0__f_526_6 O0_af_526_6 GND nmos W=0.0975U L=0.065U
M823_ GND n__O0__t_527_6 O0_at_527_6 GND nmos W=0.0975U L=0.065U
M824_ GND n__O0__f_527_6 O0_af_527_6 GND nmos W=0.0975U L=0.065U
M825_ GND n__O0__t_528_6 O0_at_528_6 GND nmos W=0.0975U L=0.065U
M826_ GND n__O0__f_528_6 O0_af_528_6 GND nmos W=0.0975U L=0.065U
M827_ GND n__O0__t_529_6 O0_at_529_6 GND nmos W=0.0975U L=0.065U
M828_ GND n__O0__f_529_6 O0_af_529_6 GND nmos W=0.0975U L=0.065U
M829_ GND n__O0__t_530_6 O0_at_530_6 GND nmos W=0.0975U L=0.065U
M830_ GND n__O0__f_530_6 O0_af_530_6 GND nmos W=0.0975U L=0.065U
M831_ GND n__O0__t_531_6 O0_at_531_6 GND nmos W=0.0975U L=0.065U
M832_ GND n__O0__f_531_6 O0_af_531_6 GND nmos W=0.0975U L=0.065U
M833_ GND p #fb734# GND nmos W=0.0975U L=0.13U
M834_ GND w__0i #fb737# GND nmos W=0.0975U L=0.13U
M835_keeper GND Vdd #736 GND nmos W=0.0975U L=16.315U
M836_ GND s #fb740# GND nmos W=0.0975U L=0.13U
M837_keeper GND Vdd #739 GND nmos W=0.0975U L=16.315U
M838_ GND f #fb743# GND nmos W=0.0975U L=0.13U
M839_keeper GND Vdd #742 GND nmos W=0.0975U L=3.055U
M840_ GND n__w__0 #fb746# GND nmos W=0.0975U L=0.13U
M841_keeper GND Vdd #745 GND nmos W=0.0975U L=50.635U
M842_ GND n__I__a #fb749# GND nmos W=0.0975U L=0.13U
M843_keeper GND Vdd #748 GND nmos W=0.0975U L=3.055U
M844_ GND n__w__1 #fb752# GND nmos W=0.0975U L=0.13U
M845_keeper GND Vdd #751 GND nmos W=0.0975U L=1.495U
M846_ GND n__v #fb755# GND nmos W=0.0975U L=0.13U
M847_keeper GND Vdd #754 GND nmos W=0.0975U L=3.055U
M848_ GND n__O0__t_50_6 #fb758# GND nmos W=0.0975U L=0.13U
M849_keeper GND Vdd #757 GND nmos W=0.0975U L=3.055U
M850_ GND n__O0__f_50_6 #fb761# GND nmos W=0.0975U L=0.13U
M851_keeper GND Vdd #760 GND nmos W=0.0975U L=0.715U
M852_ GND O1_at_50_6 #fb764# GND nmos W=0.0975U L=0.13U
M853_keeper GND Vdd #763 GND nmos W=0.0975U L=0.715U
M854_ GND O1_af_50_6 #fb767# GND nmos W=0.0975U L=0.13U
M855_keeper GND Vdd #766 GND nmos W=0.0975U L=2.275U
M856_ GND n__O0__t_51_6 #fb770# GND nmos W=0.0975U L=0.13U
M857_keeper GND Vdd #769 GND nmos W=0.0975U L=2.275U
M858_ GND n__O0__f_51_6 #fb773# GND nmos W=0.0975U L=0.13U
M859_keeper GND Vdd #772 GND nmos W=0.0975U L=0.715U
M860_ GND O1_at_51_6 #fb776# GND nmos W=0.0975U L=0.13U
M861_keeper GND Vdd #775 GND nmos W=0.0975U L=0.715U
M862_ GND O1_af_51_6 #fb779# GND nmos W=0.0975U L=0.13U
M863_keeper GND Vdd #778 GND nmos W=0.0975U L=2.275U
M864_ GND n__O0__t_52_6 #fb782# GND nmos W=0.0975U L=0.13U
M865_keeper GND Vdd #781 GND nmos W=0.0975U L=2.275U
M866_ GND n__O0__f_52_6 #fb785# GND nmos W=0.0975U L=0.13U
M867_keeper GND Vdd #784 GND nmos W=0.0975U L=0.715U
M868_ GND O1_at_52_6 #fb788# GND nmos W=0.0975U L=0.13U
M869_keeper GND Vdd #787 GND nmos W=0.0975U L=0.715U
M870_ GND O1_af_52_6 #fb791# GND nmos W=0.0975U L=0.13U
M871_keeper GND Vdd #790 GND nmos W=0.0975U L=2.275U
M872_ GND n__O0__t_53_6 #fb794# GND nmos W=0.0975U L=0.13U
M873_keeper GND Vdd #793 GND nmos W=0.0975U L=2.275U
M874_ GND n__O0__f_53_6 #fb797# GND nmos W=0.0975U L=0.13U
M875_keeper GND Vdd #796 GND nmos W=0.0975U L=0.715U
M876_ GND O1_at_53_6 #fb800# GND nmos W=0.0975U L=0.13U
M877_keeper GND Vdd #799 GND nmos W=0.0975U L=0.715U
M878_ GND O1_af_53_6 #fb803# GND nmos W=0.0975U L=0.13U
M879_keeper GND Vdd #802 GND nmos W=0.0975U L=2.275U
M880_ GND n__O0__t_54_6 #fb806# GND nmos W=0.0975U L=0.13U
M881_keeper GND Vdd #805 GND nmos W=0.0975U L=2.275U
M882_ GND n__O0__f_54_6 #fb809# GND nmos W=0.0975U L=0.13U
M883_keeper GND Vdd #808 GND nmos W=0.0975U L=0.715U
M884_ GND O1_at_54_6 #fb812# GND nmos W=0.0975U L=0.13U
M885_keeper GND Vdd #811 GND nmos W=0.0975U L=0.715U
M886_ GND O1_af_54_6 #fb815# GND nmos W=0.0975U L=0.13U
M887_keeper GND Vdd #814 GND nmos W=0.0975U L=2.275U
M888_ GND n__O0__t_55_6 #fb818# GND nmos W=0.0975U L=0.13U
M889_keeper GND Vdd #817 GND nmos W=0.0975U L=2.275U
M890_ GND n__O0__f_55_6 #fb821# GND nmos W=0.0975U L=0.13U
M891_keeper GND Vdd #820 GND nmos W=0.0975U L=0.715U
M892_ GND O1_at_55_6 #fb824# GND nmos W=0.0975U L=0.13U
M893_keeper GND Vdd #823 GND nmos W=0.0975U L=0.715U
M894_ GND O1_af_55_6 #fb827# GND nmos W=0.0975U L=0.13U
M895_keeper GND Vdd #826 GND nmos W=0.0975U L=2.275U
M896_ GND n__O0__t_56_6 #fb830# GND nmos W=0.0975U L=0.13U
M897_keeper GND Vdd #829 GND nmos W=0.0975U L=2.275U
M898_ GND n__O0__f_56_6 #fb833# GND nmos W=0.0975U L=0.13U
M899_keeper GND Vdd #832 GND nmos W=0.0975U L=0.715U
M900_ GND O1_at_56_6 #fb836# GND nmos W=0.0975U L=0.13U
M901_keeper GND Vdd #835 GND nmos W=0.0975U L=0.715U
M902_ GND O1_af_56_6 #fb839# GND nmos W=0.0975U L=0.13U
M903_keeper GND Vdd #838 GND nmos W=0.0975U L=2.275U
M904_ GND n__O0__t_57_6 #fb842# GND nmos W=0.0975U L=0.13U
M905_keeper GND Vdd #841 GND nmos W=0.0975U L=2.275U
M906_ GND n__O0__f_57_6 #fb845# GND nmos W=0.0975U L=0.13U
M907_keeper GND Vdd #844 GND nmos W=0.0975U L=0.715U
M908_ GND O1_at_57_6 #fb848# GND nmos W=0.0975U L=0.13U
M909_keeper GND Vdd #847 GND nmos W=0.0975U L=0.715U
M910_ GND O1_af_57_6 #fb851# GND nmos W=0.0975U L=0.13U
M911_keeper GND Vdd #850 GND nmos W=0.0975U L=2.275U
M912_ GND n__O0__t_58_6 #fb854# GND nmos W=0.0975U L=0.13U
M913_keeper GND Vdd #853 GND nmos W=0.0975U L=2.275U
M914_ GND n__O0__f_58_6 #fb857# GND nmos W=0.0975U L=0.13U
M915_keeper GND Vdd #856 GND nmos W=0.0975U L=0.715U
M916_ GND O1_at_58_6 #fb860# GND nmos W=0.0975U L=0.13U
M917_keeper GND Vdd #859 GND nmos W=0.0975U L=0.715U
M918_ GND O1_af_58_6 #fb863# GND nmos W=0.0975U L=0.13U
M919_keeper GND Vdd #862 GND nmos W=0.0975U L=2.275U
M920_ GND n__O0__t_59_6 #fb866# GND nmos W=0.0975U L=0.13U
M921_keeper GND Vdd #865 GND nmos W=0.0975U L=2.275U
M922_ GND n__O0__f_59_6 #fb869# GND nmos W=0.0975U L=0.13U
M923_keeper GND Vdd #868 GND nmos W=0.0975U L=0.715U
M924_ GND O1_at_59_6 #fb872# GND nmos W=0.0975U L=0.13U
M925_keeper GND Vdd #871 GND nmos W=0.0975U L=0.715U
M926_ GND O1_af_59_6 #fb875# GND nmos W=0.0975U L=0.13U
M927_keeper GND Vdd #874 GND nmos W=0.0975U L=2.275U
M928_ GND n__O0__t_510_6 #fb878# GND nmos W=0.0975U L=0.13U
M929_keeper GND Vdd #877 GND nmos W=0.0975U L=2.275U
M930_ GND n__O0__f_510_6 #fb881# GND nmos W=0.0975U L=0.13U
M931_keeper GND Vdd #880 GND nmos W=0.0975U L=0.715U
M932_ GND O1_at_510_6 #fb884# GND nmos W=0.0975U L=0.13U
M933_keeper GND Vdd #883 GND nmos W=0.0975U L=0.715U
M934_ GND O1_af_510_6 #fb887# GND nmos W=0.0975U L=0.13U
M935_keeper GND Vdd #886 GND nmos W=0.0975U L=2.275U
M936_ GND n__O0__t_511_6 #fb890# GND nmos W=0.0975U L=0.13U
M937_keeper GND Vdd #889 GND nmos W=0.0975U L=2.275U
M938_ GND n__O0__f_511_6 #fb893# GND nmos W=0.0975U L=0.13U
M939_keeper GND Vdd #892 GND nmos W=0.0975U L=0.715U
M940_ GND O1_at_511_6 #fb896# GND nmos W=0.0975U L=0.13U
M941_keeper GND Vdd #895 GND nmos W=0.0975U L=0.715U
M942_ GND O1_af_511_6 #fb899# GND nmos W=0.0975U L=0.13U
M943_keeper GND Vdd #898 GND nmos W=0.0975U L=2.275U
M944_ GND n__O0__t_512_6 #fb902# GND nmos W=0.0975U L=0.13U
M945_keeper GND Vdd #901 GND nmos W=0.0975U L=2.275U
M946_ GND n__O0__f_512_6 #fb905# GND nmos W=0.0975U L=0.13U
M947_keeper GND Vdd #904 GND nmos W=0.0975U L=0.715U
M948_ GND O1_at_512_6 #fb908# GND nmos W=0.0975U L=0.13U
M949_keeper GND Vdd #907 GND nmos W=0.0975U L=0.715U
M950_ GND O1_af_512_6 #fb911# GND nmos W=0.0975U L=0.13U
M951_keeper GND Vdd #910 GND nmos W=0.0975U L=2.275U
M952_ GND n__O0__t_513_6 #fb914# GND nmos W=0.0975U L=0.13U
M953_keeper GND Vdd #913 GND nmos W=0.0975U L=2.275U
M954_ GND n__O0__f_513_6 #fb917# GND nmos W=0.0975U L=0.13U
M955_keeper GND Vdd #916 GND nmos W=0.0975U L=0.715U
M956_ GND O1_at_513_6 #fb920# GND nmos W=0.0975U L=0.13U
M957_keeper GND Vdd #919 GND nmos W=0.0975U L=0.715U
M958_ GND O1_af_513_6 #fb923# GND nmos W=0.0975U L=0.13U
M959_keeper GND Vdd #922 GND nmos W=0.0975U L=2.275U
M960_ GND n__O0__t_514_6 #fb926# GND nmos W=0.0975U L=0.13U
M961_keeper GND Vdd #925 GND nmos W=0.0975U L=2.275U
M962_ GND n__O0__f_514_6 #fb929# GND nmos W=0.0975U L=0.13U
M963_keeper GND Vdd #928 GND nmos W=0.0975U L=0.715U
M964_ GND O1_at_514_6 #fb932# GND nmos W=0.0975U L=0.13U
M965_keeper GND Vdd #931 GND nmos W=0.0975U L=0.715U
M966_ GND O1_af_514_6 #fb935# GND nmos W=0.0975U L=0.13U
M967_keeper GND Vdd #934 GND nmos W=0.0975U L=2.275U
M968_ GND n__O0__t_515_6 #fb938# GND nmos W=0.0975U L=0.13U
M969_keeper GND Vdd #937 GND nmos W=0.0975U L=2.275U
M970_ GND n__O0__f_515_6 #fb941# GND nmos W=0.0975U L=0.13U
M971_keeper GND Vdd #940 GND nmos W=0.0975U L=0.715U
M972_ GND O1_at_515_6 #fb944# GND nmos W=0.0975U L=0.13U
M973_keeper GND Vdd #943 GND nmos W=0.0975U L=0.715U
M974_ GND O1_af_515_6 #fb947# GND nmos W=0.0975U L=0.13U
M975_keeper GND Vdd #946 GND nmos W=0.0975U L=2.275U
M976_ GND n__O0__t_516_6 #fb950# GND nmos W=0.0975U L=0.13U
M977_keeper GND Vdd #949 GND nmos W=0.0975U L=2.275U
M978_ GND n__O0__f_516_6 #fb953# GND nmos W=0.0975U L=0.13U
M979_keeper GND Vdd #952 GND nmos W=0.0975U L=0.715U
M980_ GND O1_at_516_6 #fb956# GND nmos W=0.0975U L=0.13U
M981_keeper GND Vdd #955 GND nmos W=0.0975U L=0.715U
M982_ GND O1_af_516_6 #fb959# GND nmos W=0.0975U L=0.13U
M983_keeper GND Vdd #958 GND nmos W=0.0975U L=2.275U
M984_ GND n__O0__t_517_6 #fb962# GND nmos W=0.0975U L=0.13U
M985_keeper GND Vdd #961 GND nmos W=0.0975U L=2.275U
M986_ GND n__O0__f_517_6 #fb965# GND nmos W=0.0975U L=0.13U
M987_keeper GND Vdd #964 GND nmos W=0.0975U L=0.715U
M988_ GND O1_at_517_6 #fb968# GND nmos W=0.0975U L=0.13U
M989_keeper GND Vdd #967 GND nmos W=0.0975U L=0.715U
M990_ GND O1_af_517_6 #fb971# GND nmos W=0.0975U L=0.13U
M991_keeper GND Vdd #970 GND nmos W=0.0975U L=2.275U
M992_ GND n__O0__t_518_6 #fb974# GND nmos W=0.0975U L=0.13U
M993_keeper GND Vdd #973 GND nmos W=0.0975U L=2.275U
M994_ GND n__O0__f_518_6 #fb977# GND nmos W=0.0975U L=0.13U
M995_keeper GND Vdd #976 GND nmos W=0.0975U L=0.715U
M996_ GND O1_at_518_6 #fb980# GND nmos W=0.0975U L=0.13U
M997_keeper GND Vdd #979 GND nmos W=0.0975U L=0.715U
M998_ GND O1_af_518_6 #fb983# GND nmos W=0.0975U L=0.13U
M999_keeper GND Vdd #982 GND nmos W=0.0975U L=2.275U
M1000_ GND n__O0__t_519_6 #fb986# GND nmos W=0.0975U L=0.13U
M1001_keeper GND Vdd #985 GND nmos W=0.0975U L=2.275U
M1002_ GND n__O0__f_519_6 #fb989# GND nmos W=0.0975U L=0.13U
M1003_keeper GND Vdd #988 GND nmos W=0.0975U L=0.715U
M1004_ GND O1_at_519_6 #fb992# GND nmos W=0.0975U L=0.13U
M1005_keeper GND Vdd #991 GND nmos W=0.0975U L=0.715U
M1006_ GND O1_af_519_6 #fb995# GND nmos W=0.0975U L=0.13U
M1007_keeper GND Vdd #994 GND nmos W=0.0975U L=2.275U
M1008_ GND n__O0__t_520_6 #fb998# GND nmos W=0.0975U L=0.13U
M1009_keeper GND Vdd #997 GND nmos W=0.0975U L=2.275U
M1010_ GND n__O0__f_520_6 #fb1001# GND nmos W=0.0975U L=0.13U
M1011_keeper GND Vdd #1000 GND nmos W=0.0975U L=0.715U
M1012_ GND O1_at_520_6 #fb1004# GND nmos W=0.0975U L=0.13U
M1013_keeper GND Vdd #1003 GND nmos W=0.0975U L=0.715U
M1014_ GND O1_af_520_6 #fb1007# GND nmos W=0.0975U L=0.13U
M1015_keeper GND Vdd #1006 GND nmos W=0.0975U L=2.275U
M1016_ GND n__O0__t_521_6 #fb1010# GND nmos W=0.0975U L=0.13U
M1017_keeper GND Vdd #1009 GND nmos W=0.0975U L=2.275U
M1018_ GND n__O0__f_521_6 #fb1013# GND nmos W=0.0975U L=0.13U
M1019_keeper GND Vdd #1012 GND nmos W=0.0975U L=0.715U
M1020_ GND O1_at_521_6 #fb1016# GND nmos W=0.0975U L=0.13U
M1021_keeper GND Vdd #1015 GND nmos W=0.0975U L=0.715U
M1022_ GND O1_af_521_6 #fb1019# GND nmos W=0.0975U L=0.13U
M1023_keeper GND Vdd #1018 GND nmos W=0.0975U L=2.275U
M1024_ GND n__O0__t_522_6 #fb1022# GND nmos W=0.0975U L=0.13U
M1025_keeper GND Vdd #1021 GND nmos W=0.0975U L=2.275U
M1026_ GND n__O0__f_522_6 #fb1025# GND nmos W=0.0975U L=0.13U
M1027_keeper GND Vdd #1024 GND nmos W=0.0975U L=0.715U
M1028_ GND O1_at_522_6 #fb1028# GND nmos W=0.0975U L=0.13U
M1029_keeper GND Vdd #1027 GND nmos W=0.0975U L=0.715U
M1030_ GND O1_af_522_6 #fb1031# GND nmos W=0.0975U L=0.13U
M1031_keeper GND Vdd #1030 GND nmos W=0.0975U L=2.275U
M1032_ GND n__O0__t_523_6 #fb1034# GND nmos W=0.0975U L=0.13U
M1033_keeper GND Vdd #1033 GND nmos W=0.0975U L=2.275U
M1034_ GND n__O0__f_523_6 #fb1037# GND nmos W=0.0975U L=0.13U
M1035_keeper GND Vdd #1036 GND nmos W=0.0975U L=0.715U
M1036_ GND O1_at_523_6 #fb1040# GND nmos W=0.0975U L=0.13U
M1037_keeper GND Vdd #1039 GND nmos W=0.0975U L=0.715U
M1038_ GND O1_af_523_6 #fb1043# GND nmos W=0.0975U L=0.13U
M1039_keeper GND Vdd #1042 GND nmos W=0.0975U L=2.275U
M1040_ GND n__O0__t_524_6 #fb1046# GND nmos W=0.0975U L=0.13U
M1041_keeper GND Vdd #1045 GND nmos W=0.0975U L=2.275U
M1042_ GND n__O0__f_524_6 #fb1049# GND nmos W=0.0975U L=0.13U
M1043_keeper GND Vdd #1048 GND nmos W=0.0975U L=0.715U
M1044_ GND O1_at_524_6 #fb1052# GND nmos W=0.0975U L=0.13U
M1045_keeper GND Vdd #1051 GND nmos W=0.0975U L=0.715U
M1046_ GND O1_af_524_6 #fb1055# GND nmos W=0.0975U L=0.13U
M1047_keeper GND Vdd #1054 GND nmos W=0.0975U L=2.275U
M1048_ GND n__O0__t_525_6 #fb1058# GND nmos W=0.0975U L=0.13U
M1049_keeper GND Vdd #1057 GND nmos W=0.0975U L=2.275U
M1050_ GND n__O0__f_525_6 #fb1061# GND nmos W=0.0975U L=0.13U
M1051_keeper GND Vdd #1060 GND nmos W=0.0975U L=0.715U
M1052_ GND O1_at_525_6 #fb1064# GND nmos W=0.0975U L=0.13U
M1053_keeper GND Vdd #1063 GND nmos W=0.0975U L=0.715U
M1054_ GND O1_af_525_6 #fb1067# GND nmos W=0.0975U L=0.13U
M1055_keeper GND Vdd #1066 GND nmos W=0.0975U L=2.275U
M1056_ GND n__O0__t_526_6 #fb1070# GND nmos W=0.0975U L=0.13U
M1057_keeper GND Vdd #1069 GND nmos W=0.0975U L=2.275U
M1058_ GND n__O0__f_526_6 #fb1073# GND nmos W=0.0975U L=0.13U
M1059_keeper GND Vdd #1072 GND nmos W=0.0975U L=0.715U
M1060_ GND O1_at_526_6 #fb1076# GND nmos W=0.0975U L=0.13U
M1061_keeper GND Vdd #1075 GND nmos W=0.0975U L=0.715U
M1062_ GND O1_af_526_6 #fb1079# GND nmos W=0.0975U L=0.13U
M1063_keeper GND Vdd #1078 GND nmos W=0.0975U L=2.275U
M1064_ GND n__O0__t_527_6 #fb1082# GND nmos W=0.0975U L=0.13U
M1065_keeper GND Vdd #1081 GND nmos W=0.0975U L=2.275U
M1066_ GND n__O0__f_527_6 #fb1085# GND nmos W=0.0975U L=0.13U
M1067_keeper GND Vdd #1084 GND nmos W=0.0975U L=0.715U
M1068_ GND O1_at_527_6 #fb1088# GND nmos W=0.0975U L=0.13U
M1069_keeper GND Vdd #1087 GND nmos W=0.0975U L=0.715U
M1070_ GND O1_af_527_6 #fb1091# GND nmos W=0.0975U L=0.13U
M1071_keeper GND Vdd #1090 GND nmos W=0.0975U L=2.275U
M1072_ GND n__O0__t_528_6 #fb1094# GND nmos W=0.0975U L=0.13U
M1073_keeper GND Vdd #1093 GND nmos W=0.0975U L=2.275U
M1074_ GND n__O0__f_528_6 #fb1097# GND nmos W=0.0975U L=0.13U
M1075_keeper GND Vdd #1096 GND nmos W=0.0975U L=0.715U
M1076_ GND O1_at_528_6 #fb1100# GND nmos W=0.0975U L=0.13U
M1077_keeper GND Vdd #1099 GND nmos W=0.0975U L=0.715U
M1078_ GND O1_af_528_6 #fb1103# GND nmos W=0.0975U L=0.13U
M1079_keeper GND Vdd #1102 GND nmos W=0.0975U L=2.275U
M1080_ GND n__O0__t_529_6 #fb1106# GND nmos W=0.0975U L=0.13U
M1081_keeper GND Vdd #1105 GND nmos W=0.0975U L=2.275U
M1082_ GND n__O0__f_529_6 #fb1109# GND nmos W=0.0975U L=0.13U
M1083_keeper GND Vdd #1108 GND nmos W=0.0975U L=0.715U
M1084_ GND O1_at_529_6 #fb1112# GND nmos W=0.0975U L=0.13U
M1085_keeper GND Vdd #1111 GND nmos W=0.0975U L=0.715U
M1086_ GND O1_af_529_6 #fb1115# GND nmos W=0.0975U L=0.13U
M1087_keeper GND Vdd #1114 GND nmos W=0.0975U L=2.275U
M1088_ GND n__O0__t_530_6 #fb1118# GND nmos W=0.0975U L=0.13U
M1089_keeper GND Vdd #1117 GND nmos W=0.0975U L=2.275U
M1090_ GND n__O0__f_530_6 #fb1121# GND nmos W=0.0975U L=0.13U
M1091_keeper GND Vdd #1120 GND nmos W=0.0975U L=0.715U
M1092_ GND O1_at_530_6 #fb1124# GND nmos W=0.0975U L=0.13U
M1093_keeper GND Vdd #1123 GND nmos W=0.0975U L=0.715U
M1094_ GND O1_af_530_6 #fb1127# GND nmos W=0.0975U L=0.13U
M1095_keeper GND Vdd #1126 GND nmos W=0.0975U L=2.275U
M1096_ GND n__O0__t_531_6 #fb1130# GND nmos W=0.0975U L=0.13U
M1097_keeper GND Vdd #1129 GND nmos W=0.0975U L=2.275U
M1098_ GND n__O0__f_531_6 #fb1133# GND nmos W=0.0975U L=0.13U
M1099_keeper GND Vdd #1132 GND nmos W=0.0975U L=0.715U
M1100_ GND O1_at_531_6 #fb1136# GND nmos W=0.0975U L=0.13U
M1101_keeper GND Vdd #1135 GND nmos W=0.0975U L=0.715U
M1102_ GND O1_af_531_6 #fb1139# GND nmos W=0.0975U L=0.13U
M1103_keeper GND Vdd #1138 GND nmos W=0.0975U L=2.275U
M1104_keeper GND Vdd #1141 GND nmos W=0.0975U L=2.275U
M1105_ #5 inv__s p Vdd pmos W=0.1625U L=0.065U
M1106_ #45 s p GND nmos W=0.0975U L=0.065U
M1107_keeper #735 #fb734# p Vdd pmos W=0.0975U L=0.065U
M1108_keeper #736 #fb734# p GND nmos W=0.0975U L=0.065U
M1109_ #3 inv__I__t_531_6 #23 Vdd pmos W=0.1625U L=0.065U
M1110_ #69 inv__p w__0i Vdd pmos W=0.1625U L=0.065U
M1111_ #89 p w__0i Vdd pmos W=0.1625U L=0.065U
M1112_ #109 O0_aa w__0i GND nmos W=0.0975U L=0.065U
M1113_ #109 O1_aa w__0i GND nmos W=0.0975U L=0.065U
M1114_keeper #738 #fb737# w__0i Vdd pmos W=0.0975U L=0.065U
M1115_keeper #739 #fb737# w__0i GND nmos W=0.0975U L=0.065U
M1116_ #6 inv__I__f_513_6 #5 Vdd pmos W=0.1625U L=0.065U
M1117_ #7 inv__I__f_514_6 #6 Vdd pmos W=0.1625U L=0.065U
M1118_ #8 inv__I__f_515_6 #7 Vdd pmos W=0.1625U L=0.065U
M1119_ #9 inv__I__f_516_6 #8 Vdd pmos W=0.1625U L=0.065U
M1120_ #10 inv__I__f_517_6 #9 Vdd pmos W=0.1625U L=0.065U
M1121_ #11 inv__I__f_518_6 #10 Vdd pmos W=0.1625U L=0.065U
M1122_ #12 inv__I__f_519_6 #11 Vdd pmos W=0.1625U L=0.065U
M1123_ #13 inv__I__f_520_6 #12 Vdd pmos W=0.1625U L=0.065U
M1124_ #14 inv__I__f_521_6 #13 Vdd pmos W=0.1625U L=0.065U
M1125_ #15 inv__I__f_522_6 #14 Vdd pmos W=0.1625U L=0.065U
M1126_ #16 inv__I__f_523_6 #15 Vdd pmos W=0.1625U L=0.065U
M1127_ #17 inv__I__f_524_6 #16 Vdd pmos W=0.1625U L=0.065U
M1128_ #18 inv__I__f_525_6 #17 Vdd pmos W=0.1625U L=0.065U
M1129_ #19 inv__I__f_526_6 #18 Vdd pmos W=0.1625U L=0.065U
M1130_ #20 inv__I__f_527_6 #19 Vdd pmos W=0.1625U L=0.065U
M1131_ #21 inv__I__f_528_6 #20 Vdd pmos W=0.1625U L=0.065U
M1132_ #22 inv__I__f_529_6 #21 Vdd pmos W=0.1625U L=0.065U
M1133_ #23 inv__I__f_530_6 #22 Vdd pmos W=0.1625U L=0.065U
M1134_ #46 I_af_531_6 #45 GND nmos W=0.0975U L=0.065U
M1135_ #46 I_at_530_6 #45 GND nmos W=0.0975U L=0.065U
M1136_ #46 I_at_529_6 #45 GND nmos W=0.0975U L=0.065U
M1137_ #46 I_at_528_6 #45 GND nmos W=0.0975U L=0.065U
M1138_ #46 I_at_527_6 #45 GND nmos W=0.0975U L=0.065U
M1139_ #46 I_at_526_6 #45 GND nmos W=0.0975U L=0.065U
M1140_ #46 I_at_525_6 #45 GND nmos W=0.0975U L=0.065U
M1141_ #46 I_at_524_6 #45 GND nmos W=0.0975U L=0.065U
M1142_ #46 I_at_523_6 #45 GND nmos W=0.0975U L=0.065U
M1143_ #46 I_at_522_6 #45 GND nmos W=0.0975U L=0.065U
M1144_ #46 I_at_521_6 #45 GND nmos W=0.0975U L=0.065U
M1145_ #46 I_at_520_6 #45 GND nmos W=0.0975U L=0.065U
M1146_ #46 I_at_519_6 #45 GND nmos W=0.0975U L=0.065U
M1147_ #46 I_at_518_6 #45 GND nmos W=0.0975U L=0.065U
M1148_ #46 I_at_517_6 #45 GND nmos W=0.0975U L=0.065U
M1149_ #46 I_at_516_6 #45 GND nmos W=0.0975U L=0.065U
M1150_ #46 I_at_515_6 #45 GND nmos W=0.0975U L=0.065U
M1151_ #46 I_at_514_6 #45 GND nmos W=0.0975U L=0.065U
M1152_ #46 I_at_513_6 #45 GND nmos W=0.0975U L=0.065U
M1153_ #236 O1_aa s Vdd pmos W=0.1625U L=0.065U
M1154_ #238 n__I__a s GND nmos W=0.0975U L=0.065U
M1155_ #237 inv__p s GND nmos W=0.0975U L=0.065U
M1156_keeper #741 #fb740# s Vdd pmos W=0.0975U L=0.065U
M1157_keeper #742 #fb740# s GND nmos W=0.0975U L=0.065U
M1158_ #68 inv__I__t_531_6 #87 Vdd pmos W=0.1625U L=0.065U
M1159_ #68 inv__I__f_531_6 #89 Vdd pmos W=0.1625U L=0.065U
M1160_ #68 inv__I__t_530_6 #89 Vdd pmos W=0.1625U L=0.065U
M1161_ #68 inv__I__t_529_6 #89 Vdd pmos W=0.1625U L=0.065U
M1162_ #68 inv__I__t_528_6 #89 Vdd pmos W=0.1625U L=0.065U
M1163_ #68 inv__I__t_527_6 #89 Vdd pmos W=0.1625U L=0.065U
M1164_ #68 inv__I__t_526_6 #89 Vdd pmos W=0.1625U L=0.065U
M1165_ #68 inv__I__t_525_6 #89 Vdd pmos W=0.1625U L=0.065U
M1166_ #68 inv__I__t_524_6 #89 Vdd pmos W=0.1625U L=0.065U
M1167_ #68 inv__I__t_523_6 #89 Vdd pmos W=0.1625U L=0.065U
M1168_ #68 inv__I__t_522_6 #89 Vdd pmos W=0.1625U L=0.065U
M1169_ #68 inv__I__t_521_6 #89 Vdd pmos W=0.1625U L=0.065U
M1170_ #68 inv__I__t_520_6 #89 Vdd pmos W=0.1625U L=0.065U
M1171_ #68 inv__I__t_519_6 #89 Vdd pmos W=0.1625U L=0.065U
M1172_ #68 inv__I__t_518_6 #89 Vdd pmos W=0.1625U L=0.065U
M1173_ #68 inv__I__t_517_6 #89 Vdd pmos W=0.1625U L=0.065U
M1174_ #68 inv__I__t_516_6 #89 Vdd pmos W=0.1625U L=0.065U
M1175_ #68 inv__I__t_515_6 #89 Vdd pmos W=0.1625U L=0.065U
M1176_ #68 inv__I__t_514_6 #89 Vdd pmos W=0.1625U L=0.065U
M1177_ #68 inv__I__t_513_6 #89 Vdd pmos W=0.1625U L=0.065U
M1178_ #70 inv__I__f_513_6 #69 Vdd pmos W=0.1625U L=0.065U
M1179_ #71 inv__I__f_514_6 #70 Vdd pmos W=0.1625U L=0.065U
M1180_ #72 inv__I__f_515_6 #71 Vdd pmos W=0.1625U L=0.065U
M1181_ #73 inv__I__f_516_6 #72 Vdd pmos W=0.1625U L=0.065U
M1182_ #74 inv__I__f_517_6 #73 Vdd pmos W=0.1625U L=0.065U
M1183_ #75 inv__I__f_518_6 #74 Vdd pmos W=0.1625U L=0.065U
M1184_ #76 inv__I__f_519_6 #75 Vdd pmos W=0.1625U L=0.065U
M1185_ #77 inv__I__f_520_6 #76 Vdd pmos W=0.1625U L=0.065U
M1186_ #78 inv__I__f_521_6 #77 Vdd pmos W=0.1625U L=0.065U
M1187_ #79 inv__I__f_522_6 #78 Vdd pmos W=0.1625U L=0.065U
M1188_ #80 inv__I__f_523_6 #79 Vdd pmos W=0.1625U L=0.065U
M1189_ #81 inv__I__f_524_6 #80 Vdd pmos W=0.1625U L=0.065U
M1190_ #82 inv__I__f_525_6 #81 Vdd pmos W=0.1625U L=0.065U
M1191_ #83 inv__I__f_526_6 #82 Vdd pmos W=0.1625U L=0.065U
M1192_ #84 inv__I__f_527_6 #83 Vdd pmos W=0.1625U L=0.065U
M1193_ #85 inv__I__f_528_6 #84 Vdd pmos W=0.1625U L=0.065U
M1194_ #86 inv__I__f_529_6 #85 Vdd pmos W=0.1625U L=0.065U
M1195_ #87 inv__I__f_530_6 #86 Vdd pmos W=0.1625U L=0.065U
M1196_ #115 I_af_50_6 f Vdd pmos W=0.1625U L=0.065U
M1197_keeper #744 #fb743# f Vdd pmos W=0.0975U L=0.065U
M1198_keeper #745 #fb743# f GND nmos W=0.0975U L=0.065U
M1199_ #114 I_at_531_6 #177 Vdd pmos W=0.1625U L=0.065U
M1200_ #116 I_at_50_6 #115 Vdd pmos W=0.1625U L=0.065U
M1201_ #117 I_af_51_6 #116 Vdd pmos W=0.1625U L=0.065U
M1202_ #118 I_at_51_6 #117 Vdd pmos W=0.1625U L=0.065U
M1203_ #119 I_af_52_6 #118 Vdd pmos W=0.1625U L=0.065U
M1204_ #120 I_at_52_6 #119 Vdd pmos W=0.1625U L=0.065U
M1205_ #121 I_af_53_6 #120 Vdd pmos W=0.1625U L=0.065U
M1206_ #122 I_at_53_6 #121 Vdd pmos W=0.1625U L=0.065U
M1207_ #123 I_af_54_6 #122 Vdd pmos W=0.1625U L=0.065U
M1208_ #124 I_at_54_6 #123 Vdd pmos W=0.1625U L=0.065U
M1209_ #125 I_af_55_6 #124 Vdd pmos W=0.1625U L=0.065U
M1210_ #126 I_at_55_6 #125 Vdd pmos W=0.1625U L=0.065U
M1211_ #127 I_af_56_6 #126 Vdd pmos W=0.1625U L=0.065U
M1212_ #128 I_at_56_6 #127 Vdd pmos W=0.1625U L=0.065U
M1213_ #129 I_af_57_6 #128 Vdd pmos W=0.1625U L=0.065U
M1214_ #130 I_at_57_6 #129 Vdd pmos W=0.1625U L=0.065U
M1215_ #131 I_af_58_6 #130 Vdd pmos W=0.1625U L=0.065U
M1216_ #132 I_at_58_6 #131 Vdd pmos W=0.1625U L=0.065U
M1217_ #133 I_af_59_6 #132 Vdd pmos W=0.1625U L=0.065U
M1218_ #134 I_at_59_6 #133 Vdd pmos W=0.1625U L=0.065U
M1219_ #135 I_af_510_6 #134 Vdd pmos W=0.1625U L=0.065U
M1220_ #136 I_at_510_6 #135 Vdd pmos W=0.1625U L=0.065U
M1221_ #137 I_af_511_6 #136 Vdd pmos W=0.1625U L=0.065U
M1222_ #138 I_at_511_6 #137 Vdd pmos W=0.1625U L=0.065U
M1223_ #139 I_af_512_6 #138 Vdd pmos W=0.1625U L=0.065U
M1224_ #140 I_at_512_6 #139 Vdd pmos W=0.1625U L=0.065U
M1225_ #141 I_af_513_6 #140 Vdd pmos W=0.1625U L=0.065U
M1226_ #142 I_at_513_6 #141 Vdd pmos W=0.1625U L=0.065U
M1227_ #143 I_af_514_6 #142 Vdd pmos W=0.1625U L=0.065U
M1228_ #144 I_at_514_6 #143 Vdd pmos W=0.1625U L=0.065U
M1229_ #145 I_af_515_6 #144 Vdd pmos W=0.1625U L=0.065U
M1230_ #146 I_at_515_6 #145 Vdd pmos W=0.1625U L=0.065U
M1231_ #147 I_af_516_6 #146 Vdd pmos W=0.1625U L=0.065U
M1232_ #148 I_at_516_6 #147 Vdd pmos W=0.1625U L=0.065U
M1233_ #149 I_af_517_6 #148 Vdd pmos W=0.1625U L=0.065U
M1234_ #150 I_at_517_6 #149 Vdd pmos W=0.1625U L=0.065U
M1235_ #151 I_af_518_6 #150 Vdd pmos W=0.1625U L=0.065U
M1236_ #152 I_at_518_6 #151 Vdd pmos W=0.1625U L=0.065U
M1237_ #153 I_af_519_6 #152 Vdd pmos W=0.1625U L=0.065U
M1238_ #154 I_at_519_6 #153 Vdd pmos W=0.1625U L=0.065U
M1239_ #155 I_af_520_6 #154 Vdd pmos W=0.1625U L=0.065U
M1240_ #156 I_at_520_6 #155 Vdd pmos W=0.1625U L=0.065U
M1241_ #157 I_af_521_6 #156 Vdd pmos W=0.1625U L=0.065U
M1242_ #158 I_at_521_6 #157 Vdd pmos W=0.1625U L=0.065U
M1243_ #159 I_af_522_6 #158 Vdd pmos W=0.1625U L=0.065U
M1244_ #160 I_at_522_6 #159 Vdd pmos W=0.1625U L=0.065U
M1245_ #161 I_af_523_6 #160 Vdd pmos W=0.1625U L=0.065U
M1246_ #162 I_at_523_6 #161 Vdd pmos W=0.1625U L=0.065U
M1247_ #163 I_af_524_6 #162 Vdd pmos W=0.1625U L=0.065U
M1248_ #164 I_at_524_6 #163 Vdd pmos W=0.1625U L=0.065U
M1249_ #165 I_af_525_6 #164 Vdd pmos W=0.1625U L=0.065U
M1250_ #166 I_at_525_6 #165 Vdd pmos W=0.1625U L=0.065U
M1251_ #167 I_af_526_6 #166 Vdd pmos W=0.1625U L=0.065U
M1252_ #168 I_at_526_6 #167 Vdd pmos W=0.1625U L=0.065U
M1253_ #169 I_af_527_6 #168 Vdd pmos W=0.1625U L=0.065U
M1254_ #170 I_at_527_6 #169 Vdd pmos W=0.1625U L=0.065U
M1255_ #171 I_af_528_6 #170 Vdd pmos W=0.1625U L=0.065U
M1256_ #172 I_at_528_6 #171 Vdd pmos W=0.1625U L=0.065U
M1257_ #173 I_af_529_6 #172 Vdd pmos W=0.1625U L=0.065U
M1258_ #174 I_at_529_6 #173 Vdd pmos W=0.1625U L=0.065U
M1259_ #175 I_af_530_6 #174 Vdd pmos W=0.1625U L=0.065U
M1260_ #176 I_at_530_6 #175 Vdd pmos W=0.1625U L=0.065U
M1261_ #177 I_af_531_6 #176 Vdd pmos W=0.1625U L=0.065U
M1262_ #224 I_af_50_6 n__w__0 GND nmos W=0.0975U L=0.065U
M1263_ #228 O1_aa n__w__0 Vdd pmos W=0.1625U L=0.065U
M1264_keeper #747 #fb746# n__w__0 Vdd pmos W=0.0975U L=0.065U
M1265_keeper #748 #fb746# n__w__0 GND nmos W=0.0975U L=0.065U
M1266_ #226 n__I__a #225 Vdd pmos W=0.1625U L=0.065U
M1267_ #225 O0_aa #228 Vdd pmos W=0.1625U L=0.065U
M1268_ #250 v n__I__a GND nmos W=0.0975U L=0.065U
M1269_ #252 inv__f n__I__a GND nmos W=0.0975U L=0.065U
M1270_ #255 v n__I__a Vdd pmos W=0.1625U L=0.065U
M1271_ #256 inv__f n__I__a Vdd pmos W=0.1625U L=0.065U
M1272_keeper #750 #fb749# n__I__a Vdd pmos W=0.0975U L=0.065U
M1273_keeper #751 #fb749# n__I__a GND nmos W=0.0975U L=0.065U
M1274_ #230 I_at_50_6 n__w__1 GND nmos W=0.0975U L=0.065U
M1275_ #233 O1_aa n__w__1 Vdd pmos W=0.1625U L=0.065U
M1276_keeper #753 #fb752# n__w__1 Vdd pmos W=0.0975U L=0.065U
M1277_keeper #754 #fb752# n__w__1 GND nmos W=0.0975U L=0.065U
M1278_ #232 n__I__a #231 Vdd pmos W=0.1625U L=0.065U
M1279_ #231 O0_aa #233 Vdd pmos W=0.1625U L=0.065U
M1280_ #235 n__I__a #234 Vdd pmos W=0.1625U L=0.065U
M1281_ #234 O0_aa #236 Vdd pmos W=0.1625U L=0.065U
M1282_ #237 p #239 GND nmos W=0.0975U L=0.065U
M1283_ #239 f #238 GND nmos W=0.0975U L=0.065U
M1284_ #241 inv__f n__v GND nmos W=0.0975U L=0.065U
M1285_ #249 w__0 n__v Vdd pmos W=0.1625U L=0.065U
M1286_keeper #756 #fb755# n__v Vdd pmos W=0.0975U L=0.065U
M1287_keeper #757 #fb755# n__v GND nmos W=0.0975U L=0.065U
M1288_ #242 inv__w__0i #241 GND nmos W=0.0975U L=0.065U
M1289_ #243 w__1 #242 GND nmos W=0.0975U L=0.065U
M1290_ #243 w__0 #242 GND nmos W=0.0975U L=0.065U
M1291_ #248 O1_aa #247 Vdd pmos W=0.1625U L=0.065U
M1292_ #247 w__1 #249 Vdd pmos W=0.1625U L=0.065U
M1293_ #253 p #252 GND nmos W=0.0975U L=0.065U
M1294_ #254 w__0i #253 GND nmos W=0.0975U L=0.065U
M1295_ #258 I_at_50_6 n__O0__t_50_6 GND nmos W=0.0975U L=0.065U
M1296_keeper #759 #fb758# n__O0__t_50_6 Vdd pmos W=0.0975U L=0.065U
M1297_keeper #760 #fb758# n__O0__t_50_6 GND nmos W=0.0975U L=0.065U
M1298_ #259 inv__s #258 GND nmos W=0.0975U L=0.065U
M1299_ #261 I_af_50_6 n__O0__f_50_6 GND nmos W=0.0975U L=0.065U
M1300_keeper #762 #fb761# n__O0__f_50_6 Vdd pmos W=0.0975U L=0.065U
M1301_keeper #763 #fb761# n__O0__f_50_6 GND nmos W=0.0975U L=0.065U
M1302_ #262 inv__s #261 GND nmos W=0.0975U L=0.065U
M1303_ #264 inv__I__t_50_6 O1_at_50_6 Vdd pmos W=0.1625U L=0.065U
M1304_keeper #765 #fb764# O1_at_50_6 Vdd pmos W=0.0975U L=0.065U
M1305_keeper #766 #fb764# O1_at_50_6 GND nmos W=0.0975U L=0.065U
M1306_ #265 s #264 Vdd pmos W=0.1625U L=0.065U
M1307_ #268 inv__I__f_50_6 O1_af_50_6 Vdd pmos W=0.1625U L=0.065U
M1308_keeper #768 #fb767# O1_af_50_6 Vdd pmos W=0.0975U L=0.065U
M1309_keeper #769 #fb767# O1_af_50_6 GND nmos W=0.0975U L=0.065U
M1310_ #269 s #268 Vdd pmos W=0.1625U L=0.065U
M1311_ #272 I_at_51_6 n__O0__t_51_6 GND nmos W=0.0975U L=0.065U
M1312_keeper #771 #fb770# n__O0__t_51_6 Vdd pmos W=0.0975U L=0.065U
M1313_keeper #772 #fb770# n__O0__t_51_6 GND nmos W=0.0975U L=0.065U
M1314_ #273 inv__s #272 GND nmos W=0.0975U L=0.065U
M1315_ #275 I_af_51_6 n__O0__f_51_6 GND nmos W=0.0975U L=0.065U
M1316_keeper #774 #fb773# n__O0__f_51_6 Vdd pmos W=0.0975U L=0.065U
M1317_keeper #775 #fb773# n__O0__f_51_6 GND nmos W=0.0975U L=0.065U
M1318_ #276 inv__s #275 GND nmos W=0.0975U L=0.065U
M1319_ #278 inv__I__t_51_6 O1_at_51_6 Vdd pmos W=0.1625U L=0.065U
M1320_keeper #777 #fb776# O1_at_51_6 Vdd pmos W=0.0975U L=0.065U
M1321_keeper #778 #fb776# O1_at_51_6 GND nmos W=0.0975U L=0.065U
M1322_ #279 s #278 Vdd pmos W=0.1625U L=0.065U
M1323_ #282 inv__I__f_51_6 O1_af_51_6 Vdd pmos W=0.1625U L=0.065U
M1324_keeper #780 #fb779# O1_af_51_6 Vdd pmos W=0.0975U L=0.065U
M1325_keeper #781 #fb779# O1_af_51_6 GND nmos W=0.0975U L=0.065U
M1326_ #283 s #282 Vdd pmos W=0.1625U L=0.065U
M1327_ #286 I_at_52_6 n__O0__t_52_6 GND nmos W=0.0975U L=0.065U
M1328_keeper #783 #fb782# n__O0__t_52_6 Vdd pmos W=0.0975U L=0.065U
M1329_keeper #784 #fb782# n__O0__t_52_6 GND nmos W=0.0975U L=0.065U
M1330_ #287 inv__s #286 GND nmos W=0.0975U L=0.065U
M1331_ #289 I_af_52_6 n__O0__f_52_6 GND nmos W=0.0975U L=0.065U
M1332_keeper #786 #fb785# n__O0__f_52_6 Vdd pmos W=0.0975U L=0.065U
M1333_keeper #787 #fb785# n__O0__f_52_6 GND nmos W=0.0975U L=0.065U
M1334_ #290 inv__s #289 GND nmos W=0.0975U L=0.065U
M1335_ #292 inv__I__t_52_6 O1_at_52_6 Vdd pmos W=0.1625U L=0.065U
M1336_keeper #789 #fb788# O1_at_52_6 Vdd pmos W=0.0975U L=0.065U
M1337_keeper #790 #fb788# O1_at_52_6 GND nmos W=0.0975U L=0.065U
M1338_ #293 s #292 Vdd pmos W=0.1625U L=0.065U
M1339_ #296 inv__I__f_52_6 O1_af_52_6 Vdd pmos W=0.1625U L=0.065U
M1340_keeper #792 #fb791# O1_af_52_6 Vdd pmos W=0.0975U L=0.065U
M1341_keeper #793 #fb791# O1_af_52_6 GND nmos W=0.0975U L=0.065U
M1342_ #297 s #296 Vdd pmos W=0.1625U L=0.065U
M1343_ #300 I_at_53_6 n__O0__t_53_6 GND nmos W=0.0975U L=0.065U
M1344_keeper #795 #fb794# n__O0__t_53_6 Vdd pmos W=0.0975U L=0.065U
M1345_keeper #796 #fb794# n__O0__t_53_6 GND nmos W=0.0975U L=0.065U
M1346_ #301 inv__s #300 GND nmos W=0.0975U L=0.065U
M1347_ #303 I_af_53_6 n__O0__f_53_6 GND nmos W=0.0975U L=0.065U
M1348_keeper #798 #fb797# n__O0__f_53_6 Vdd pmos W=0.0975U L=0.065U
M1349_keeper #799 #fb797# n__O0__f_53_6 GND nmos W=0.0975U L=0.065U
M1350_ #304 inv__s #303 GND nmos W=0.0975U L=0.065U
M1351_ #306 inv__I__t_53_6 O1_at_53_6 Vdd pmos W=0.1625U L=0.065U
M1352_keeper #801 #fb800# O1_at_53_6 Vdd pmos W=0.0975U L=0.065U
M1353_keeper #802 #fb800# O1_at_53_6 GND nmos W=0.0975U L=0.065U
M1354_ #307 s #306 Vdd pmos W=0.1625U L=0.065U
M1355_ #310 inv__I__f_53_6 O1_af_53_6 Vdd pmos W=0.1625U L=0.065U
M1356_keeper #804 #fb803# O1_af_53_6 Vdd pmos W=0.0975U L=0.065U
M1357_keeper #805 #fb803# O1_af_53_6 GND nmos W=0.0975U L=0.065U
M1358_ #311 s #310 Vdd pmos W=0.1625U L=0.065U
M1359_ #314 I_at_54_6 n__O0__t_54_6 GND nmos W=0.0975U L=0.065U
M1360_keeper #807 #fb806# n__O0__t_54_6 Vdd pmos W=0.0975U L=0.065U
M1361_keeper #808 #fb806# n__O0__t_54_6 GND nmos W=0.0975U L=0.065U
M1362_ #315 inv__s #314 GND nmos W=0.0975U L=0.065U
M1363_ #317 I_af_54_6 n__O0__f_54_6 GND nmos W=0.0975U L=0.065U
M1364_keeper #810 #fb809# n__O0__f_54_6 Vdd pmos W=0.0975U L=0.065U
M1365_keeper #811 #fb809# n__O0__f_54_6 GND nmos W=0.0975U L=0.065U
M1366_ #318 inv__s #317 GND nmos W=0.0975U L=0.065U
M1367_ #320 inv__I__t_54_6 O1_at_54_6 Vdd pmos W=0.1625U L=0.065U
M1368_keeper #813 #fb812# O1_at_54_6 Vdd pmos W=0.0975U L=0.065U
M1369_keeper #814 #fb812# O1_at_54_6 GND nmos W=0.0975U L=0.065U
M1370_ #321 s #320 Vdd pmos W=0.1625U L=0.065U
M1371_ #324 inv__I__f_54_6 O1_af_54_6 Vdd pmos W=0.1625U L=0.065U
M1372_keeper #816 #fb815# O1_af_54_6 Vdd pmos W=0.0975U L=0.065U
M1373_keeper #817 #fb815# O1_af_54_6 GND nmos W=0.0975U L=0.065U
M1374_ #325 s #324 Vdd pmos W=0.1625U L=0.065U
M1375_ #328 I_at_55_6 n__O0__t_55_6 GND nmos W=0.0975U L=0.065U
M1376_keeper #819 #fb818# n__O0__t_55_6 Vdd pmos W=0.0975U L=0.065U
M1377_keeper #820 #fb818# n__O0__t_55_6 GND nmos W=0.0975U L=0.065U
M1378_ #329 inv__s #328 GND nmos W=0.0975U L=0.065U
M1379_ #331 I_af_55_6 n__O0__f_55_6 GND nmos W=0.0975U L=0.065U
M1380_keeper #822 #fb821# n__O0__f_55_6 Vdd pmos W=0.0975U L=0.065U
M1381_keeper #823 #fb821# n__O0__f_55_6 GND nmos W=0.0975U L=0.065U
M1382_ #332 inv__s #331 GND nmos W=0.0975U L=0.065U
M1383_ #334 inv__I__t_55_6 O1_at_55_6 Vdd pmos W=0.1625U L=0.065U
M1384_keeper #825 #fb824# O1_at_55_6 Vdd pmos W=0.0975U L=0.065U
M1385_keeper #826 #fb824# O1_at_55_6 GND nmos W=0.0975U L=0.065U
M1386_ #335 s #334 Vdd pmos W=0.1625U L=0.065U
M1387_ #338 inv__I__f_55_6 O1_af_55_6 Vdd pmos W=0.1625U L=0.065U
M1388_keeper #828 #fb827# O1_af_55_6 Vdd pmos W=0.0975U L=0.065U
M1389_keeper #829 #fb827# O1_af_55_6 GND nmos W=0.0975U L=0.065U
M1390_ #339 s #338 Vdd pmos W=0.1625U L=0.065U
M1391_ #342 I_at_56_6 n__O0__t_56_6 GND nmos W=0.0975U L=0.065U
M1392_keeper #831 #fb830# n__O0__t_56_6 Vdd pmos W=0.0975U L=0.065U
M1393_keeper #832 #fb830# n__O0__t_56_6 GND nmos W=0.0975U L=0.065U
M1394_ #343 inv__s #342 GND nmos W=0.0975U L=0.065U
M1395_ #345 I_af_56_6 n__O0__f_56_6 GND nmos W=0.0975U L=0.065U
M1396_keeper #834 #fb833# n__O0__f_56_6 Vdd pmos W=0.0975U L=0.065U
M1397_keeper #835 #fb833# n__O0__f_56_6 GND nmos W=0.0975U L=0.065U
M1398_ #346 inv__s #345 GND nmos W=0.0975U L=0.065U
M1399_ #348 inv__I__t_56_6 O1_at_56_6 Vdd pmos W=0.1625U L=0.065U
M1400_keeper #837 #fb836# O1_at_56_6 Vdd pmos W=0.0975U L=0.065U
M1401_keeper #838 #fb836# O1_at_56_6 GND nmos W=0.0975U L=0.065U
M1402_ #349 s #348 Vdd pmos W=0.1625U L=0.065U
M1403_ #352 inv__I__f_56_6 O1_af_56_6 Vdd pmos W=0.1625U L=0.065U
M1404_keeper #840 #fb839# O1_af_56_6 Vdd pmos W=0.0975U L=0.065U
M1405_keeper #841 #fb839# O1_af_56_6 GND nmos W=0.0975U L=0.065U
M1406_ #353 s #352 Vdd pmos W=0.1625U L=0.065U
M1407_ #356 I_at_57_6 n__O0__t_57_6 GND nmos W=0.0975U L=0.065U
M1408_keeper #843 #fb842# n__O0__t_57_6 Vdd pmos W=0.0975U L=0.065U
M1409_keeper #844 #fb842# n__O0__t_57_6 GND nmos W=0.0975U L=0.065U
M1410_ #357 inv__s #356 GND nmos W=0.0975U L=0.065U
M1411_ #359 I_af_57_6 n__O0__f_57_6 GND nmos W=0.0975U L=0.065U
M1412_keeper #846 #fb845# n__O0__f_57_6 Vdd pmos W=0.0975U L=0.065U
M1413_keeper #847 #fb845# n__O0__f_57_6 GND nmos W=0.0975U L=0.065U
M1414_ #360 inv__s #359 GND nmos W=0.0975U L=0.065U
M1415_ #362 inv__I__t_57_6 O1_at_57_6 Vdd pmos W=0.1625U L=0.065U
M1416_keeper #849 #fb848# O1_at_57_6 Vdd pmos W=0.0975U L=0.065U
M1417_keeper #850 #fb848# O1_at_57_6 GND nmos W=0.0975U L=0.065U
M1418_ #363 s #362 Vdd pmos W=0.1625U L=0.065U
M1419_ #366 inv__I__f_57_6 O1_af_57_6 Vdd pmos W=0.1625U L=0.065U
M1420_keeper #852 #fb851# O1_af_57_6 Vdd pmos W=0.0975U L=0.065U
M1421_keeper #853 #fb851# O1_af_57_6 GND nmos W=0.0975U L=0.065U
M1422_ #367 s #366 Vdd pmos W=0.1625U L=0.065U
M1423_ #370 I_at_58_6 n__O0__t_58_6 GND nmos W=0.0975U L=0.065U
M1424_keeper #855 #fb854# n__O0__t_58_6 Vdd pmos W=0.0975U L=0.065U
M1425_keeper #856 #fb854# n__O0__t_58_6 GND nmos W=0.0975U L=0.065U
M1426_ #371 inv__s #370 GND nmos W=0.0975U L=0.065U
M1427_ #373 I_af_58_6 n__O0__f_58_6 GND nmos W=0.0975U L=0.065U
M1428_keeper #858 #fb857# n__O0__f_58_6 Vdd pmos W=0.0975U L=0.065U
M1429_keeper #859 #fb857# n__O0__f_58_6 GND nmos W=0.0975U L=0.065U
M1430_ #374 inv__s #373 GND nmos W=0.0975U L=0.065U
M1431_ #376 inv__I__t_58_6 O1_at_58_6 Vdd pmos W=0.1625U L=0.065U
M1432_keeper #861 #fb860# O1_at_58_6 Vdd pmos W=0.0975U L=0.065U
M1433_keeper #862 #fb860# O1_at_58_6 GND nmos W=0.0975U L=0.065U
M1434_ #377 s #376 Vdd pmos W=0.1625U L=0.065U
M1435_ #380 inv__I__f_58_6 O1_af_58_6 Vdd pmos W=0.1625U L=0.065U
M1436_keeper #864 #fb863# O1_af_58_6 Vdd pmos W=0.0975U L=0.065U
M1437_keeper #865 #fb863# O1_af_58_6 GND nmos W=0.0975U L=0.065U
M1438_ #381 s #380 Vdd pmos W=0.1625U L=0.065U
M1439_ #384 I_at_59_6 n__O0__t_59_6 GND nmos W=0.0975U L=0.065U
M1440_keeper #867 #fb866# n__O0__t_59_6 Vdd pmos W=0.0975U L=0.065U
M1441_keeper #868 #fb866# n__O0__t_59_6 GND nmos W=0.0975U L=0.065U
M1442_ #385 inv__s #384 GND nmos W=0.0975U L=0.065U
M1443_ #387 I_af_59_6 n__O0__f_59_6 GND nmos W=0.0975U L=0.065U
M1444_keeper #870 #fb869# n__O0__f_59_6 Vdd pmos W=0.0975U L=0.065U
M1445_keeper #871 #fb869# n__O0__f_59_6 GND nmos W=0.0975U L=0.065U
M1446_ #388 inv__s #387 GND nmos W=0.0975U L=0.065U
M1447_ #390 inv__I__t_59_6 O1_at_59_6 Vdd pmos W=0.1625U L=0.065U
M1448_keeper #873 #fb872# O1_at_59_6 Vdd pmos W=0.0975U L=0.065U
M1449_keeper #874 #fb872# O1_at_59_6 GND nmos W=0.0975U L=0.065U
M1450_ #391 s #390 Vdd pmos W=0.1625U L=0.065U
M1451_ #394 inv__I__f_59_6 O1_af_59_6 Vdd pmos W=0.1625U L=0.065U
M1452_keeper #876 #fb875# O1_af_59_6 Vdd pmos W=0.0975U L=0.065U
M1453_keeper #877 #fb875# O1_af_59_6 GND nmos W=0.0975U L=0.065U
M1454_ #395 s #394 Vdd pmos W=0.1625U L=0.065U
M1455_ #398 I_at_510_6 n__O0__t_510_6 GND nmos W=0.0975U L=0.065U
M1456_keeper #879 #fb878# n__O0__t_510_6 Vdd pmos W=0.0975U L=0.065U
M1457_keeper #880 #fb878# n__O0__t_510_6 GND nmos W=0.0975U L=0.065U
M1458_ #399 inv__s #398 GND nmos W=0.0975U L=0.065U
M1459_ #401 I_af_510_6 n__O0__f_510_6 GND nmos W=0.0975U L=0.065U
M1460_keeper #882 #fb881# n__O0__f_510_6 Vdd pmos W=0.0975U L=0.065U
M1461_keeper #883 #fb881# n__O0__f_510_6 GND nmos W=0.0975U L=0.065U
M1462_ #402 inv__s #401 GND nmos W=0.0975U L=0.065U
M1463_ #404 inv__I__t_510_6 O1_at_510_6 Vdd pmos W=0.1625U L=0.065U
M1464_keeper #885 #fb884# O1_at_510_6 Vdd pmos W=0.0975U L=0.065U
M1465_keeper #886 #fb884# O1_at_510_6 GND nmos W=0.0975U L=0.065U
M1466_ #405 s #404 Vdd pmos W=0.1625U L=0.065U
M1467_ #408 inv__I__f_510_6 O1_af_510_6 Vdd pmos W=0.1625U L=0.065U
M1468_keeper #888 #fb887# O1_af_510_6 Vdd pmos W=0.0975U L=0.065U
M1469_keeper #889 #fb887# O1_af_510_6 GND nmos W=0.0975U L=0.065U
M1470_ #409 s #408 Vdd pmos W=0.1625U L=0.065U
M1471_ #412 I_at_511_6 n__O0__t_511_6 GND nmos W=0.0975U L=0.065U
M1472_keeper #891 #fb890# n__O0__t_511_6 Vdd pmos W=0.0975U L=0.065U
M1473_keeper #892 #fb890# n__O0__t_511_6 GND nmos W=0.0975U L=0.065U
M1474_ #413 inv__s #412 GND nmos W=0.0975U L=0.065U
M1475_ #415 I_af_511_6 n__O0__f_511_6 GND nmos W=0.0975U L=0.065U
M1476_keeper #894 #fb893# n__O0__f_511_6 Vdd pmos W=0.0975U L=0.065U
M1477_keeper #895 #fb893# n__O0__f_511_6 GND nmos W=0.0975U L=0.065U
M1478_ #416 inv__s #415 GND nmos W=0.0975U L=0.065U
M1479_ #418 inv__I__t_511_6 O1_at_511_6 Vdd pmos W=0.1625U L=0.065U
M1480_keeper #897 #fb896# O1_at_511_6 Vdd pmos W=0.0975U L=0.065U
M1481_keeper #898 #fb896# O1_at_511_6 GND nmos W=0.0975U L=0.065U
M1482_ #419 s #418 Vdd pmos W=0.1625U L=0.065U
M1483_ #422 inv__I__f_511_6 O1_af_511_6 Vdd pmos W=0.1625U L=0.065U
M1484_keeper #900 #fb899# O1_af_511_6 Vdd pmos W=0.0975U L=0.065U
M1485_keeper #901 #fb899# O1_af_511_6 GND nmos W=0.0975U L=0.065U
M1486_ #423 s #422 Vdd pmos W=0.1625U L=0.065U
M1487_ #426 I_at_512_6 n__O0__t_512_6 GND nmos W=0.0975U L=0.065U
M1488_keeper #903 #fb902# n__O0__t_512_6 Vdd pmos W=0.0975U L=0.065U
M1489_keeper #904 #fb902# n__O0__t_512_6 GND nmos W=0.0975U L=0.065U
M1490_ #427 inv__s #426 GND nmos W=0.0975U L=0.065U
M1491_ #429 I_af_512_6 n__O0__f_512_6 GND nmos W=0.0975U L=0.065U
M1492_keeper #906 #fb905# n__O0__f_512_6 Vdd pmos W=0.0975U L=0.065U
M1493_keeper #907 #fb905# n__O0__f_512_6 GND nmos W=0.0975U L=0.065U
M1494_ #430 inv__s #429 GND nmos W=0.0975U L=0.065U
M1495_ #432 inv__I__t_512_6 O1_at_512_6 Vdd pmos W=0.1625U L=0.065U
M1496_keeper #909 #fb908# O1_at_512_6 Vdd pmos W=0.0975U L=0.065U
M1497_keeper #910 #fb908# O1_at_512_6 GND nmos W=0.0975U L=0.065U
M1498_ #433 s #432 Vdd pmos W=0.1625U L=0.065U
M1499_ #436 inv__I__f_512_6 O1_af_512_6 Vdd pmos W=0.1625U L=0.065U
M1500_keeper #912 #fb911# O1_af_512_6 Vdd pmos W=0.0975U L=0.065U
M1501_keeper #913 #fb911# O1_af_512_6 GND nmos W=0.0975U L=0.065U
M1502_ #437 s #436 Vdd pmos W=0.1625U L=0.065U
M1503_ #440 I_at_513_6 n__O0__t_513_6 GND nmos W=0.0975U L=0.065U
M1504_keeper #915 #fb914# n__O0__t_513_6 Vdd pmos W=0.0975U L=0.065U
M1505_keeper #916 #fb914# n__O0__t_513_6 GND nmos W=0.0975U L=0.065U
M1506_ #441 inv__s #440 GND nmos W=0.0975U L=0.065U
M1507_ #443 I_af_513_6 n__O0__f_513_6 GND nmos W=0.0975U L=0.065U
M1508_keeper #918 #fb917# n__O0__f_513_6 Vdd pmos W=0.0975U L=0.065U
M1509_keeper #919 #fb917# n__O0__f_513_6 GND nmos W=0.0975U L=0.065U
M1510_ #444 inv__s #443 GND nmos W=0.0975U L=0.065U
M1511_ #446 inv__I__t_513_6 O1_at_513_6 Vdd pmos W=0.1625U L=0.065U
M1512_keeper #921 #fb920# O1_at_513_6 Vdd pmos W=0.0975U L=0.065U
M1513_keeper #922 #fb920# O1_at_513_6 GND nmos W=0.0975U L=0.065U
M1514_ #447 s #446 Vdd pmos W=0.1625U L=0.065U
M1515_ #449 inv__I__f_513_6 O1_af_513_6 Vdd pmos W=0.1625U L=0.065U
M1516_keeper #924 #fb923# O1_af_513_6 Vdd pmos W=0.0975U L=0.065U
M1517_keeper #925 #fb923# O1_af_513_6 GND nmos W=0.0975U L=0.065U
M1518_ #450 s #449 Vdd pmos W=0.1625U L=0.065U
M1519_ #452 I_at_514_6 n__O0__t_514_6 GND nmos W=0.0975U L=0.065U
M1520_keeper #927 #fb926# n__O0__t_514_6 Vdd pmos W=0.0975U L=0.065U
M1521_keeper #928 #fb926# n__O0__t_514_6 GND nmos W=0.0975U L=0.065U
M1522_ #453 inv__s #452 GND nmos W=0.0975U L=0.065U
M1523_ #455 I_af_514_6 n__O0__f_514_6 GND nmos W=0.0975U L=0.065U
M1524_keeper #930 #fb929# n__O0__f_514_6 Vdd pmos W=0.0975U L=0.065U
M1525_keeper #931 #fb929# n__O0__f_514_6 GND nmos W=0.0975U L=0.065U
M1526_ #456 inv__s #455 GND nmos W=0.0975U L=0.065U
M1527_ #458 inv__I__t_514_6 O1_at_514_6 Vdd pmos W=0.1625U L=0.065U
M1528_keeper #933 #fb932# O1_at_514_6 Vdd pmos W=0.0975U L=0.065U
M1529_keeper #934 #fb932# O1_at_514_6 GND nmos W=0.0975U L=0.065U
M1530_ #459 s #458 Vdd pmos W=0.1625U L=0.065U
M1531_ #461 inv__I__f_514_6 O1_af_514_6 Vdd pmos W=0.1625U L=0.065U
M1532_keeper #936 #fb935# O1_af_514_6 Vdd pmos W=0.0975U L=0.065U
M1533_keeper #937 #fb935# O1_af_514_6 GND nmos W=0.0975U L=0.065U
M1534_ #462 s #461 Vdd pmos W=0.1625U L=0.065U
M1535_ #464 I_at_515_6 n__O0__t_515_6 GND nmos W=0.0975U L=0.065U
M1536_keeper #939 #fb938# n__O0__t_515_6 Vdd pmos W=0.0975U L=0.065U
M1537_keeper #940 #fb938# n__O0__t_515_6 GND nmos W=0.0975U L=0.065U
M1538_ #465 inv__s #464 GND nmos W=0.0975U L=0.065U
M1539_ #467 I_af_515_6 n__O0__f_515_6 GND nmos W=0.0975U L=0.065U
M1540_keeper #942 #fb941# n__O0__f_515_6 Vdd pmos W=0.0975U L=0.065U
M1541_keeper #943 #fb941# n__O0__f_515_6 GND nmos W=0.0975U L=0.065U
M1542_ #468 inv__s #467 GND nmos W=0.0975U L=0.065U
M1543_ #470 inv__I__t_515_6 O1_at_515_6 Vdd pmos W=0.1625U L=0.065U
M1544_keeper #945 #fb944# O1_at_515_6 Vdd pmos W=0.0975U L=0.065U
M1545_keeper #946 #fb944# O1_at_515_6 GND nmos W=0.0975U L=0.065U
M1546_ #471 s #470 Vdd pmos W=0.1625U L=0.065U
M1547_ #473 inv__I__f_515_6 O1_af_515_6 Vdd pmos W=0.1625U L=0.065U
M1548_keeper #948 #fb947# O1_af_515_6 Vdd pmos W=0.0975U L=0.065U
M1549_keeper #949 #fb947# O1_af_515_6 GND nmos W=0.0975U L=0.065U
M1550_ #474 s #473 Vdd pmos W=0.1625U L=0.065U
M1551_ #476 I_at_516_6 n__O0__t_516_6 GND nmos W=0.0975U L=0.065U
M1552_keeper #951 #fb950# n__O0__t_516_6 Vdd pmos W=0.0975U L=0.065U
M1553_keeper #952 #fb950# n__O0__t_516_6 GND nmos W=0.0975U L=0.065U
M1554_ #477 inv__s #476 GND nmos W=0.0975U L=0.065U
M1555_ #479 I_af_516_6 n__O0__f_516_6 GND nmos W=0.0975U L=0.065U
M1556_keeper #954 #fb953# n__O0__f_516_6 Vdd pmos W=0.0975U L=0.065U
M1557_keeper #955 #fb953# n__O0__f_516_6 GND nmos W=0.0975U L=0.065U
M1558_ #480 inv__s #479 GND nmos W=0.0975U L=0.065U
M1559_ #482 inv__I__t_516_6 O1_at_516_6 Vdd pmos W=0.1625U L=0.065U
M1560_keeper #957 #fb956# O1_at_516_6 Vdd pmos W=0.0975U L=0.065U
M1561_keeper #958 #fb956# O1_at_516_6 GND nmos W=0.0975U L=0.065U
M1562_ #483 s #482 Vdd pmos W=0.1625U L=0.065U
M1563_ #485 inv__I__f_516_6 O1_af_516_6 Vdd pmos W=0.1625U L=0.065U
M1564_keeper #960 #fb959# O1_af_516_6 Vdd pmos W=0.0975U L=0.065U
M1565_keeper #961 #fb959# O1_af_516_6 GND nmos W=0.0975U L=0.065U
M1566_ #486 s #485 Vdd pmos W=0.1625U L=0.065U
M1567_ #488 I_at_517_6 n__O0__t_517_6 GND nmos W=0.0975U L=0.065U
M1568_keeper #963 #fb962# n__O0__t_517_6 Vdd pmos W=0.0975U L=0.065U
M1569_keeper #964 #fb962# n__O0__t_517_6 GND nmos W=0.0975U L=0.065U
M1570_ #489 inv__s #488 GND nmos W=0.0975U L=0.065U
M1571_ #491 I_af_517_6 n__O0__f_517_6 GND nmos W=0.0975U L=0.065U
M1572_keeper #966 #fb965# n__O0__f_517_6 Vdd pmos W=0.0975U L=0.065U
M1573_keeper #967 #fb965# n__O0__f_517_6 GND nmos W=0.0975U L=0.065U
M1574_ #492 inv__s #491 GND nmos W=0.0975U L=0.065U
M1575_ #494 inv__I__t_517_6 O1_at_517_6 Vdd pmos W=0.1625U L=0.065U
M1576_keeper #969 #fb968# O1_at_517_6 Vdd pmos W=0.0975U L=0.065U
M1577_keeper #970 #fb968# O1_at_517_6 GND nmos W=0.0975U L=0.065U
M1578_ #495 s #494 Vdd pmos W=0.1625U L=0.065U
M1579_ #497 inv__I__f_517_6 O1_af_517_6 Vdd pmos W=0.1625U L=0.065U
M1580_keeper #972 #fb971# O1_af_517_6 Vdd pmos W=0.0975U L=0.065U
M1581_keeper #973 #fb971# O1_af_517_6 GND nmos W=0.0975U L=0.065U
M1582_ #498 s #497 Vdd pmos W=0.1625U L=0.065U
M1583_ #500 I_at_518_6 n__O0__t_518_6 GND nmos W=0.0975U L=0.065U
M1584_keeper #975 #fb974# n__O0__t_518_6 Vdd pmos W=0.0975U L=0.065U
M1585_keeper #976 #fb974# n__O0__t_518_6 GND nmos W=0.0975U L=0.065U
M1586_ #501 inv__s #500 GND nmos W=0.0975U L=0.065U
M1587_ #503 I_af_518_6 n__O0__f_518_6 GND nmos W=0.0975U L=0.065U
M1588_keeper #978 #fb977# n__O0__f_518_6 Vdd pmos W=0.0975U L=0.065U
M1589_keeper #979 #fb977# n__O0__f_518_6 GND nmos W=0.0975U L=0.065U
M1590_ #504 inv__s #503 GND nmos W=0.0975U L=0.065U
M1591_ #506 inv__I__t_518_6 O1_at_518_6 Vdd pmos W=0.1625U L=0.065U
M1592_keeper #981 #fb980# O1_at_518_6 Vdd pmos W=0.0975U L=0.065U
M1593_keeper #982 #fb980# O1_at_518_6 GND nmos W=0.0975U L=0.065U
M1594_ #507 s #506 Vdd pmos W=0.1625U L=0.065U
M1595_ #509 inv__I__f_518_6 O1_af_518_6 Vdd pmos W=0.1625U L=0.065U
M1596_keeper #984 #fb983# O1_af_518_6 Vdd pmos W=0.0975U L=0.065U
M1597_keeper #985 #fb983# O1_af_518_6 GND nmos W=0.0975U L=0.065U
M1598_ #510 s #509 Vdd pmos W=0.1625U L=0.065U
M1599_ #512 I_at_519_6 n__O0__t_519_6 GND nmos W=0.0975U L=0.065U
M1600_keeper #987 #fb986# n__O0__t_519_6 Vdd pmos W=0.0975U L=0.065U
M1601_keeper #988 #fb986# n__O0__t_519_6 GND nmos W=0.0975U L=0.065U
M1602_ #513 inv__s #512 GND nmos W=0.0975U L=0.065U
M1603_ #515 I_af_519_6 n__O0__f_519_6 GND nmos W=0.0975U L=0.065U
M1604_keeper #990 #fb989# n__O0__f_519_6 Vdd pmos W=0.0975U L=0.065U
M1605_keeper #991 #fb989# n__O0__f_519_6 GND nmos W=0.0975U L=0.065U
M1606_ #516 inv__s #515 GND nmos W=0.0975U L=0.065U
M1607_ #518 inv__I__t_519_6 O1_at_519_6 Vdd pmos W=0.1625U L=0.065U
M1608_keeper #993 #fb992# O1_at_519_6 Vdd pmos W=0.0975U L=0.065U
M1609_keeper #994 #fb992# O1_at_519_6 GND nmos W=0.0975U L=0.065U
M1610_ #519 s #518 Vdd pmos W=0.1625U L=0.065U
M1611_ #521 inv__I__f_519_6 O1_af_519_6 Vdd pmos W=0.1625U L=0.065U
M1612_keeper #996 #fb995# O1_af_519_6 Vdd pmos W=0.0975U L=0.065U
M1613_keeper #997 #fb995# O1_af_519_6 GND nmos W=0.0975U L=0.065U
M1614_ #522 s #521 Vdd pmos W=0.1625U L=0.065U
M1615_ #524 I_at_520_6 n__O0__t_520_6 GND nmos W=0.0975U L=0.065U
M1616_keeper #999 #fb998# n__O0__t_520_6 Vdd pmos W=0.0975U L=0.065U
M1617_keeper #1000 #fb998# n__O0__t_520_6 GND nmos W=0.0975U L=0.065U
M1618_ #525 inv__s #524 GND nmos W=0.0975U L=0.065U
M1619_ #527 I_af_520_6 n__O0__f_520_6 GND nmos W=0.0975U L=0.065U
M1620_keeper #1002 #fb1001# n__O0__f_520_6 Vdd pmos W=0.0975U L=0.065U
M1621_keeper #1003 #fb1001# n__O0__f_520_6 GND nmos W=0.0975U L=0.065U
M1622_ #528 inv__s #527 GND nmos W=0.0975U L=0.065U
M1623_ #530 inv__I__t_520_6 O1_at_520_6 Vdd pmos W=0.1625U L=0.065U
M1624_keeper #1005 #fb1004# O1_at_520_6 Vdd pmos W=0.0975U L=0.065U
M1625_keeper #1006 #fb1004# O1_at_520_6 GND nmos W=0.0975U L=0.065U
M1626_ #531 s #530 Vdd pmos W=0.1625U L=0.065U
M1627_ #533 inv__I__f_520_6 O1_af_520_6 Vdd pmos W=0.1625U L=0.065U
M1628_keeper #1008 #fb1007# O1_af_520_6 Vdd pmos W=0.0975U L=0.065U
M1629_keeper #1009 #fb1007# O1_af_520_6 GND nmos W=0.0975U L=0.065U
M1630_ #534 s #533 Vdd pmos W=0.1625U L=0.065U
M1631_ #536 I_at_521_6 n__O0__t_521_6 GND nmos W=0.0975U L=0.065U
M1632_keeper #1011 #fb1010# n__O0__t_521_6 Vdd pmos W=0.0975U L=0.065U
M1633_keeper #1012 #fb1010# n__O0__t_521_6 GND nmos W=0.0975U L=0.065U
M1634_ #537 inv__s #536 GND nmos W=0.0975U L=0.065U
M1635_ #539 I_af_521_6 n__O0__f_521_6 GND nmos W=0.0975U L=0.065U
M1636_keeper #1014 #fb1013# n__O0__f_521_6 Vdd pmos W=0.0975U L=0.065U
M1637_keeper #1015 #fb1013# n__O0__f_521_6 GND nmos W=0.0975U L=0.065U
M1638_ #540 inv__s #539 GND nmos W=0.0975U L=0.065U
M1639_ #542 inv__I__t_521_6 O1_at_521_6 Vdd pmos W=0.1625U L=0.065U
M1640_keeper #1017 #fb1016# O1_at_521_6 Vdd pmos W=0.0975U L=0.065U
M1641_keeper #1018 #fb1016# O1_at_521_6 GND nmos W=0.0975U L=0.065U
M1642_ #543 s #542 Vdd pmos W=0.1625U L=0.065U
M1643_ #545 inv__I__f_521_6 O1_af_521_6 Vdd pmos W=0.1625U L=0.065U
M1644_keeper #1020 #fb1019# O1_af_521_6 Vdd pmos W=0.0975U L=0.065U
M1645_keeper #1021 #fb1019# O1_af_521_6 GND nmos W=0.0975U L=0.065U
M1646_ #546 s #545 Vdd pmos W=0.1625U L=0.065U
M1647_ #548 I_at_522_6 n__O0__t_522_6 GND nmos W=0.0975U L=0.065U
M1648_keeper #1023 #fb1022# n__O0__t_522_6 Vdd pmos W=0.0975U L=0.065U
M1649_keeper #1024 #fb1022# n__O0__t_522_6 GND nmos W=0.0975U L=0.065U
M1650_ #549 inv__s #548 GND nmos W=0.0975U L=0.065U
M1651_ #551 I_af_522_6 n__O0__f_522_6 GND nmos W=0.0975U L=0.065U
M1652_keeper #1026 #fb1025# n__O0__f_522_6 Vdd pmos W=0.0975U L=0.065U
M1653_keeper #1027 #fb1025# n__O0__f_522_6 GND nmos W=0.0975U L=0.065U
M1654_ #552 inv__s #551 GND nmos W=0.0975U L=0.065U
M1655_ #554 inv__I__t_522_6 O1_at_522_6 Vdd pmos W=0.1625U L=0.065U
M1656_keeper #1029 #fb1028# O1_at_522_6 Vdd pmos W=0.0975U L=0.065U
M1657_keeper #1030 #fb1028# O1_at_522_6 GND nmos W=0.0975U L=0.065U
M1658_ #555 s #554 Vdd pmos W=0.1625U L=0.065U
M1659_ #557 inv__I__f_522_6 O1_af_522_6 Vdd pmos W=0.1625U L=0.065U
M1660_keeper #1032 #fb1031# O1_af_522_6 Vdd pmos W=0.0975U L=0.065U
M1661_keeper #1033 #fb1031# O1_af_522_6 GND nmos W=0.0975U L=0.065U
M1662_ #558 s #557 Vdd pmos W=0.1625U L=0.065U
M1663_ #560 I_at_523_6 n__O0__t_523_6 GND nmos W=0.0975U L=0.065U
M1664_keeper #1035 #fb1034# n__O0__t_523_6 Vdd pmos W=0.0975U L=0.065U
M1665_keeper #1036 #fb1034# n__O0__t_523_6 GND nmos W=0.0975U L=0.065U
M1666_ #561 inv__s #560 GND nmos W=0.0975U L=0.065U
M1667_ #563 I_af_523_6 n__O0__f_523_6 GND nmos W=0.0975U L=0.065U
M1668_keeper #1038 #fb1037# n__O0__f_523_6 Vdd pmos W=0.0975U L=0.065U
M1669_keeper #1039 #fb1037# n__O0__f_523_6 GND nmos W=0.0975U L=0.065U
M1670_ #564 inv__s #563 GND nmos W=0.0975U L=0.065U
M1671_ #566 inv__I__t_523_6 O1_at_523_6 Vdd pmos W=0.1625U L=0.065U
M1672_keeper #1041 #fb1040# O1_at_523_6 Vdd pmos W=0.0975U L=0.065U
M1673_keeper #1042 #fb1040# O1_at_523_6 GND nmos W=0.0975U L=0.065U
M1674_ #567 s #566 Vdd pmos W=0.1625U L=0.065U
M1675_ #569 inv__I__f_523_6 O1_af_523_6 Vdd pmos W=0.1625U L=0.065U
M1676_keeper #1044 #fb1043# O1_af_523_6 Vdd pmos W=0.0975U L=0.065U
M1677_keeper #1045 #fb1043# O1_af_523_6 GND nmos W=0.0975U L=0.065U
M1678_ #570 s #569 Vdd pmos W=0.1625U L=0.065U
M1679_ #572 I_at_524_6 n__O0__t_524_6 GND nmos W=0.0975U L=0.065U
M1680_keeper #1047 #fb1046# n__O0__t_524_6 Vdd pmos W=0.0975U L=0.065U
M1681_keeper #1048 #fb1046# n__O0__t_524_6 GND nmos W=0.0975U L=0.065U
M1682_ #573 inv__s #572 GND nmos W=0.0975U L=0.065U
M1683_ #575 I_af_524_6 n__O0__f_524_6 GND nmos W=0.0975U L=0.065U
M1684_keeper #1050 #fb1049# n__O0__f_524_6 Vdd pmos W=0.0975U L=0.065U
M1685_keeper #1051 #fb1049# n__O0__f_524_6 GND nmos W=0.0975U L=0.065U
M1686_ #576 inv__s #575 GND nmos W=0.0975U L=0.065U
M1687_ #578 inv__I__t_524_6 O1_at_524_6 Vdd pmos W=0.1625U L=0.065U
M1688_keeper #1053 #fb1052# O1_at_524_6 Vdd pmos W=0.0975U L=0.065U
M1689_keeper #1054 #fb1052# O1_at_524_6 GND nmos W=0.0975U L=0.065U
M1690_ #579 s #578 Vdd pmos W=0.1625U L=0.065U
M1691_ #581 inv__I__f_524_6 O1_af_524_6 Vdd pmos W=0.1625U L=0.065U
M1692_keeper #1056 #fb1055# O1_af_524_6 Vdd pmos W=0.0975U L=0.065U
M1693_keeper #1057 #fb1055# O1_af_524_6 GND nmos W=0.0975U L=0.065U
M1694_ #582 s #581 Vdd pmos W=0.1625U L=0.065U
M1695_ #584 I_at_525_6 n__O0__t_525_6 GND nmos W=0.0975U L=0.065U
M1696_keeper #1059 #fb1058# n__O0__t_525_6 Vdd pmos W=0.0975U L=0.065U
M1697_keeper #1060 #fb1058# n__O0__t_525_6 GND nmos W=0.0975U L=0.065U
M1698_ #585 inv__s #584 GND nmos W=0.0975U L=0.065U
M1699_ #587 I_af_525_6 n__O0__f_525_6 GND nmos W=0.0975U L=0.065U
M1700_keeper #1062 #fb1061# n__O0__f_525_6 Vdd pmos W=0.0975U L=0.065U
M1701_keeper #1063 #fb1061# n__O0__f_525_6 GND nmos W=0.0975U L=0.065U
M1702_ #588 inv__s #587 GND nmos W=0.0975U L=0.065U
M1703_ #590 inv__I__t_525_6 O1_at_525_6 Vdd pmos W=0.1625U L=0.065U
M1704_keeper #1065 #fb1064# O1_at_525_6 Vdd pmos W=0.0975U L=0.065U
M1705_keeper #1066 #fb1064# O1_at_525_6 GND nmos W=0.0975U L=0.065U
M1706_ #591 s #590 Vdd pmos W=0.1625U L=0.065U
M1707_ #593 inv__I__f_525_6 O1_af_525_6 Vdd pmos W=0.1625U L=0.065U
M1708_keeper #1068 #fb1067# O1_af_525_6 Vdd pmos W=0.0975U L=0.065U
M1709_keeper #1069 #fb1067# O1_af_525_6 GND nmos W=0.0975U L=0.065U
M1710_ #594 s #593 Vdd pmos W=0.1625U L=0.065U
M1711_ #596 I_at_526_6 n__O0__t_526_6 GND nmos W=0.0975U L=0.065U
M1712_keeper #1071 #fb1070# n__O0__t_526_6 Vdd pmos W=0.0975U L=0.065U
M1713_keeper #1072 #fb1070# n__O0__t_526_6 GND nmos W=0.0975U L=0.065U
M1714_ #597 inv__s #596 GND nmos W=0.0975U L=0.065U
M1715_ #599 I_af_526_6 n__O0__f_526_6 GND nmos W=0.0975U L=0.065U
M1716_keeper #1074 #fb1073# n__O0__f_526_6 Vdd pmos W=0.0975U L=0.065U
M1717_keeper #1075 #fb1073# n__O0__f_526_6 GND nmos W=0.0975U L=0.065U
M1718_ #600 inv__s #599 GND nmos W=0.0975U L=0.065U
M1719_ #602 inv__I__t_526_6 O1_at_526_6 Vdd pmos W=0.1625U L=0.065U
M1720_keeper #1077 #fb1076# O1_at_526_6 Vdd pmos W=0.0975U L=0.065U
M1721_keeper #1078 #fb1076# O1_at_526_6 GND nmos W=0.0975U L=0.065U
M1722_ #603 s #602 Vdd pmos W=0.1625U L=0.065U
M1723_ #605 inv__I__f_526_6 O1_af_526_6 Vdd pmos W=0.1625U L=0.065U
M1724_keeper #1080 #fb1079# O1_af_526_6 Vdd pmos W=0.0975U L=0.065U
M1725_keeper #1081 #fb1079# O1_af_526_6 GND nmos W=0.0975U L=0.065U
M1726_ #606 s #605 Vdd pmos W=0.1625U L=0.065U
M1727_ #608 I_at_527_6 n__O0__t_527_6 GND nmos W=0.0975U L=0.065U
M1728_keeper #1083 #fb1082# n__O0__t_527_6 Vdd pmos W=0.0975U L=0.065U
M1729_keeper #1084 #fb1082# n__O0__t_527_6 GND nmos W=0.0975U L=0.065U
M1730_ #609 inv__s #608 GND nmos W=0.0975U L=0.065U
M1731_ #611 I_af_527_6 n__O0__f_527_6 GND nmos W=0.0975U L=0.065U
M1732_keeper #1086 #fb1085# n__O0__f_527_6 Vdd pmos W=0.0975U L=0.065U
M1733_keeper #1087 #fb1085# n__O0__f_527_6 GND nmos W=0.0975U L=0.065U
M1734_ #612 inv__s #611 GND nmos W=0.0975U L=0.065U
M1735_ #614 inv__I__t_527_6 O1_at_527_6 Vdd pmos W=0.1625U L=0.065U
M1736_keeper #1089 #fb1088# O1_at_527_6 Vdd pmos W=0.0975U L=0.065U
M1737_keeper #1090 #fb1088# O1_at_527_6 GND nmos W=0.0975U L=0.065U
M1738_ #615 s #614 Vdd pmos W=0.1625U L=0.065U
M1739_ #617 inv__I__f_527_6 O1_af_527_6 Vdd pmos W=0.1625U L=0.065U
M1740_keeper #1092 #fb1091# O1_af_527_6 Vdd pmos W=0.0975U L=0.065U
M1741_keeper #1093 #fb1091# O1_af_527_6 GND nmos W=0.0975U L=0.065U
M1742_ #618 s #617 Vdd pmos W=0.1625U L=0.065U
M1743_ #620 I_at_528_6 n__O0__t_528_6 GND nmos W=0.0975U L=0.065U
M1744_keeper #1095 #fb1094# n__O0__t_528_6 Vdd pmos W=0.0975U L=0.065U
M1745_keeper #1096 #fb1094# n__O0__t_528_6 GND nmos W=0.0975U L=0.065U
M1746_ #621 inv__s #620 GND nmos W=0.0975U L=0.065U
M1747_ #623 I_af_528_6 n__O0__f_528_6 GND nmos W=0.0975U L=0.065U
M1748_keeper #1098 #fb1097# n__O0__f_528_6 Vdd pmos W=0.0975U L=0.065U
M1749_keeper #1099 #fb1097# n__O0__f_528_6 GND nmos W=0.0975U L=0.065U
M1750_ #624 inv__s #623 GND nmos W=0.0975U L=0.065U
M1751_ #626 inv__I__t_528_6 O1_at_528_6 Vdd pmos W=0.1625U L=0.065U
M1752_keeper #1101 #fb1100# O1_at_528_6 Vdd pmos W=0.0975U L=0.065U
M1753_keeper #1102 #fb1100# O1_at_528_6 GND nmos W=0.0975U L=0.065U
M1754_ #627 s #626 Vdd pmos W=0.1625U L=0.065U
M1755_ #629 inv__I__f_528_6 O1_af_528_6 Vdd pmos W=0.1625U L=0.065U
M1756_keeper #1104 #fb1103# O1_af_528_6 Vdd pmos W=0.0975U L=0.065U
M1757_keeper #1105 #fb1103# O1_af_528_6 GND nmos W=0.0975U L=0.065U
M1758_ #630 s #629 Vdd pmos W=0.1625U L=0.065U
M1759_ #632 I_at_529_6 n__O0__t_529_6 GND nmos W=0.0975U L=0.065U
M1760_keeper #1107 #fb1106# n__O0__t_529_6 Vdd pmos W=0.0975U L=0.065U
M1761_keeper #1108 #fb1106# n__O0__t_529_6 GND nmos W=0.0975U L=0.065U
M1762_ #633 inv__s #632 GND nmos W=0.0975U L=0.065U
M1763_ #635 I_af_529_6 n__O0__f_529_6 GND nmos W=0.0975U L=0.065U
M1764_keeper #1110 #fb1109# n__O0__f_529_6 Vdd pmos W=0.0975U L=0.065U
M1765_keeper #1111 #fb1109# n__O0__f_529_6 GND nmos W=0.0975U L=0.065U
M1766_ #636 inv__s #635 GND nmos W=0.0975U L=0.065U
M1767_ #638 inv__I__t_529_6 O1_at_529_6 Vdd pmos W=0.1625U L=0.065U
M1768_keeper #1113 #fb1112# O1_at_529_6 Vdd pmos W=0.0975U L=0.065U
M1769_keeper #1114 #fb1112# O1_at_529_6 GND nmos W=0.0975U L=0.065U
M1770_ #639 s #638 Vdd pmos W=0.1625U L=0.065U
M1771_ #641 inv__I__f_529_6 O1_af_529_6 Vdd pmos W=0.1625U L=0.065U
M1772_keeper #1116 #fb1115# O1_af_529_6 Vdd pmos W=0.0975U L=0.065U
M1773_keeper #1117 #fb1115# O1_af_529_6 GND nmos W=0.0975U L=0.065U
M1774_ #642 s #641 Vdd pmos W=0.1625U L=0.065U
M1775_ #644 I_at_530_6 n__O0__t_530_6 GND nmos W=0.0975U L=0.065U
M1776_keeper #1119 #fb1118# n__O0__t_530_6 Vdd pmos W=0.0975U L=0.065U
M1777_keeper #1120 #fb1118# n__O0__t_530_6 GND nmos W=0.0975U L=0.065U
M1778_ #645 inv__s #644 GND nmos W=0.0975U L=0.065U
M1779_ #647 I_af_530_6 n__O0__f_530_6 GND nmos W=0.0975U L=0.065U
M1780_keeper #1122 #fb1121# n__O0__f_530_6 Vdd pmos W=0.0975U L=0.065U
M1781_keeper #1123 #fb1121# n__O0__f_530_6 GND nmos W=0.0975U L=0.065U
M1782_ #648 inv__s #647 GND nmos W=0.0975U L=0.065U
M1783_ #650 inv__I__t_530_6 O1_at_530_6 Vdd pmos W=0.1625U L=0.065U
M1784_keeper #1125 #fb1124# O1_at_530_6 Vdd pmos W=0.0975U L=0.065U
M1785_keeper #1126 #fb1124# O1_at_530_6 GND nmos W=0.0975U L=0.065U
M1786_ #651 s #650 Vdd pmos W=0.1625U L=0.065U
M1787_ #653 inv__I__f_530_6 O1_af_530_6 Vdd pmos W=0.1625U L=0.065U
M1788_keeper #1128 #fb1127# O1_af_530_6 Vdd pmos W=0.0975U L=0.065U
M1789_keeper #1129 #fb1127# O1_af_530_6 GND nmos W=0.0975U L=0.065U
M1790_ #654 s #653 Vdd pmos W=0.1625U L=0.065U
M1791_ #656 I_at_531_6 n__O0__t_531_6 GND nmos W=0.0975U L=0.065U
M1792_keeper #1131 #fb1130# n__O0__t_531_6 Vdd pmos W=0.0975U L=0.065U
M1793_keeper #1132 #fb1130# n__O0__t_531_6 GND nmos W=0.0975U L=0.065U
M1794_ #657 inv__s #656 GND nmos W=0.0975U L=0.065U
M1795_ #659 I_af_531_6 n__O0__f_531_6 GND nmos W=0.0975U L=0.065U
M1796_keeper #1134 #fb1133# n__O0__f_531_6 Vdd pmos W=0.0975U L=0.065U
M1797_keeper #1135 #fb1133# n__O0__f_531_6 GND nmos W=0.0975U L=0.065U
M1798_ #660 inv__s #659 GND nmos W=0.0975U L=0.065U
M1799_ #662 inv__I__t_531_6 O1_at_531_6 Vdd pmos W=0.1625U L=0.065U
M1800_keeper #1137 #fb1136# O1_at_531_6 Vdd pmos W=0.0975U L=0.065U
M1801_keeper #1138 #fb1136# O1_at_531_6 GND nmos W=0.0975U L=0.065U
M1802_ #663 s #662 Vdd pmos W=0.1625U L=0.065U
M1803_ #665 inv__I__f_531_6 O1_af_531_6 Vdd pmos W=0.1625U L=0.065U
M1804_keeper #1140 #fb1139# O1_af_531_6 Vdd pmos W=0.0975U L=0.065U
M1805_keeper #1141 #fb1139# O1_af_531_6 GND nmos W=0.0975U L=0.065U
M1806_ #666 s #665 Vdd pmos W=0.1625U L=0.065U
.ends
*---- end of process: StopcodeSel<> -----
*
*---- act defproc: ChildRouter<> -----
* raw ports:  reset I.t[0] I.t[1] I.t[2] I.t[3] I.t[4] I.t[5] I.t[6] I.t[7] I.t[8] I.t[9] I.t[10] I.t[11] I.t[12] I.t[13] I.t[14] I.t[15] I.t[16] I.t[17] I.t[18] I.t[19] I.t[20] I.t[21] I.t[22] I.t[23] I.t[24] I.t[25] I.t[26] I.t[27] I.t[28] I.t[29] I.t[30] I.t[31] I.f[0] I.f[1] I.f[2] I.f[3] I.f[4] I.f[5] I.f[6] I.f[7] I.f[8] I.f[9] I.f[10] I.f[11] I.f[12] I.f[13] I.f[14] I.f[15] I.f[16] I.f[17] I.f[18] I.f[19] I.f[20] I.f[21] I.f[22] I.f[23] I.f[24] I.f[25] I.f[26] I.f[27] I.f[28] I.f[29] I.f[30] I.f[31] I.a M.t[0] M.t[1] M.t[2] M.t[3] M.t[4] M.t[5] M.t[6] M.t[7] M.t[8] M.t[9] M.t[10] M.t[11] M.t[12] M.t[13] M.t[14] M.t[15] M.t[16] M.t[17] M.t[18] M.t[19] M.t[20] M.t[21] M.t[22] M.t[23] M.t[24] M.t[25] M.t[26] M.t[27] M.t[28] M.t[29] M.t[30] M.t[31] M.f[0] M.f[1] M.f[2] M.f[3] M.f[4] M.f[5] M.f[6] M.f[7] M.f[8] M.f[9] M.f[10] M.f[11] M.f[12] M.f[13] M.f[14] M.f[15] M.f[16] M.f[17] M.f[18] M.f[19] M.f[20] M.f[21] M.f[22] M.f[23] M.f[24] M.f[25] M.f[26] M.f[27] M.f[28] M.f[29] M.f[30] M.f[31] M.a P.t[0] P.t[1] P.t[2] P.t[3] P.t[4] P.t[5] P.t[6] P.t[7] P.t[8] P.t[9] P.t[10] P.t[11] P.t[12] P.t[13] P.t[14] P.t[15] P.t[16] P.t[17] P.t[18] P.t[19] P.t[20] P.t[21] P.t[22] P.t[23] P.t[24] P.t[25] P.t[26] P.t[27] P.t[28] P.t[29] P.t[30] P.t[31] P.f[0] P.f[1] P.f[2] P.f[3] P.f[4] P.f[5] P.f[6] P.f[7] P.f[8] P.f[9] P.f[10] P.f[11] P.f[12] P.f[13] P.f[14] P.f[15] P.f[16] P.f[17] P.f[18] P.f[19] P.f[20] P.f[21] P.f[22] P.f[23] P.f[24] P.f[25] P.f[26] P.f[27] P.f[28] P.f[29] P.f[30] P.f[31] P.a C0.t[0] C0.t[1] C0.t[2] C0.t[3] C0.t[4] C0.t[5] C0.t[6] C0.t[7] C0.t[8] C0.t[9] C0.t[10] C0.t[11] C0.t[12] C0.t[13] C0.t[14] C0.t[15] C0.t[16] C0.t[17] C0.t[18] C0.t[19] C0.t[20] C0.t[21] C0.t[22] C0.t[23] C0.t[24] C0.t[25] C0.t[26] C0.t[27] C0.t[28] C0.t[29] C0.t[30] C0.t[31] C0.f[0] C0.f[1] C0.f[2] C0.f[3] C0.f[4] C0.f[5] C0.f[6] C0.f[7] C0.f[8] C0.f[9] C0.f[10] C0.f[11] C0.f[12] C0.f[13] C0.f[14] C0.f[15] C0.f[16] C0.f[17] C0.f[18] C0.f[19] C0.f[20] C0.f[21] C0.f[22] C0.f[23] C0.f[24] C0.f[25] C0.f[26] C0.f[27] C0.f[28] C0.f[29] C0.f[30] C0.f[31] C0.a C1.t[0] C1.t[1] C1.t[2] C1.t[3] C1.t[4] C1.t[5] C1.t[6] C1.t[7] C1.t[8] C1.t[9] C1.t[10] C1.t[11] C1.t[12] C1.t[13] C1.t[14] C1.t[15] C1.t[16] C1.t[17] C1.t[18] C1.t[19] C1.t[20] C1.t[21] C1.t[22] C1.t[23] C1.t[24] C1.t[25] C1.t[26] C1.t[27] C1.t[28] C1.t[29] C1.t[30] C1.t[31] C1.f[0] C1.f[1] C1.f[2] C1.f[3] C1.f[4] C1.f[5] C1.f[6] C1.f[7] C1.f[8] C1.f[9] C1.f[10] C1.f[11] C1.f[12] C1.f[13] C1.f[14] C1.f[15] C1.f[16] C1.f[17] C1.f[18] C1.f[19] C1.f[20] C1.f[21] C1.f[22] C1.f[23] C1.f[24] C1.f[25] C1.f[26] C1.f[27] C1.f[28] C1.f[29] C1.f[30] C1.f[31] C1.a C2.t[0] C2.t[1] C2.t[2] C2.t[3] C2.t[4] C2.t[5] C2.t[6] C2.t[7] C2.t[8] C2.t[9] C2.t[10] C2.t[11] C2.t[12] C2.t[13] C2.t[14] C2.t[15] C2.t[16] C2.t[17] C2.t[18] C2.t[19] C2.t[20] C2.t[21] C2.t[22] C2.t[23] C2.t[24] C2.t[25] C2.t[26] C2.t[27] C2.t[28] C2.t[29] C2.t[30] C2.t[31] C2.f[0] C2.f[1] C2.f[2] C2.f[3] C2.f[4] C2.f[5] C2.f[6] C2.f[7] C2.f[8] C2.f[9] C2.f[10] C2.f[11] C2.f[12] C2.f[13] C2.f[14] C2.f[15] C2.f[16] C2.f[17] C2.f[18] C2.f[19] C2.f[20] C2.f[21] C2.f[22] C2.f[23] C2.f[24] C2.f[25] C2.f[26] C2.f[27] C2.f[28] C2.f[29] C2.f[30] C2.f[31] C2.a C3.t[0] C3.t[1] C3.t[2] C3.t[3] C3.t[4] C3.t[5] C3.t[6] C3.t[7] C3.t[8] C3.t[9] C3.t[10] C3.t[11] C3.t[12] C3.t[13] C3.t[14] C3.t[15] C3.t[16] C3.t[17] C3.t[18] C3.t[19] C3.t[20] C3.t[21] C3.t[22] C3.t[23] C3.t[24] C3.t[25] C3.t[26] C3.t[27] C3.t[28] C3.t[29] C3.t[30] C3.t[31] C3.f[0] C3.f[1] C3.f[2] C3.f[3] C3.f[4] C3.f[5] C3.f[6] C3.f[7] C3.f[8] C3.f[9] C3.f[10] C3.f[11] C3.f[12] C3.f[13] C3.f[14] C3.f[15] C3.f[16] C3.f[17] C3.f[18] C3.f[19] C3.f[20] C3.f[21] C3.f[22] C3.f[23] C3.f[24] C3.f[25] C3.f[26] C3.f[27] C3.f[28] C3.f[29] C3.f[30] C3.f[31] C3.a
*
.subckt ChildRouter reset I_at_50_6 I_at_51_6 I_at_52_6 I_at_53_6 I_at_54_6 I_at_55_6 I_at_56_6 I_at_57_6 I_at_58_6 I_at_59_6 I_at_510_6 I_at_511_6 I_at_512_6 I_at_513_6 I_at_514_6 I_at_515_6 I_at_516_6 I_at_517_6 I_at_518_6 I_at_519_6 I_at_520_6 I_at_521_6 I_at_522_6 I_at_523_6 I_at_524_6 I_at_525_6 I_at_526_6 I_at_527_6 I_at_528_6 I_at_529_6 I_at_530_6 I_at_531_6 I_af_50_6 I_af_51_6 I_af_52_6 I_af_53_6 I_af_54_6 I_af_55_6 I_af_56_6 I_af_57_6 I_af_58_6 I_af_59_6 I_af_510_6 I_af_511_6 I_af_512_6 I_af_513_6 I_af_514_6 I_af_515_6 I_af_516_6 I_af_517_6 I_af_518_6 I_af_519_6 I_af_520_6 I_af_521_6 I_af_522_6 I_af_523_6 I_af_524_6 I_af_525_6 I_af_526_6 I_af_527_6 I_af_528_6 I_af_529_6 I_af_530_6 I_af_531_6 I_aa M_at_50_6 M_at_51_6 M_at_52_6 M_at_53_6 M_at_54_6 M_at_55_6 M_at_56_6 M_at_57_6 M_at_58_6 M_at_59_6 M_at_510_6 M_at_511_6 M_at_512_6 M_at_513_6 M_at_514_6 M_at_515_6 M_at_516_6 M_at_517_6 M_at_518_6 M_at_519_6 M_at_520_6 M_at_521_6 M_at_522_6 M_at_523_6 M_at_524_6 M_at_525_6 M_at_526_6 M_at_527_6 M_at_528_6 M_at_529_6 M_at_530_6 M_at_531_6 M_af_50_6 M_af_51_6 M_af_52_6 M_af_53_6 M_af_54_6 M_af_55_6 M_af_56_6 M_af_57_6 M_af_58_6 M_af_59_6 M_af_510_6 M_af_511_6 M_af_512_6 M_af_513_6 M_af_514_6 M_af_515_6 M_af_516_6 M_af_517_6 M_af_518_6 M_af_519_6 M_af_520_6 M_af_521_6 M_af_522_6 M_af_523_6 M_af_524_6 M_af_525_6 M_af_526_6 M_af_527_6 M_af_528_6 M_af_529_6 M_af_530_6 M_af_531_6 M_aa P_at_50_6 P_at_51_6 P_at_52_6 P_at_53_6 P_at_54_6 P_at_55_6 P_at_56_6 P_at_57_6 P_at_58_6 P_at_59_6 P_at_510_6 P_at_511_6 P_at_512_6 P_at_513_6 P_at_514_6 P_at_515_6 P_at_516_6 P_at_517_6 P_at_518_6 P_at_519_6 P_at_520_6 P_at_521_6 P_at_522_6 P_at_523_6 P_at_524_6 P_at_525_6 P_at_526_6 P_at_527_6 P_at_528_6 P_at_529_6 P_at_530_6 P_at_531_6 P_af_50_6 P_af_51_6 P_af_52_6 P_af_53_6 P_af_54_6 P_af_55_6 P_af_56_6 P_af_57_6 P_af_58_6 P_af_59_6 P_af_510_6 P_af_511_6 P_af_512_6 P_af_513_6 P_af_514_6 P_af_515_6 P_af_516_6 P_af_517_6 P_af_518_6 P_af_519_6 P_af_520_6 P_af_521_6 P_af_522_6 P_af_523_6 P_af_524_6 P_af_525_6 P_af_526_6 P_af_527_6 P_af_528_6 P_af_529_6 P_af_530_6 P_af_531_6 P_aa C0_at_50_6 C0_at_51_6 C0_at_52_6 C0_at_53_6 C0_at_54_6 C0_at_55_6 C0_at_56_6 C0_at_57_6 C0_at_58_6 C0_at_59_6 C0_at_510_6 C0_at_511_6 C0_at_512_6 C0_at_513_6 C0_at_514_6 C0_at_515_6 C0_at_516_6 C0_at_517_6 C0_at_518_6 C0_at_519_6 C0_at_520_6 C0_at_521_6 C0_at_522_6 C0_at_523_6 C0_at_524_6 C0_at_525_6 C0_at_526_6 C0_at_527_6 C0_at_528_6 C0_at_529_6 C0_at_530_6 C0_at_531_6 C0_af_50_6 C0_af_51_6 C0_af_52_6 C0_af_53_6 C0_af_54_6 C0_af_55_6 C0_af_56_6 C0_af_57_6 C0_af_58_6 C0_af_59_6 C0_af_510_6 C0_af_511_6 C0_af_512_6 C0_af_513_6 C0_af_514_6 C0_af_515_6 C0_af_516_6 C0_af_517_6 C0_af_518_6 C0_af_519_6 C0_af_520_6 C0_af_521_6 C0_af_522_6 C0_af_523_6 C0_af_524_6 C0_af_525_6 C0_af_526_6 C0_af_527_6 C0_af_528_6 C0_af_529_6 C0_af_530_6 C0_af_531_6 C0_aa C1_at_50_6 C1_at_51_6 C1_at_52_6 C1_at_53_6 C1_at_54_6 C1_at_55_6 C1_at_56_6 C1_at_57_6 C1_at_58_6 C1_at_59_6 C1_at_510_6 C1_at_511_6 C1_at_512_6 C1_at_513_6 C1_at_514_6 C1_at_515_6 C1_at_516_6 C1_at_517_6 C1_at_518_6 C1_at_519_6 C1_at_520_6 C1_at_521_6 C1_at_522_6 C1_at_523_6 C1_at_524_6 C1_at_525_6 C1_at_526_6 C1_at_527_6 C1_at_528_6 C1_at_529_6 C1_at_530_6 C1_at_531_6 C1_af_50_6 C1_af_51_6 C1_af_52_6 C1_af_53_6 C1_af_54_6 C1_af_55_6 C1_af_56_6 C1_af_57_6 C1_af_58_6 C1_af_59_6 C1_af_510_6 C1_af_511_6 C1_af_512_6 C1_af_513_6 C1_af_514_6 C1_af_515_6 C1_af_516_6 C1_af_517_6 C1_af_518_6 C1_af_519_6 C1_af_520_6 C1_af_521_6 C1_af_522_6 C1_af_523_6 C1_af_524_6 C1_af_525_6 C1_af_526_6 C1_af_527_6 C1_af_528_6 C1_af_529_6 C1_af_530_6 C1_af_531_6 C1_aa C2_at_50_6 C2_at_51_6 C2_at_52_6 C2_at_53_6 C2_at_54_6 C2_at_55_6 C2_at_56_6 C2_at_57_6 C2_at_58_6 C2_at_59_6 C2_at_510_6 C2_at_511_6 C2_at_512_6 C2_at_513_6 C2_at_514_6 C2_at_515_6 C2_at_516_6 C2_at_517_6 C2_at_518_6 C2_at_519_6 C2_at_520_6 C2_at_521_6 C2_at_522_6 C2_at_523_6 C2_at_524_6 C2_at_525_6 C2_at_526_6 C2_at_527_6 C2_at_528_6 C2_at_529_6 C2_at_530_6 C2_at_531_6 C2_af_50_6 C2_af_51_6 C2_af_52_6 C2_af_53_6 C2_af_54_6 C2_af_55_6 C2_af_56_6 C2_af_57_6 C2_af_58_6 C2_af_59_6 C2_af_510_6 C2_af_511_6 C2_af_512_6 C2_af_513_6 C2_af_514_6 C2_af_515_6 C2_af_516_6 C2_af_517_6 C2_af_518_6 C2_af_519_6 C2_af_520_6 C2_af_521_6 C2_af_522_6 C2_af_523_6 C2_af_524_6 C2_af_525_6 C2_af_526_6 C2_af_527_6 C2_af_528_6 C2_af_529_6 C2_af_530_6 C2_af_531_6 C2_aa C3_at_50_6 C3_at_51_6 C3_at_52_6 C3_at_53_6 C3_at_54_6 C3_at_55_6 C3_at_56_6 C3_at_57_6 C3_at_58_6 C3_at_59_6 C3_at_510_6 C3_at_511_6 C3_at_512_6 C3_at_513_6 C3_at_514_6 C3_at_515_6 C3_at_516_6 C3_at_517_6 C3_at_518_6 C3_at_519_6 C3_at_520_6 C3_at_521_6 C3_at_522_6 C3_at_523_6 C3_at_524_6 C3_at_525_6 C3_at_526_6 C3_at_527_6 C3_at_528_6 C3_at_529_6 C3_at_530_6 C3_at_531_6 C3_af_50_6 C3_af_51_6 C3_af_52_6 C3_af_53_6 C3_af_54_6 C3_af_55_6 C3_af_56_6 C3_af_57_6 C3_af_58_6 C3_af_59_6 C3_af_510_6 C3_af_511_6 C3_af_512_6 C3_af_513_6 C3_af_514_6 C3_af_515_6 C3_af_516_6 C3_af_517_6 C3_af_518_6 C3_af_519_6 C3_af_520_6 C3_af_521_6 C3_af_522_6 C3_af_523_6 C3_af_524_6 C3_af_525_6 C3_af_526_6 C3_af_527_6 C3_af_528_6 C3_af_529_6 C3_af_530_6 C3_af_531_6 C3_aa
*.PININFO reset:I I_at_50_6:I I_at_51_6:I I_at_52_6:I I_at_53_6:I I_at_54_6:I I_at_55_6:I I_at_56_6:I I_at_57_6:I I_at_58_6:I I_at_59_6:I I_at_510_6:I I_at_511_6:I I_at_512_6:I I_at_513_6:I I_at_514_6:I I_at_515_6:I I_at_516_6:I I_at_517_6:I I_at_518_6:I I_at_519_6:I I_at_520_6:I I_at_521_6:I I_at_522_6:I I_at_523_6:I I_at_524_6:I I_at_525_6:I I_at_526_6:I I_at_527_6:I I_at_528_6:I I_at_529_6:I I_at_530_6:I I_at_531_6:I I_af_50_6:I I_af_51_6:I I_af_52_6:I I_af_53_6:I I_af_54_6:I I_af_55_6:I I_af_56_6:I I_af_57_6:I I_af_58_6:I I_af_59_6:I I_af_510_6:I I_af_511_6:I I_af_512_6:I I_af_513_6:I I_af_514_6:I I_af_515_6:I I_af_516_6:I I_af_517_6:I I_af_518_6:I I_af_519_6:I I_af_520_6:I I_af_521_6:I I_af_522_6:I I_af_523_6:I I_af_524_6:I I_af_525_6:I I_af_526_6:I I_af_527_6:I I_af_528_6:I I_af_529_6:I I_af_530_6:I I_af_531_6:I I_aa:O M_at_50_6:O M_at_51_6:O M_at_52_6:O M_at_53_6:O M_at_54_6:O M_at_55_6:O M_at_56_6:O M_at_57_6:O M_at_58_6:O M_at_59_6:O M_at_510_6:O M_at_511_6:O M_at_512_6:O M_at_513_6:O M_at_514_6:O M_at_515_6:O M_at_516_6:O M_at_517_6:O M_at_518_6:O M_at_519_6:O M_at_520_6:O M_at_521_6:O M_at_522_6:O M_at_523_6:O M_at_524_6:O M_at_525_6:O M_at_526_6:O M_at_527_6:O M_at_528_6:O M_at_529_6:O M_at_530_6:O M_at_531_6:O M_af_50_6:O M_af_51_6:O M_af_52_6:O M_af_53_6:O M_af_54_6:O M_af_55_6:O M_af_56_6:O M_af_57_6:O M_af_58_6:O M_af_59_6:O M_af_510_6:O M_af_511_6:O M_af_512_6:O M_af_513_6:O M_af_514_6:O M_af_515_6:O M_af_516_6:O M_af_517_6:O M_af_518_6:O M_af_519_6:O M_af_520_6:O M_af_521_6:O M_af_522_6:O M_af_523_6:O M_af_524_6:O M_af_525_6:O M_af_526_6:O M_af_527_6:O M_af_528_6:O M_af_529_6:O M_af_530_6:O M_af_531_6:O M_aa:I P_at_50_6:O P_at_51_6:O P_at_52_6:O P_at_53_6:O P_at_54_6:O P_at_55_6:O P_at_56_6:O P_at_57_6:O P_at_58_6:O P_at_59_6:O P_at_510_6:O P_at_511_6:O P_at_512_6:O P_at_513_6:O P_at_514_6:O P_at_515_6:O P_at_516_6:O P_at_517_6:O P_at_518_6:O P_at_519_6:O P_at_520_6:O P_at_521_6:O P_at_522_6:O P_at_523_6:O P_at_524_6:O P_at_525_6:O P_at_526_6:O P_at_527_6:O P_at_528_6:O P_at_529_6:O P_at_530_6:O P_at_531_6:O P_af_50_6:O P_af_51_6:O P_af_52_6:O P_af_53_6:O P_af_54_6:O P_af_55_6:O P_af_56_6:O P_af_57_6:O P_af_58_6:O P_af_59_6:O P_af_510_6:O P_af_511_6:O P_af_512_6:O P_af_513_6:O P_af_514_6:O P_af_515_6:O P_af_516_6:O P_af_517_6:O P_af_518_6:O P_af_519_6:O P_af_520_6:O P_af_521_6:O P_af_522_6:O P_af_523_6:O P_af_524_6:O P_af_525_6:O P_af_526_6:O P_af_527_6:O P_af_528_6:O P_af_529_6:O P_af_530_6:O P_af_531_6:O P_aa:I C0_at_50_6:O C0_at_51_6:O C0_at_52_6:O C0_at_53_6:O C0_at_54_6:O C0_at_55_6:O C0_at_56_6:O C0_at_57_6:O C0_at_58_6:O C0_at_59_6:O C0_at_510_6:O C0_at_511_6:O C0_at_512_6:O C0_at_513_6:O C0_at_514_6:O C0_at_515_6:O C0_at_516_6:O C0_at_517_6:O C0_at_518_6:O C0_at_519_6:O C0_at_520_6:O C0_at_521_6:O C0_at_522_6:O C0_at_523_6:O C0_at_524_6:O C0_at_525_6:O C0_at_526_6:O C0_at_527_6:O C0_at_528_6:O C0_at_529_6:O C0_at_530_6:O C0_at_531_6:O C0_af_50_6:O C0_af_51_6:O C0_af_52_6:O C0_af_53_6:O C0_af_54_6:O C0_af_55_6:O C0_af_56_6:O C0_af_57_6:O C0_af_58_6:O C0_af_59_6:O C0_af_510_6:O C0_af_511_6:O C0_af_512_6:O C0_af_513_6:O C0_af_514_6:O C0_af_515_6:O C0_af_516_6:O C0_af_517_6:O C0_af_518_6:O C0_af_519_6:O C0_af_520_6:O C0_af_521_6:O C0_af_522_6:O C0_af_523_6:O C0_af_524_6:O C0_af_525_6:O C0_af_526_6:O C0_af_527_6:O C0_af_528_6:O C0_af_529_6:O C0_af_530_6:O C0_af_531_6:O C0_aa:I C1_at_50_6:O C1_at_51_6:O C1_at_52_6:O C1_at_53_6:O C1_at_54_6:O C1_at_55_6:O C1_at_56_6:O C1_at_57_6:O C1_at_58_6:O C1_at_59_6:O C1_at_510_6:O C1_at_511_6:O C1_at_512_6:O C1_at_513_6:O C1_at_514_6:O C1_at_515_6:O C1_at_516_6:O C1_at_517_6:O C1_at_518_6:O C1_at_519_6:O C1_at_520_6:O C1_at_521_6:O C1_at_522_6:O C1_at_523_6:O C1_at_524_6:O C1_at_525_6:O C1_at_526_6:O C1_at_527_6:O C1_at_528_6:O C1_at_529_6:O C1_at_530_6:O C1_at_531_6:O C1_af_50_6:O C1_af_51_6:O C1_af_52_6:O C1_af_53_6:O C1_af_54_6:O C1_af_55_6:O C1_af_56_6:O C1_af_57_6:O C1_af_58_6:O C1_af_59_6:O C1_af_510_6:O C1_af_511_6:O C1_af_512_6:O C1_af_513_6:O C1_af_514_6:O C1_af_515_6:O C1_af_516_6:O C1_af_517_6:O C1_af_518_6:O C1_af_519_6:O C1_af_520_6:O C1_af_521_6:O C1_af_522_6:O C1_af_523_6:O C1_af_524_6:O C1_af_525_6:O C1_af_526_6:O C1_af_527_6:O C1_af_528_6:O C1_af_529_6:O C1_af_530_6:O C1_af_531_6:O C1_aa:I C2_at_50_6:O C2_at_51_6:O C2_at_52_6:O C2_at_53_6:O C2_at_54_6:O C2_at_55_6:O C2_at_56_6:O C2_at_57_6:O C2_at_58_6:O C2_at_59_6:O C2_at_510_6:O C2_at_511_6:O C2_at_512_6:O C2_at_513_6:O C2_at_514_6:O C2_at_515_6:O C2_at_516_6:O C2_at_517_6:O C2_at_518_6:O C2_at_519_6:O C2_at_520_6:O C2_at_521_6:O C2_at_522_6:O C2_at_523_6:O C2_at_524_6:O C2_at_525_6:O C2_at_526_6:O C2_at_527_6:O C2_at_528_6:O C2_at_529_6:O C2_at_530_6:O C2_at_531_6:O C2_af_50_6:O C2_af_51_6:O C2_af_52_6:O C2_af_53_6:O C2_af_54_6:O C2_af_55_6:O C2_af_56_6:O C2_af_57_6:O C2_af_58_6:O C2_af_59_6:O C2_af_510_6:O C2_af_511_6:O C2_af_512_6:O C2_af_513_6:O C2_af_514_6:O C2_af_515_6:O C2_af_516_6:O C2_af_517_6:O C2_af_518_6:O C2_af_519_6:O C2_af_520_6:O C2_af_521_6:O C2_af_522_6:O C2_af_523_6:O C2_af_524_6:O C2_af_525_6:O C2_af_526_6:O C2_af_527_6:O C2_af_528_6:O C2_af_529_6:O C2_af_530_6:O C2_af_531_6:O C2_aa:I C3_at_50_6:O C3_at_51_6:O C3_at_52_6:O C3_at_53_6:O C3_at_54_6:O C3_at_55_6:O C3_at_56_6:O C3_at_57_6:O C3_at_58_6:O C3_at_59_6:O C3_at_510_6:O C3_at_511_6:O C3_at_512_6:O C3_at_513_6:O C3_at_514_6:O C3_at_515_6:O C3_at_516_6:O C3_at_517_6:O C3_at_518_6:O C3_at_519_6:O C3_at_520_6:O C3_at_521_6:O C3_at_522_6:O C3_at_523_6:O C3_at_524_6:O C3_at_525_6:O C3_at_526_6:O C3_at_527_6:O C3_at_528_6:O C3_at_529_6:O C3_at_530_6:O C3_at_531_6:O C3_af_50_6:O C3_af_51_6:O C3_af_52_6:O C3_af_53_6:O C3_af_54_6:O C3_af_55_6:O C3_af_56_6:O C3_af_57_6:O C3_af_58_6:O C3_af_59_6:O C3_af_510_6:O C3_af_511_6:O C3_af_512_6:O C3_af_513_6:O C3_af_514_6:O C3_af_515_6:O C3_af_516_6:O C3_af_517_6:O C3_af_518_6:O C3_af_519_6:O C3_af_520_6:O C3_af_521_6:O C3_af_522_6:O C3_af_523_6:O C3_af_524_6:O C3_af_525_6:O C3_af_526_6:O C3_af_527_6:O C3_af_528_6:O C3_af_529_6:O C3_af_530_6:O C3_af_531_6:O C3_aa:I
*.POWER VDD Vdd
*.POWER GND GND
*.POWER NSUB GND
*.POWER PSUB Vdd
xCS reset CS_aI_at_50_6 CS_aI_at_51_6 CS_aI_at_52_6 CS_aI_at_53_6 CS_aI_at_54_6 CS_aI_at_55_6 CS_aI_at_56_6 CS_aI_at_57_6 CS_aI_at_58_6 CS_aI_at_59_6 CS_aI_at_510_6 CS_aI_at_511_6 CS_aI_at_512_6 CS_aI_at_513_6 CS_aI_at_514_6 CS_aI_at_515_6 CS_aI_at_516_6 CS_aI_at_517_6 CS_aI_at_518_6 CS_aI_at_519_6 CS_aI_at_520_6 CS_aI_at_521_6 CS_aI_at_522_6 CS_aI_at_523_6 CS_aI_at_524_6 CS_aI_at_525_6 CS_aI_at_526_6 CS_aI_at_527_6 CS_aI_at_528_6 CS_aI_at_529_6 CS_aI_at_530_6 CS_aI_at_531_6 CS_aI_af_50_6 CS_aI_af_51_6 CS_aI_af_52_6 CS_aI_af_53_6 CS_aI_af_54_6 CS_aI_af_55_6 CS_aI_af_56_6 CS_aI_af_57_6 CS_aI_af_58_6 CS_aI_af_59_6 CS_aI_af_510_6 CS_aI_af_511_6 CS_aI_af_512_6 CS_aI_af_513_6 CS_aI_af_514_6 CS_aI_af_515_6 CS_aI_af_516_6 CS_aI_af_517_6 CS_aI_af_518_6 CS_aI_af_519_6 CS_aI_af_520_6 CS_aI_af_521_6 CS_aI_af_522_6 CS_aI_af_523_6 CS_aI_af_524_6 CS_aI_af_525_6 CS_aI_af_526_6 CS_aI_af_527_6 CS_aI_af_528_6 CS_aI_af_529_6 CS_aI_af_530_6 CS_aI_af_531_6 CS_aI_aa C0_at_50_6 C0_at_51_6 C0_at_52_6 C0_at_53_6 C0_at_54_6 C0_at_55_6 C0_at_56_6 C0_at_57_6 C0_at_58_6 C0_at_59_6 C0_at_510_6 C0_at_511_6 C0_at_512_6 C0_at_513_6 C0_at_514_6 C0_at_515_6 C0_at_516_6 C0_at_517_6 C0_at_518_6 C0_at_519_6 C0_at_520_6 C0_at_521_6 C0_at_522_6 C0_at_523_6 C0_at_524_6 C0_at_525_6 C0_at_526_6 C0_at_527_6 C0_at_528_6 C0_at_529_6 C0_at_530_6 C0_at_531_6 C0_af_50_6 C0_af_51_6 C0_af_52_6 C0_af_53_6 C0_af_54_6 C0_af_55_6 C0_af_56_6 C0_af_57_6 C0_af_58_6 C0_af_59_6 C0_af_510_6 C0_af_511_6 C0_af_512_6 C0_af_513_6 C0_af_514_6 C0_af_515_6 C0_af_516_6 C0_af_517_6 C0_af_518_6 C0_af_519_6 C0_af_520_6 C0_af_521_6 C0_af_522_6 C0_af_523_6 C0_af_524_6 C0_af_525_6 C0_af_526_6 C0_af_527_6 C0_af_528_6 C0_af_529_6 C0_af_530_6 C0_af_531_6 C0_aa C1_at_50_6 C1_at_51_6 C1_at_52_6 C1_at_53_6 C1_at_54_6 C1_at_55_6 C1_at_56_6 C1_at_57_6 C1_at_58_6 C1_at_59_6 C1_at_510_6 C1_at_511_6 C1_at_512_6 C1_at_513_6 C1_at_514_6 C1_at_515_6 C1_at_516_6 C1_at_517_6 C1_at_518_6 C1_at_519_6 C1_at_520_6 C1_at_521_6 C1_at_522_6 C1_at_523_6 C1_at_524_6 C1_at_525_6 C1_at_526_6 C1_at_527_6 C1_at_528_6 C1_at_529_6 C1_at_530_6 C1_at_531_6 C1_af_50_6 C1_af_51_6 C1_af_52_6 C1_af_53_6 C1_af_54_6 C1_af_55_6 C1_af_56_6 C1_af_57_6 C1_af_58_6 C1_af_59_6 C1_af_510_6 C1_af_511_6 C1_af_512_6 C1_af_513_6 C1_af_514_6 C1_af_515_6 C1_af_516_6 C1_af_517_6 C1_af_518_6 C1_af_519_6 C1_af_520_6 C1_af_521_6 C1_af_522_6 C1_af_523_6 C1_af_524_6 C1_af_525_6 C1_af_526_6 C1_af_527_6 C1_af_528_6 C1_af_529_6 C1_af_530_6 C1_af_531_6 C1_aa C2_at_50_6 C2_at_51_6 C2_at_52_6 C2_at_53_6 C2_at_54_6 C2_at_55_6 C2_at_56_6 C2_at_57_6 C2_at_58_6 C2_at_59_6 C2_at_510_6 C2_at_511_6 C2_at_512_6 C2_at_513_6 C2_at_514_6 C2_at_515_6 C2_at_516_6 C2_at_517_6 C2_at_518_6 C2_at_519_6 C2_at_520_6 C2_at_521_6 C2_at_522_6 C2_at_523_6 C2_at_524_6 C2_at_525_6 C2_at_526_6 C2_at_527_6 C2_at_528_6 C2_at_529_6 C2_at_530_6 C2_at_531_6 C2_af_50_6 C2_af_51_6 C2_af_52_6 C2_af_53_6 C2_af_54_6 C2_af_55_6 C2_af_56_6 C2_af_57_6 C2_af_58_6 C2_af_59_6 C2_af_510_6 C2_af_511_6 C2_af_512_6 C2_af_513_6 C2_af_514_6 C2_af_515_6 C2_af_516_6 C2_af_517_6 C2_af_518_6 C2_af_519_6 C2_af_520_6 C2_af_521_6 C2_af_522_6 C2_af_523_6 C2_af_524_6 C2_af_525_6 C2_af_526_6 C2_af_527_6 C2_af_528_6 C2_af_529_6 C2_af_530_6 C2_af_531_6 C2_aa C3_at_50_6 C3_at_51_6 C3_at_52_6 C3_at_53_6 C3_at_54_6 C3_at_55_6 C3_at_56_6 C3_at_57_6 C3_at_58_6 C3_at_59_6 C3_at_510_6 C3_at_511_6 C3_at_512_6 C3_at_513_6 C3_at_514_6 C3_at_515_6 C3_at_516_6 C3_at_517_6 C3_at_518_6 C3_at_519_6 C3_at_520_6 C3_at_521_6 C3_at_522_6 C3_at_523_6 C3_at_524_6 C3_at_525_6 C3_at_526_6 C3_at_527_6 C3_at_528_6 C3_at_529_6 C3_at_530_6 C3_at_531_6 C3_af_50_6 C3_af_51_6 C3_af_52_6 C3_af_53_6 C3_af_54_6 C3_af_55_6 C3_af_56_6 C3_af_57_6 C3_af_58_6 C3_af_59_6 C3_af_510_6 C3_af_511_6 C3_af_512_6 C3_af_513_6 C3_af_514_6 C3_af_515_6 C3_af_516_6 C3_af_517_6 C3_af_518_6 C3_af_519_6 C3_af_520_6 C3_af_521_6 C3_af_522_6 C3_af_523_6 C3_af_524_6 C3_af_525_6 C3_af_526_6 C3_af_527_6 C3_af_528_6 C3_af_529_6 C3_af_530_6 C3_af_531_6 C3_aa ChildSel
xUS reset SS_aO1_at_50_6 SS_aO1_at_51_6 SS_aO1_at_52_6 SS_aO1_at_53_6 SS_aO1_at_54_6 SS_aO1_at_55_6 SS_aO1_at_56_6 SS_aO1_at_57_6 SS_aO1_at_58_6 SS_aO1_at_59_6 SS_aO1_at_510_6 SS_aO1_at_511_6 SS_aO1_at_512_6 SS_aO1_at_513_6 SS_aO1_at_514_6 SS_aO1_at_515_6 SS_aO1_at_516_6 SS_aO1_at_517_6 SS_aO1_at_518_6 SS_aO1_at_519_6 SS_aO1_at_520_6 SS_aO1_at_521_6 SS_aO1_at_522_6 SS_aO1_at_523_6 SS_aO1_at_524_6 SS_aO1_at_525_6 SS_aO1_at_526_6 SS_aO1_at_527_6 SS_aO1_at_528_6 SS_aO1_at_529_6 SS_aO1_at_530_6 SS_aO1_at_531_6 SS_aO1_af_50_6 SS_aO1_af_51_6 SS_aO1_af_52_6 SS_aO1_af_53_6 SS_aO1_af_54_6 SS_aO1_af_55_6 SS_aO1_af_56_6 SS_aO1_af_57_6 SS_aO1_af_58_6 SS_aO1_af_59_6 SS_aO1_af_510_6 SS_aO1_af_511_6 SS_aO1_af_512_6 SS_aO1_af_513_6 SS_aO1_af_514_6 SS_aO1_af_515_6 SS_aO1_af_516_6 SS_aO1_af_517_6 SS_aO1_af_518_6 SS_aO1_af_519_6 SS_aO1_af_520_6 SS_aO1_af_521_6 SS_aO1_af_522_6 SS_aO1_af_523_6 SS_aO1_af_524_6 SS_aO1_af_525_6 SS_aO1_af_526_6 SS_aO1_af_527_6 SS_aO1_af_528_6 SS_aO1_af_529_6 SS_aO1_af_530_6 SS_aO1_af_531_6 SS_aO1_aa P_at_50_6 P_at_51_6 P_at_52_6 P_at_53_6 P_at_54_6 P_at_55_6 P_at_56_6 P_at_57_6 P_at_58_6 P_at_59_6 P_at_510_6 P_at_511_6 P_at_512_6 P_at_513_6 P_at_514_6 P_at_515_6 P_at_516_6 P_at_517_6 P_at_518_6 P_at_519_6 P_at_520_6 P_at_521_6 P_at_522_6 P_at_523_6 P_at_524_6 P_at_525_6 P_at_526_6 P_at_527_6 P_at_528_6 P_at_529_6 P_at_530_6 P_at_531_6 P_af_50_6 P_af_51_6 P_af_52_6 P_af_53_6 P_af_54_6 P_af_55_6 P_af_56_6 P_af_57_6 P_af_58_6 P_af_59_6 P_af_510_6 P_af_511_6 P_af_512_6 P_af_513_6 P_af_514_6 P_af_515_6 P_af_516_6 P_af_517_6 P_af_518_6 P_af_519_6 P_af_520_6 P_af_521_6 P_af_522_6 P_af_523_6 P_af_524_6 P_af_525_6 P_af_526_6 P_af_527_6 P_af_528_6 P_af_529_6 P_af_530_6 P_af_531_6 P_aa CS_aI_at_50_6 CS_aI_at_51_6 CS_aI_at_52_6 CS_aI_at_53_6 CS_aI_at_54_6 CS_aI_at_55_6 CS_aI_at_56_6 CS_aI_at_57_6 CS_aI_at_58_6 CS_aI_at_59_6 CS_aI_at_510_6 CS_aI_at_511_6 CS_aI_at_512_6 CS_aI_at_513_6 CS_aI_at_514_6 CS_aI_at_515_6 CS_aI_at_516_6 CS_aI_at_517_6 CS_aI_at_518_6 CS_aI_at_519_6 CS_aI_at_520_6 CS_aI_at_521_6 CS_aI_at_522_6 CS_aI_at_523_6 CS_aI_at_524_6 CS_aI_at_525_6 CS_aI_at_526_6 CS_aI_at_527_6 CS_aI_at_528_6 CS_aI_at_529_6 CS_aI_at_530_6 CS_aI_at_531_6 CS_aI_af_50_6 CS_aI_af_51_6 CS_aI_af_52_6 CS_aI_af_53_6 CS_aI_af_54_6 CS_aI_af_55_6 CS_aI_af_56_6 CS_aI_af_57_6 CS_aI_af_58_6 CS_aI_af_59_6 CS_aI_af_510_6 CS_aI_af_511_6 CS_aI_af_512_6 CS_aI_af_513_6 CS_aI_af_514_6 CS_aI_af_515_6 CS_aI_af_516_6 CS_aI_af_517_6 CS_aI_af_518_6 CS_aI_af_519_6 CS_aI_af_520_6 CS_aI_af_521_6 CS_aI_af_522_6 CS_aI_af_523_6 CS_aI_af_524_6 CS_aI_af_525_6 CS_aI_af_526_6 CS_aI_af_527_6 CS_aI_af_528_6 CS_aI_af_529_6 CS_aI_af_530_6 CS_aI_af_531_6 CS_aI_aa UpdownSel
xSS reset I_at_50_6 I_at_51_6 I_at_52_6 I_at_53_6 I_at_54_6 I_at_55_6 I_at_56_6 I_at_57_6 I_at_58_6 I_at_59_6 I_at_510_6 I_at_511_6 I_at_512_6 I_at_513_6 I_at_514_6 I_at_515_6 I_at_516_6 I_at_517_6 I_at_518_6 I_at_519_6 I_at_520_6 I_at_521_6 I_at_522_6 I_at_523_6 I_at_524_6 I_at_525_6 I_at_526_6 I_at_527_6 I_at_528_6 I_at_529_6 I_at_530_6 I_at_531_6 I_af_50_6 I_af_51_6 I_af_52_6 I_af_53_6 I_af_54_6 I_af_55_6 I_af_56_6 I_af_57_6 I_af_58_6 I_af_59_6 I_af_510_6 I_af_511_6 I_af_512_6 I_af_513_6 I_af_514_6 I_af_515_6 I_af_516_6 I_af_517_6 I_af_518_6 I_af_519_6 I_af_520_6 I_af_521_6 I_af_522_6 I_af_523_6 I_af_524_6 I_af_525_6 I_af_526_6 I_af_527_6 I_af_528_6 I_af_529_6 I_af_530_6 I_af_531_6 I_aa M_at_50_6 M_at_51_6 M_at_52_6 M_at_53_6 M_at_54_6 M_at_55_6 M_at_56_6 M_at_57_6 M_at_58_6 M_at_59_6 M_at_510_6 M_at_511_6 M_at_512_6 M_at_513_6 M_at_514_6 M_at_515_6 M_at_516_6 M_at_517_6 M_at_518_6 M_at_519_6 M_at_520_6 M_at_521_6 M_at_522_6 M_at_523_6 M_at_524_6 M_at_525_6 M_at_526_6 M_at_527_6 M_at_528_6 M_at_529_6 M_at_530_6 M_at_531_6 M_af_50_6 M_af_51_6 M_af_52_6 M_af_53_6 M_af_54_6 M_af_55_6 M_af_56_6 M_af_57_6 M_af_58_6 M_af_59_6 M_af_510_6 M_af_511_6 M_af_512_6 M_af_513_6 M_af_514_6 M_af_515_6 M_af_516_6 M_af_517_6 M_af_518_6 M_af_519_6 M_af_520_6 M_af_521_6 M_af_522_6 M_af_523_6 M_af_524_6 M_af_525_6 M_af_526_6 M_af_527_6 M_af_528_6 M_af_529_6 M_af_530_6 M_af_531_6 M_aa SS_aO1_at_50_6 SS_aO1_at_51_6 SS_aO1_at_52_6 SS_aO1_at_53_6 SS_aO1_at_54_6 SS_aO1_at_55_6 SS_aO1_at_56_6 SS_aO1_at_57_6 SS_aO1_at_58_6 SS_aO1_at_59_6 SS_aO1_at_510_6 SS_aO1_at_511_6 SS_aO1_at_512_6 SS_aO1_at_513_6 SS_aO1_at_514_6 SS_aO1_at_515_6 SS_aO1_at_516_6 SS_aO1_at_517_6 SS_aO1_at_518_6 SS_aO1_at_519_6 SS_aO1_at_520_6 SS_aO1_at_521_6 SS_aO1_at_522_6 SS_aO1_at_523_6 SS_aO1_at_524_6 SS_aO1_at_525_6 SS_aO1_at_526_6 SS_aO1_at_527_6 SS_aO1_at_528_6 SS_aO1_at_529_6 SS_aO1_at_530_6 SS_aO1_at_531_6 SS_aO1_af_50_6 SS_aO1_af_51_6 SS_aO1_af_52_6 SS_aO1_af_53_6 SS_aO1_af_54_6 SS_aO1_af_55_6 SS_aO1_af_56_6 SS_aO1_af_57_6 SS_aO1_af_58_6 SS_aO1_af_59_6 SS_aO1_af_510_6 SS_aO1_af_511_6 SS_aO1_af_512_6 SS_aO1_af_513_6 SS_aO1_af_514_6 SS_aO1_af_515_6 SS_aO1_af_516_6 SS_aO1_af_517_6 SS_aO1_af_518_6 SS_aO1_af_519_6 SS_aO1_af_520_6 SS_aO1_af_521_6 SS_aO1_af_522_6 SS_aO1_af_523_6 SS_aO1_af_524_6 SS_aO1_af_525_6 SS_aO1_af_526_6 SS_aO1_af_527_6 SS_aO1_af_528_6 SS_aO1_af_529_6 SS_aO1_af_530_6 SS_aO1_af_531_6 SS_aO1_aa StopcodeSel
.ends
*---- end of process: ChildRouter<> -----
*
*---- act defproc: Arb2<> -----
* raw ports:  reset I0.t[0] I0.t[1] I0.t[2] I0.t[3] I0.t[4] I0.t[5] I0.t[6] I0.t[7] I0.t[8] I0.t[9] I0.t[10] I0.t[11] I0.t[12] I0.t[13] I0.t[14] I0.t[15] I0.t[16] I0.t[17] I0.t[18] I0.t[19] I0.t[20] I0.t[21] I0.t[22] I0.t[23] I0.t[24] I0.t[25] I0.t[26] I0.t[27] I0.t[28] I0.t[29] I0.t[30] I0.t[31] I0.f[0] I0.f[1] I0.f[2] I0.f[3] I0.f[4] I0.f[5] I0.f[6] I0.f[7] I0.f[8] I0.f[9] I0.f[10] I0.f[11] I0.f[12] I0.f[13] I0.f[14] I0.f[15] I0.f[16] I0.f[17] I0.f[18] I0.f[19] I0.f[20] I0.f[21] I0.f[22] I0.f[23] I0.f[24] I0.f[25] I0.f[26] I0.f[27] I0.f[28] I0.f[29] I0.f[30] I0.f[31] I0.a I1.t[0] I1.t[1] I1.t[2] I1.t[3] I1.t[4] I1.t[5] I1.t[6] I1.t[7] I1.t[8] I1.t[9] I1.t[10] I1.t[11] I1.t[12] I1.t[13] I1.t[14] I1.t[15] I1.t[16] I1.t[17] I1.t[18] I1.t[19] I1.t[20] I1.t[21] I1.t[22] I1.t[23] I1.t[24] I1.t[25] I1.t[26] I1.t[27] I1.t[28] I1.t[29] I1.t[30] I1.t[31] I1.f[0] I1.f[1] I1.f[2] I1.f[3] I1.f[4] I1.f[5] I1.f[6] I1.f[7] I1.f[8] I1.f[9] I1.f[10] I1.f[11] I1.f[12] I1.f[13] I1.f[14] I1.f[15] I1.f[16] I1.f[17] I1.f[18] I1.f[19] I1.f[20] I1.f[21] I1.f[22] I1.f[23] I1.f[24] I1.f[25] I1.f[26] I1.f[27] I1.f[28] I1.f[29] I1.f[30] I1.f[31] I1.a O.t[0] O.t[1] O.t[2] O.t[3] O.t[4] O.t[5] O.t[6] O.t[7] O.t[8] O.t[9] O.t[10] O.t[11] O.t[12] O.t[13] O.t[14] O.t[15] O.t[16] O.t[17] O.t[18] O.t[19] O.t[20] O.t[21] O.t[22] O.t[23] O.t[24] O.t[25] O.t[26] O.t[27] O.t[28] O.t[29] O.t[30] O.t[31] O.f[0] O.f[1] O.f[2] O.f[3] O.f[4] O.f[5] O.f[6] O.f[7] O.f[8] O.f[9] O.f[10] O.f[11] O.f[12] O.f[13] O.f[14] O.f[15] O.f[16] O.f[17] O.f[18] O.f[19] O.f[20] O.f[21] O.f[22] O.f[23] O.f[24] O.f[25] O.f[26] O.f[27] O.f[28] O.f[29] O.f[30] O.f[31] O.a
*
.subckt Arb2 reset I0_at_50_6 I0_at_51_6 I0_at_52_6 I0_at_53_6 I0_at_54_6 I0_at_55_6 I0_at_56_6 I0_at_57_6 I0_at_58_6 I0_at_59_6 I0_at_510_6 I0_at_511_6 I0_at_512_6 I0_at_513_6 I0_at_514_6 I0_at_515_6 I0_at_516_6 I0_at_517_6 I0_at_518_6 I0_at_519_6 I0_at_520_6 I0_at_521_6 I0_at_522_6 I0_at_523_6 I0_at_524_6 I0_at_525_6 I0_at_526_6 I0_at_527_6 I0_at_528_6 I0_at_529_6 I0_at_530_6 I0_at_531_6 I0_af_50_6 I0_af_51_6 I0_af_52_6 I0_af_53_6 I0_af_54_6 I0_af_55_6 I0_af_56_6 I0_af_57_6 I0_af_58_6 I0_af_59_6 I0_af_510_6 I0_af_511_6 I0_af_512_6 I0_af_513_6 I0_af_514_6 I0_af_515_6 I0_af_516_6 I0_af_517_6 I0_af_518_6 I0_af_519_6 I0_af_520_6 I0_af_521_6 I0_af_522_6 I0_af_523_6 I0_af_524_6 I0_af_525_6 I0_af_526_6 I0_af_527_6 I0_af_528_6 I0_af_529_6 I0_af_530_6 I0_af_531_6 I0_aa I1_at_50_6 I1_at_51_6 I1_at_52_6 I1_at_53_6 I1_at_54_6 I1_at_55_6 I1_at_56_6 I1_at_57_6 I1_at_58_6 I1_at_59_6 I1_at_510_6 I1_at_511_6 I1_at_512_6 I1_at_513_6 I1_at_514_6 I1_at_515_6 I1_at_516_6 I1_at_517_6 I1_at_518_6 I1_at_519_6 I1_at_520_6 I1_at_521_6 I1_at_522_6 I1_at_523_6 I1_at_524_6 I1_at_525_6 I1_at_526_6 I1_at_527_6 I1_at_528_6 I1_at_529_6 I1_at_530_6 I1_at_531_6 I1_af_50_6 I1_af_51_6 I1_af_52_6 I1_af_53_6 I1_af_54_6 I1_af_55_6 I1_af_56_6 I1_af_57_6 I1_af_58_6 I1_af_59_6 I1_af_510_6 I1_af_511_6 I1_af_512_6 I1_af_513_6 I1_af_514_6 I1_af_515_6 I1_af_516_6 I1_af_517_6 I1_af_518_6 I1_af_519_6 I1_af_520_6 I1_af_521_6 I1_af_522_6 I1_af_523_6 I1_af_524_6 I1_af_525_6 I1_af_526_6 I1_af_527_6 I1_af_528_6 I1_af_529_6 I1_af_530_6 I1_af_531_6 I1_aa O_at_50_6 O_at_51_6 O_at_52_6 O_at_53_6 O_at_54_6 O_at_55_6 O_at_56_6 O_at_57_6 O_at_58_6 O_at_59_6 O_at_510_6 O_at_511_6 O_at_512_6 O_at_513_6 O_at_514_6 O_at_515_6 O_at_516_6 O_at_517_6 O_at_518_6 O_at_519_6 O_at_520_6 O_at_521_6 O_at_522_6 O_at_523_6 O_at_524_6 O_at_525_6 O_at_526_6 O_at_527_6 O_at_528_6 O_at_529_6 O_at_530_6 O_at_531_6 O_af_50_6 O_af_51_6 O_af_52_6 O_af_53_6 O_af_54_6 O_af_55_6 O_af_56_6 O_af_57_6 O_af_58_6 O_af_59_6 O_af_510_6 O_af_511_6 O_af_512_6 O_af_513_6 O_af_514_6 O_af_515_6 O_af_516_6 O_af_517_6 O_af_518_6 O_af_519_6 O_af_520_6 O_af_521_6 O_af_522_6 O_af_523_6 O_af_524_6 O_af_525_6 O_af_526_6 O_af_527_6 O_af_528_6 O_af_529_6 O_af_530_6 O_af_531_6 O_aa
*.PININFO reset:I I0_at_50_6:I I0_at_51_6:I I0_at_52_6:I I0_at_53_6:I I0_at_54_6:I I0_at_55_6:I I0_at_56_6:I I0_at_57_6:I I0_at_58_6:I I0_at_59_6:I I0_at_510_6:I I0_at_511_6:I I0_at_512_6:I I0_at_513_6:I I0_at_514_6:I I0_at_515_6:I I0_at_516_6:I I0_at_517_6:I I0_at_518_6:I I0_at_519_6:I I0_at_520_6:I I0_at_521_6:I I0_at_522_6:I I0_at_523_6:I I0_at_524_6:I I0_at_525_6:I I0_at_526_6:I I0_at_527_6:I I0_at_528_6:I I0_at_529_6:I I0_at_530_6:I I0_at_531_6:I I0_af_50_6:I I0_af_51_6:I I0_af_52_6:I I0_af_53_6:I I0_af_54_6:I I0_af_55_6:I I0_af_56_6:I I0_af_57_6:I I0_af_58_6:I I0_af_59_6:I I0_af_510_6:I I0_af_511_6:I I0_af_512_6:I I0_af_513_6:I I0_af_514_6:I I0_af_515_6:I I0_af_516_6:I I0_af_517_6:I I0_af_518_6:I I0_af_519_6:I I0_af_520_6:I I0_af_521_6:I I0_af_522_6:I I0_af_523_6:I I0_af_524_6:I I0_af_525_6:I I0_af_526_6:I I0_af_527_6:I I0_af_528_6:I I0_af_529_6:I I0_af_530_6:I I0_af_531_6:I I0_aa:O I1_at_50_6:I I1_at_51_6:I I1_at_52_6:I I1_at_53_6:I I1_at_54_6:I I1_at_55_6:I I1_at_56_6:I I1_at_57_6:I I1_at_58_6:I I1_at_59_6:I I1_at_510_6:I I1_at_511_6:I I1_at_512_6:I I1_at_513_6:I I1_at_514_6:I I1_at_515_6:I I1_at_516_6:I I1_at_517_6:I I1_at_518_6:I I1_at_519_6:I I1_at_520_6:I I1_at_521_6:I I1_at_522_6:I I1_at_523_6:I I1_at_524_6:I I1_at_525_6:I I1_at_526_6:I I1_at_527_6:I I1_at_528_6:I I1_at_529_6:I I1_at_530_6:I I1_at_531_6:I I1_af_50_6:I I1_af_51_6:I I1_af_52_6:I I1_af_53_6:I I1_af_54_6:I I1_af_55_6:I I1_af_56_6:I I1_af_57_6:I I1_af_58_6:I I1_af_59_6:I I1_af_510_6:I I1_af_511_6:I I1_af_512_6:I I1_af_513_6:I I1_af_514_6:I I1_af_515_6:I I1_af_516_6:I I1_af_517_6:I I1_af_518_6:I I1_af_519_6:I I1_af_520_6:I I1_af_521_6:I I1_af_522_6:I I1_af_523_6:I I1_af_524_6:I I1_af_525_6:I I1_af_526_6:I I1_af_527_6:I I1_af_528_6:I I1_af_529_6:I I1_af_530_6:I I1_af_531_6:I I1_aa:O O_at_50_6:O O_at_51_6:O O_at_52_6:O O_at_53_6:O O_at_54_6:O O_at_55_6:O O_at_56_6:O O_at_57_6:O O_at_58_6:O O_at_59_6:O O_at_510_6:O O_at_511_6:O O_at_512_6:O O_at_513_6:O O_at_514_6:O O_at_515_6:O O_at_516_6:O O_at_517_6:O O_at_518_6:O O_at_519_6:O O_at_520_6:O O_at_521_6:O O_at_522_6:O O_at_523_6:O O_at_524_6:O O_at_525_6:O O_at_526_6:O O_at_527_6:O O_at_528_6:O O_at_529_6:O O_at_530_6:O O_at_531_6:O O_af_50_6:O O_af_51_6:O O_af_52_6:O O_af_53_6:O O_af_54_6:O O_af_55_6:O O_af_56_6:O O_af_57_6:O O_af_58_6:O O_af_59_6:O O_af_510_6:O O_af_511_6:O O_af_512_6:O O_af_513_6:O O_af_514_6:O O_af_515_6:O O_af_516_6:O O_af_517_6:O O_af_518_6:O O_af_519_6:O O_af_520_6:O O_af_521_6:O O_af_522_6:O O_af_523_6:O O_af_524_6:O O_af_525_6:O O_af_526_6:O O_af_527_6:O O_af_528_6:O O_af_529_6:O O_af_530_6:O O_af_531_6:O O_aa:I
*.POWER VDD Vdd
*.POWER GND GND
*.POWER NSUB GND
*.POWER PSUB Vdd
*
* --- node flags ---
*
* p (state-holding): pup_reff=1.6; pdn_reff=2.66667
* I0_aa (combinational)
* I1_aa (combinational)
* n__u (combinational)
* n__s (state-holding): pup_reff=0.4; pdn_reff=1.33333
* inv__reset (combinational)
* n__I0__a (state-holding): pup_reff=1.2; pdn_reff=2.66667
* n__I1__a (state-holding): pup_reff=1.2; pdn_reff=2.66667
* v (combinational)
* s (combinational)
* w0i (state-holding): pup_reff=1.2; pdn_reff=1.33333
* inv__p (combinational)
* n__v (combinational)
* f (state-holding): pup_reff=2; pdn_reff=1.33333
* n__w0 (state-holding): pup_reff=0.8; pdn_reff=2
* n__w1 (state-holding): pup_reff=0.8; pdn_reff=2
* u (combinational)
* inv__f (combinational)
* w1 (combinational)
* inv__w0i (combinational)
* w0 (combinational)
* n__O__t_50_6 (state-holding): pup_reff=0.8; pdn_reff=2
* n__O__f_50_6 (state-holding): pup_reff=0.8; pdn_reff=2
* n__O__t_51_6 (state-holding): pup_reff=0.8; pdn_reff=2
* n__O__f_51_6 (state-holding): pup_reff=0.8; pdn_reff=2
* n__O__t_52_6 (state-holding): pup_reff=0.8; pdn_reff=2
* n__O__f_52_6 (state-holding): pup_reff=0.8; pdn_reff=2
* n__O__t_53_6 (state-holding): pup_reff=0.8; pdn_reff=2
* n__O__f_53_6 (state-holding): pup_reff=0.8; pdn_reff=2
* n__O__t_54_6 (state-holding): pup_reff=0.8; pdn_reff=2
* n__O__f_54_6 (state-holding): pup_reff=0.8; pdn_reff=2
* n__O__t_55_6 (state-holding): pup_reff=0.8; pdn_reff=2
* n__O__f_55_6 (state-holding): pup_reff=0.8; pdn_reff=2
* n__O__t_56_6 (state-holding): pup_reff=0.8; pdn_reff=2
* n__O__f_56_6 (state-holding): pup_reff=0.8; pdn_reff=2
* n__O__t_57_6 (state-holding): pup_reff=0.8; pdn_reff=2
* n__O__f_57_6 (state-holding): pup_reff=0.8; pdn_reff=2
* n__O__t_58_6 (state-holding): pup_reff=0.8; pdn_reff=2
* n__O__f_58_6 (state-holding): pup_reff=0.8; pdn_reff=2
* n__O__t_59_6 (state-holding): pup_reff=0.8; pdn_reff=2
* n__O__f_59_6 (state-holding): pup_reff=0.8; pdn_reff=2
* n__O__t_510_6 (state-holding): pup_reff=0.8; pdn_reff=2
* n__O__f_510_6 (state-holding): pup_reff=0.8; pdn_reff=2
* n__O__t_511_6 (state-holding): pup_reff=0.8; pdn_reff=2
* n__O__f_511_6 (state-holding): pup_reff=0.8; pdn_reff=2
* n__O__t_512_6 (state-holding): pup_reff=0.8; pdn_reff=2
* n__O__f_512_6 (state-holding): pup_reff=0.8; pdn_reff=2
* n__O__t_513_6 (state-holding): pup_reff=0.8; pdn_reff=2
* n__O__f_513_6 (state-holding): pup_reff=0.8; pdn_reff=2
* n__O__t_514_6 (state-holding): pup_reff=0.8; pdn_reff=2
* n__O__f_514_6 (state-holding): pup_reff=0.8; pdn_reff=2
* n__O__t_515_6 (state-holding): pup_reff=0.8; pdn_reff=2
* n__O__f_515_6 (state-holding): pup_reff=0.8; pdn_reff=2
* n__O__t_516_6 (state-holding): pup_reff=0.8; pdn_reff=2
* n__O__f_516_6 (state-holding): pup_reff=0.8; pdn_reff=2
* n__O__t_517_6 (state-holding): pup_reff=0.8; pdn_reff=2
* n__O__f_517_6 (state-holding): pup_reff=0.8; pdn_reff=2
* n__O__t_518_6 (state-holding): pup_reff=0.8; pdn_reff=2
* n__O__f_518_6 (state-holding): pup_reff=0.8; pdn_reff=2
* n__O__t_519_6 (state-holding): pup_reff=0.8; pdn_reff=2
* n__O__f_519_6 (state-holding): pup_reff=0.8; pdn_reff=2
* n__O__t_520_6 (state-holding): pup_reff=0.8; pdn_reff=2
* n__O__f_520_6 (state-holding): pup_reff=0.8; pdn_reff=2
* n__O__t_521_6 (state-holding): pup_reff=0.8; pdn_reff=2
* n__O__f_521_6 (state-holding): pup_reff=0.8; pdn_reff=2
* n__O__t_522_6 (state-holding): pup_reff=0.8; pdn_reff=2
* n__O__f_522_6 (state-holding): pup_reff=0.8; pdn_reff=2
* n__O__t_523_6 (state-holding): pup_reff=0.8; pdn_reff=2
* n__O__f_523_6 (state-holding): pup_reff=0.8; pdn_reff=2
* n__O__t_524_6 (state-holding): pup_reff=0.8; pdn_reff=2
* n__O__f_524_6 (state-holding): pup_reff=0.8; pdn_reff=2
* n__O__t_525_6 (state-holding): pup_reff=0.8; pdn_reff=2
* n__O__f_525_6 (state-holding): pup_reff=0.8; pdn_reff=2
* n__O__t_526_6 (state-holding): pup_reff=0.8; pdn_reff=2
* n__O__f_526_6 (state-holding): pup_reff=0.8; pdn_reff=2
* n__O__t_527_6 (state-holding): pup_reff=0.8; pdn_reff=2
* n__O__f_527_6 (state-holding): pup_reff=0.8; pdn_reff=2
* n__O__t_528_6 (state-holding): pup_reff=0.8; pdn_reff=2
* n__O__f_528_6 (state-holding): pup_reff=0.8; pdn_reff=2
* n__O__t_529_6 (state-holding): pup_reff=0.8; pdn_reff=2
* n__O__f_529_6 (state-holding): pup_reff=0.8; pdn_reff=2
* n__O__t_530_6 (state-holding): pup_reff=0.8; pdn_reff=2
* n__O__f_530_6 (state-holding): pup_reff=0.8; pdn_reff=2
* n__O__t_531_6 (state-holding): pup_reff=0.8; pdn_reff=2
* n__O__f_531_6 (state-holding): pup_reff=0.8; pdn_reff=2
* O_at_50_6 (combinational)
* O_af_50_6 (combinational)
* O_at_51_6 (combinational)
* O_af_51_6 (combinational)
* O_at_52_6 (combinational)
* O_af_52_6 (combinational)
* O_at_53_6 (combinational)
* O_af_53_6 (combinational)
* O_at_54_6 (combinational)
* O_af_54_6 (combinational)
* O_at_55_6 (combinational)
* O_af_55_6 (combinational)
* O_at_56_6 (combinational)
* O_af_56_6 (combinational)
* O_at_57_6 (combinational)
* O_af_57_6 (combinational)
* O_at_58_6 (combinational)
* O_af_58_6 (combinational)
* O_at_59_6 (combinational)
* O_af_59_6 (combinational)
* O_at_510_6 (combinational)
* O_af_510_6 (combinational)
* O_at_511_6 (combinational)
* O_af_511_6 (combinational)
* O_at_512_6 (combinational)
* O_af_512_6 (combinational)
* O_at_513_6 (combinational)
* O_af_513_6 (combinational)
* O_at_514_6 (combinational)
* O_af_514_6 (combinational)
* O_at_515_6 (combinational)
* O_af_515_6 (combinational)
* O_at_516_6 (combinational)
* O_af_516_6 (combinational)
* O_at_517_6 (combinational)
* O_af_517_6 (combinational)
* O_at_518_6 (combinational)
* O_af_518_6 (combinational)
* O_at_519_6 (combinational)
* O_af_519_6 (combinational)
* O_at_520_6 (combinational)
* O_af_520_6 (combinational)
* O_at_521_6 (combinational)
* O_af_521_6 (combinational)
* O_at_522_6 (combinational)
* O_af_522_6 (combinational)
* O_at_523_6 (combinational)
* O_af_523_6 (combinational)
* O_at_524_6 (combinational)
* O_af_524_6 (combinational)
* O_at_525_6 (combinational)
* O_af_525_6 (combinational)
* O_at_526_6 (combinational)
* O_af_526_6 (combinational)
* O_at_527_6 (combinational)
* O_af_527_6 (combinational)
* O_at_528_6 (combinational)
* O_af_528_6 (combinational)
* O_at_529_6 (combinational)
* O_af_529_6 (combinational)
* O_at_530_6 (combinational)
* O_af_530_6 (combinational)
* O_at_531_6 (combinational)
* O_af_531_6 (combinational)
*
* --- end node flags ---
*
M0_ Vdd I0_aa #4 Vdd pmos W=0.1625U L=0.065U
M1_ Vdd inv__reset p Vdd pmos W=0.1625U L=0.065U
M2_ Vdd n__s #19 Vdd pmos W=0.1625U L=0.065U
M3_ Vdd O_aa #30 Vdd pmos W=0.1625U L=0.065U
M4_ Vdd s #42 Vdd pmos W=0.1625U L=0.065U
M5_ Vdd inv__reset n__w0 Vdd pmos W=0.1625U L=0.065U
M6_ Vdd n__s #49 Vdd pmos W=0.1625U L=0.065U
M7_ Vdd inv__reset n__w1 Vdd pmos W=0.1625U L=0.065U
M8_ Vdd inv__w0i n__s Vdd pmos W=0.1625U L=0.065U
M9_ Vdd f #57 Vdd pmos W=0.1625U L=0.065U
M10_ Vdd f #62 Vdd pmos W=0.1625U L=0.065U
M11_ Vdd inv__p #68 Vdd pmos W=0.1625U L=0.065U
M12_ Vdd p #69 Vdd pmos W=0.1625U L=0.065U
M13_ Vdd inv__p #74 Vdd pmos W=0.1625U L=0.065U
M14_ Vdd p #75 Vdd pmos W=0.1625U L=0.065U
M15_ Vdd inv__p #82 Vdd pmos W=0.1625U L=0.065U
M16_ Vdd p #83 Vdd pmos W=0.1625U L=0.065U
M17_ Vdd inv__p #90 Vdd pmos W=0.1625U L=0.065U
M18_ Vdd p #91 Vdd pmos W=0.1625U L=0.065U
M19_ Vdd inv__p #98 Vdd pmos W=0.1625U L=0.065U
M20_ Vdd p #99 Vdd pmos W=0.1625U L=0.065U
M21_ Vdd inv__p #106 Vdd pmos W=0.1625U L=0.065U
M22_ Vdd p #107 Vdd pmos W=0.1625U L=0.065U
M23_ Vdd inv__p #114 Vdd pmos W=0.1625U L=0.065U
M24_ Vdd p #115 Vdd pmos W=0.1625U L=0.065U
M25_ Vdd inv__p #122 Vdd pmos W=0.1625U L=0.065U
M26_ Vdd p #123 Vdd pmos W=0.1625U L=0.065U
M27_ Vdd inv__p #130 Vdd pmos W=0.1625U L=0.065U
M28_ Vdd p #131 Vdd pmos W=0.1625U L=0.065U
M29_ Vdd inv__p #138 Vdd pmos W=0.1625U L=0.065U
M30_ Vdd p #139 Vdd pmos W=0.1625U L=0.065U
M31_ Vdd inv__p #146 Vdd pmos W=0.1625U L=0.065U
M32_ Vdd p #147 Vdd pmos W=0.1625U L=0.065U
M33_ Vdd inv__p #154 Vdd pmos W=0.1625U L=0.065U
M34_ Vdd p #155 Vdd pmos W=0.1625U L=0.065U
M35_ Vdd inv__p #162 Vdd pmos W=0.1625U L=0.065U
M36_ Vdd p #163 Vdd pmos W=0.1625U L=0.065U
M37_ Vdd inv__p #170 Vdd pmos W=0.1625U L=0.065U
M38_ Vdd p #171 Vdd pmos W=0.1625U L=0.065U
M39_ Vdd inv__p #178 Vdd pmos W=0.1625U L=0.065U
M40_ Vdd p #179 Vdd pmos W=0.1625U L=0.065U
M41_ Vdd inv__p #186 Vdd pmos W=0.1625U L=0.065U
M42_ Vdd p #187 Vdd pmos W=0.1625U L=0.065U
M43_ Vdd inv__p #194 Vdd pmos W=0.1625U L=0.065U
M44_ Vdd p #195 Vdd pmos W=0.1625U L=0.065U
M45_ Vdd inv__p #202 Vdd pmos W=0.1625U L=0.065U
M46_ Vdd p #203 Vdd pmos W=0.1625U L=0.065U
M47_ Vdd inv__p #210 Vdd pmos W=0.1625U L=0.065U
M48_ Vdd p #211 Vdd pmos W=0.1625U L=0.065U
M49_ Vdd inv__p #218 Vdd pmos W=0.1625U L=0.065U
M50_ Vdd p #219 Vdd pmos W=0.1625U L=0.065U
M51_ Vdd inv__p #226 Vdd pmos W=0.1625U L=0.065U
M52_ Vdd p #227 Vdd pmos W=0.1625U L=0.065U
M53_ Vdd inv__p #234 Vdd pmos W=0.1625U L=0.065U
M54_ Vdd p #235 Vdd pmos W=0.1625U L=0.065U
M55_ Vdd inv__p #242 Vdd pmos W=0.1625U L=0.065U
M56_ Vdd p #243 Vdd pmos W=0.1625U L=0.065U
M57_ Vdd inv__p #250 Vdd pmos W=0.1625U L=0.065U
M58_ Vdd p #251 Vdd pmos W=0.1625U L=0.065U
M59_ Vdd inv__p #258 Vdd pmos W=0.1625U L=0.065U
M60_ Vdd p #259 Vdd pmos W=0.1625U L=0.065U
M61_ Vdd inv__p #266 Vdd pmos W=0.1625U L=0.065U
M62_ Vdd p #267 Vdd pmos W=0.1625U L=0.065U
M63_ Vdd inv__p #274 Vdd pmos W=0.1625U L=0.065U
M64_ Vdd p #275 Vdd pmos W=0.1625U L=0.065U
M65_ Vdd inv__p #282 Vdd pmos W=0.1625U L=0.065U
M66_ Vdd p #283 Vdd pmos W=0.1625U L=0.065U
M67_ Vdd inv__p #290 Vdd pmos W=0.1625U L=0.065U
M68_ Vdd p #291 Vdd pmos W=0.1625U L=0.065U
M69_ Vdd inv__p #298 Vdd pmos W=0.1625U L=0.065U
M70_ Vdd p #299 Vdd pmos W=0.1625U L=0.065U
M71_ Vdd inv__p #306 Vdd pmos W=0.1625U L=0.065U
M72_ Vdd p #307 Vdd pmos W=0.1625U L=0.065U
M73_ Vdd inv__p #314 Vdd pmos W=0.1625U L=0.065U
M74_ Vdd p #315 Vdd pmos W=0.1625U L=0.065U
M75_ Vdd inv__p #322 Vdd pmos W=0.1625U L=0.065U
M76_ Vdd p #323 Vdd pmos W=0.1625U L=0.065U
M77_ Vdd inv__p #330 Vdd pmos W=0.1625U L=0.065U
M78_ Vdd p #331 Vdd pmos W=0.1625U L=0.065U
M79_ Vdd inv__p #338 Vdd pmos W=0.1625U L=0.065U
M80_ Vdd p #339 Vdd pmos W=0.1625U L=0.065U
M81_ Vdd inv__p #346 Vdd pmos W=0.1625U L=0.065U
M82_ Vdd p #347 Vdd pmos W=0.1625U L=0.065U
M83_ Vdd inv__p #354 Vdd pmos W=0.1625U L=0.065U
M84_ Vdd p #355 Vdd pmos W=0.1625U L=0.065U
M85_ Vdd inv__p #362 Vdd pmos W=0.1625U L=0.065U
M86_ Vdd p #363 Vdd pmos W=0.1625U L=0.065U
M87_ Vdd inv__p #370 Vdd pmos W=0.1625U L=0.065U
M88_ Vdd p #371 Vdd pmos W=0.1625U L=0.065U
M89_ Vdd inv__p #378 Vdd pmos W=0.1625U L=0.065U
M90_ Vdd p #379 Vdd pmos W=0.1625U L=0.065U
M91_ Vdd inv__p #386 Vdd pmos W=0.1625U L=0.065U
M92_ Vdd p #387 Vdd pmos W=0.1625U L=0.065U
M93_ Vdd inv__p #394 Vdd pmos W=0.1625U L=0.065U
M94_ Vdd p #395 Vdd pmos W=0.1625U L=0.065U
M95_ Vdd inv__p #402 Vdd pmos W=0.1625U L=0.065U
M96_ Vdd p #403 Vdd pmos W=0.1625U L=0.065U
M97_ Vdd inv__p #410 Vdd pmos W=0.1625U L=0.065U
M98_ Vdd p #411 Vdd pmos W=0.1625U L=0.065U
M99_ Vdd inv__p #418 Vdd pmos W=0.1625U L=0.065U
M100_ Vdd p #419 Vdd pmos W=0.1625U L=0.065U
M101_ Vdd inv__p #426 Vdd pmos W=0.1625U L=0.065U
M102_ Vdd p #427 Vdd pmos W=0.1625U L=0.065U
M103_ Vdd inv__p #434 Vdd pmos W=0.1625U L=0.065U
M104_ Vdd p #435 Vdd pmos W=0.1625U L=0.065U
M105_ Vdd inv__p #442 Vdd pmos W=0.1625U L=0.065U
M106_ Vdd p #443 Vdd pmos W=0.1625U L=0.065U
M107_ Vdd inv__p #450 Vdd pmos W=0.1625U L=0.065U
M108_ Vdd p #451 Vdd pmos W=0.1625U L=0.065U
M109_ Vdd inv__p #458 Vdd pmos W=0.1625U L=0.065U
M110_ Vdd p #459 Vdd pmos W=0.1625U L=0.065U
M111_ Vdd inv__p #466 Vdd pmos W=0.1625U L=0.065U
M112_ Vdd p #467 Vdd pmos W=0.1625U L=0.065U
M113_ Vdd inv__p #474 Vdd pmos W=0.1625U L=0.065U
M114_ Vdd p #475 Vdd pmos W=0.1625U L=0.065U
M115_ Vdd inv__p #482 Vdd pmos W=0.1625U L=0.065U
M116_ Vdd p #483 Vdd pmos W=0.1625U L=0.065U
M117_ Vdd inv__p #490 Vdd pmos W=0.1625U L=0.065U
M118_ Vdd p #491 Vdd pmos W=0.1625U L=0.065U
M119_ Vdd inv__p #498 Vdd pmos W=0.1625U L=0.065U
M120_ Vdd p #499 Vdd pmos W=0.1625U L=0.065U
M121_ Vdd inv__p #506 Vdd pmos W=0.1625U L=0.065U
M122_ Vdd p #507 Vdd pmos W=0.1625U L=0.065U
M123_ Vdd inv__p #514 Vdd pmos W=0.1625U L=0.065U
M124_ Vdd p #515 Vdd pmos W=0.1625U L=0.065U
M125_ Vdd inv__p #522 Vdd pmos W=0.1625U L=0.065U
M126_ Vdd p #523 Vdd pmos W=0.1625U L=0.065U
M127_ Vdd inv__p #530 Vdd pmos W=0.1625U L=0.065U
M128_ Vdd p #531 Vdd pmos W=0.1625U L=0.065U
M129_ Vdd inv__p #538 Vdd pmos W=0.1625U L=0.065U
M130_ Vdd p #539 Vdd pmos W=0.1625U L=0.065U
M131_ Vdd inv__p #546 Vdd pmos W=0.1625U L=0.065U
M132_ Vdd p #547 Vdd pmos W=0.1625U L=0.065U
M133_ Vdd inv__p #554 Vdd pmos W=0.1625U L=0.065U
M134_ Vdd p #555 Vdd pmos W=0.1625U L=0.065U
M135_ Vdd inv__p #562 Vdd pmos W=0.1625U L=0.065U
M136_ Vdd p #563 Vdd pmos W=0.1625U L=0.065U
M137_ Vdd inv__p #570 Vdd pmos W=0.1625U L=0.065U
M138_ Vdd p #571 Vdd pmos W=0.1625U L=0.065U
M139_ Vdd I0_at_531_6 #573 Vdd pmos W=0.1625U L=0.065U
M140_ Vdd n__v n__u Vdd pmos W=0.1625U L=0.065U
M141_ Vdd I1_at_531_6 #575 Vdd pmos W=0.1625U L=0.065U
M142_ Vdd n__u n__v Vdd pmos W=0.1625U L=0.065U
M143_ Vdd p inv__p Vdd pmos W=0.1625U L=0.065U
M144_ Vdd n__s s Vdd pmos W=0.1625U L=0.065U
M145_ Vdd w0i inv__w0i Vdd pmos W=0.1625U L=0.065U
M146_ Vdd n__w0 w0 Vdd pmos W=0.1625U L=0.065U
M147_ Vdd n__w1 w1 Vdd pmos W=0.1625U L=0.065U
M148_ Vdd f inv__f Vdd pmos W=0.1625U L=0.065U
M149_ Vdd reset inv__reset Vdd pmos W=0.1625U L=0.065U
M150_ Vdd n__u u Vdd pmos W=0.1625U L=0.065U
M151_ Vdd n__v v Vdd pmos W=0.1625U L=0.065U
M152_ Vdd n__I0__a I0_aa Vdd pmos W=0.1625U L=0.065U
M153_ Vdd n__I1__a I1_aa Vdd pmos W=0.1625U L=0.065U
M154_ Vdd n__O__t_50_6 O_at_50_6 Vdd pmos W=0.1625U L=0.065U
M155_ Vdd n__O__f_50_6 O_af_50_6 Vdd pmos W=0.1625U L=0.065U
M156_ Vdd n__O__t_51_6 O_at_51_6 Vdd pmos W=0.1625U L=0.065U
M157_ Vdd n__O__f_51_6 O_af_51_6 Vdd pmos W=0.1625U L=0.065U
M158_ Vdd n__O__t_52_6 O_at_52_6 Vdd pmos W=0.1625U L=0.065U
M159_ Vdd n__O__f_52_6 O_af_52_6 Vdd pmos W=0.1625U L=0.065U
M160_ Vdd n__O__t_53_6 O_at_53_6 Vdd pmos W=0.1625U L=0.065U
M161_ Vdd n__O__f_53_6 O_af_53_6 Vdd pmos W=0.1625U L=0.065U
M162_ Vdd n__O__t_54_6 O_at_54_6 Vdd pmos W=0.1625U L=0.065U
M163_ Vdd n__O__f_54_6 O_af_54_6 Vdd pmos W=0.1625U L=0.065U
M164_ Vdd n__O__t_55_6 O_at_55_6 Vdd pmos W=0.1625U L=0.065U
M165_ Vdd n__O__f_55_6 O_af_55_6 Vdd pmos W=0.1625U L=0.065U
M166_ Vdd n__O__t_56_6 O_at_56_6 Vdd pmos W=0.1625U L=0.065U
M167_ Vdd n__O__f_56_6 O_af_56_6 Vdd pmos W=0.1625U L=0.065U
M168_ Vdd n__O__t_57_6 O_at_57_6 Vdd pmos W=0.1625U L=0.065U
M169_ Vdd n__O__f_57_6 O_af_57_6 Vdd pmos W=0.1625U L=0.065U
M170_ Vdd n__O__t_58_6 O_at_58_6 Vdd pmos W=0.1625U L=0.065U
M171_ Vdd n__O__f_58_6 O_af_58_6 Vdd pmos W=0.1625U L=0.065U
M172_ Vdd n__O__t_59_6 O_at_59_6 Vdd pmos W=0.1625U L=0.065U
M173_ Vdd n__O__f_59_6 O_af_59_6 Vdd pmos W=0.1625U L=0.065U
M174_ Vdd n__O__t_510_6 O_at_510_6 Vdd pmos W=0.1625U L=0.065U
M175_ Vdd n__O__f_510_6 O_af_510_6 Vdd pmos W=0.1625U L=0.065U
M176_ Vdd n__O__t_511_6 O_at_511_6 Vdd pmos W=0.1625U L=0.065U
M177_ Vdd n__O__f_511_6 O_af_511_6 Vdd pmos W=0.1625U L=0.065U
M178_ Vdd n__O__t_512_6 O_at_512_6 Vdd pmos W=0.1625U L=0.065U
M179_ Vdd n__O__f_512_6 O_af_512_6 Vdd pmos W=0.1625U L=0.065U
M180_ Vdd n__O__t_513_6 O_at_513_6 Vdd pmos W=0.1625U L=0.065U
M181_ Vdd n__O__f_513_6 O_af_513_6 Vdd pmos W=0.1625U L=0.065U
M182_ Vdd n__O__t_514_6 O_at_514_6 Vdd pmos W=0.1625U L=0.065U
M183_ Vdd n__O__f_514_6 O_af_514_6 Vdd pmos W=0.1625U L=0.065U
M184_ Vdd n__O__t_515_6 O_at_515_6 Vdd pmos W=0.1625U L=0.065U
M185_ Vdd n__O__f_515_6 O_af_515_6 Vdd pmos W=0.1625U L=0.065U
M186_ Vdd n__O__t_516_6 O_at_516_6 Vdd pmos W=0.1625U L=0.065U
M187_ Vdd n__O__f_516_6 O_af_516_6 Vdd pmos W=0.1625U L=0.065U
M188_ Vdd n__O__t_517_6 O_at_517_6 Vdd pmos W=0.1625U L=0.065U
M189_ Vdd n__O__f_517_6 O_af_517_6 Vdd pmos W=0.1625U L=0.065U
M190_ Vdd n__O__t_518_6 O_at_518_6 Vdd pmos W=0.1625U L=0.065U
M191_ Vdd n__O__f_518_6 O_af_518_6 Vdd pmos W=0.1625U L=0.065U
M192_ Vdd n__O__t_519_6 O_at_519_6 Vdd pmos W=0.1625U L=0.065U
M193_ Vdd n__O__f_519_6 O_af_519_6 Vdd pmos W=0.1625U L=0.065U
M194_ Vdd n__O__t_520_6 O_at_520_6 Vdd pmos W=0.1625U L=0.065U
M195_ Vdd n__O__f_520_6 O_af_520_6 Vdd pmos W=0.1625U L=0.065U
M196_ Vdd n__O__t_521_6 O_at_521_6 Vdd pmos W=0.1625U L=0.065U
M197_ Vdd n__O__f_521_6 O_af_521_6 Vdd pmos W=0.1625U L=0.065U
M198_ Vdd n__O__t_522_6 O_at_522_6 Vdd pmos W=0.1625U L=0.065U
M199_ Vdd n__O__f_522_6 O_af_522_6 Vdd pmos W=0.1625U L=0.065U
M200_ Vdd n__O__t_523_6 O_at_523_6 Vdd pmos W=0.1625U L=0.065U
M201_ Vdd n__O__f_523_6 O_af_523_6 Vdd pmos W=0.1625U L=0.065U
M202_ Vdd n__O__t_524_6 O_at_524_6 Vdd pmos W=0.1625U L=0.065U
M203_ Vdd n__O__f_524_6 O_af_524_6 Vdd pmos W=0.1625U L=0.065U
M204_ Vdd n__O__t_525_6 O_at_525_6 Vdd pmos W=0.1625U L=0.065U
M205_ Vdd n__O__f_525_6 O_af_525_6 Vdd pmos W=0.1625U L=0.065U
M206_ Vdd n__O__t_526_6 O_at_526_6 Vdd pmos W=0.1625U L=0.065U
M207_ Vdd n__O__f_526_6 O_af_526_6 Vdd pmos W=0.1625U L=0.065U
M208_ Vdd n__O__t_527_6 O_at_527_6 Vdd pmos W=0.1625U L=0.065U
M209_ Vdd n__O__f_527_6 O_af_527_6 Vdd pmos W=0.1625U L=0.065U
M210_ Vdd n__O__t_528_6 O_at_528_6 Vdd pmos W=0.1625U L=0.065U
M211_ Vdd n__O__f_528_6 O_af_528_6 Vdd pmos W=0.1625U L=0.065U
M212_ Vdd n__O__t_529_6 O_at_529_6 Vdd pmos W=0.1625U L=0.065U
M213_ Vdd n__O__f_529_6 O_af_529_6 Vdd pmos W=0.1625U L=0.065U
M214_ Vdd n__O__t_530_6 O_at_530_6 Vdd pmos W=0.1625U L=0.065U
M215_ Vdd n__O__f_530_6 O_af_530_6 Vdd pmos W=0.1625U L=0.065U
M216_ Vdd n__O__t_531_6 O_at_531_6 Vdd pmos W=0.1625U L=0.065U
M217_ Vdd n__O__f_531_6 O_af_531_6 Vdd pmos W=0.1625U L=0.065U
M218_ Vdd p #fb640# Vdd pmos W=0.1625U L=0.13U
M219_ Vdd n__s #fb643# Vdd pmos W=0.1625U L=0.13U
M220_keeper Vdd GND #641 Vdd pmos W=0.0975U L=1.235U
M221_ Vdd n__I0__a #fb646# Vdd pmos W=0.1625U L=0.13U
M222_keeper Vdd GND #644 Vdd pmos W=0.0975U L=0.585U
M223_ Vdd n__I1__a #fb649# Vdd pmos W=0.1625U L=0.13U
M224_keeper Vdd GND #647 Vdd pmos W=0.0975U L=1.235U
M225_ Vdd w0i #fb652# Vdd pmos W=0.1625U L=0.13U
M226_keeper Vdd GND #650 Vdd pmos W=0.0975U L=1.235U
M227_ Vdd f #fb655# Vdd pmos W=0.1625U L=0.13U
M228_keeper Vdd GND #653 Vdd pmos W=0.0975U L=0.585U
M229_ Vdd n__w0 #fb658# Vdd pmos W=0.1625U L=0.13U
M230_keeper Vdd GND #656 Vdd pmos W=0.0975U L=0.585U
M231_ Vdd n__w1 #fb661# Vdd pmos W=0.1625U L=0.13U
M232_keeper Vdd GND #659 Vdd pmos W=0.0975U L=0.91U
M233_ Vdd n__O__t_50_6 #fb664# Vdd pmos W=0.1625U L=0.13U
M234_keeper Vdd GND #662 Vdd pmos W=0.0975U L=0.91U
M235_ Vdd n__O__f_50_6 #fb667# Vdd pmos W=0.1625U L=0.13U
M236_keeper Vdd GND #665 Vdd pmos W=0.0975U L=0.91U
M237_ Vdd n__O__t_51_6 #fb670# Vdd pmos W=0.1625U L=0.13U
M238_keeper Vdd GND #668 Vdd pmos W=0.0975U L=0.91U
M239_ Vdd n__O__f_51_6 #fb673# Vdd pmos W=0.1625U L=0.13U
M240_keeper Vdd GND #671 Vdd pmos W=0.0975U L=0.91U
M241_ Vdd n__O__t_52_6 #fb676# Vdd pmos W=0.1625U L=0.13U
M242_keeper Vdd GND #674 Vdd pmos W=0.0975U L=0.91U
M243_ Vdd n__O__f_52_6 #fb679# Vdd pmos W=0.1625U L=0.13U
M244_keeper Vdd GND #677 Vdd pmos W=0.0975U L=0.91U
M245_ Vdd n__O__t_53_6 #fb682# Vdd pmos W=0.1625U L=0.13U
M246_keeper Vdd GND #680 Vdd pmos W=0.0975U L=0.91U
M247_ Vdd n__O__f_53_6 #fb685# Vdd pmos W=0.1625U L=0.13U
M248_keeper Vdd GND #683 Vdd pmos W=0.0975U L=0.91U
M249_ Vdd n__O__t_54_6 #fb688# Vdd pmos W=0.1625U L=0.13U
M250_keeper Vdd GND #686 Vdd pmos W=0.0975U L=0.91U
M251_ Vdd n__O__f_54_6 #fb691# Vdd pmos W=0.1625U L=0.13U
M252_keeper Vdd GND #689 Vdd pmos W=0.0975U L=0.91U
M253_ Vdd n__O__t_55_6 #fb694# Vdd pmos W=0.1625U L=0.13U
M254_keeper Vdd GND #692 Vdd pmos W=0.0975U L=0.91U
M255_ Vdd n__O__f_55_6 #fb697# Vdd pmos W=0.1625U L=0.13U
M256_keeper Vdd GND #695 Vdd pmos W=0.0975U L=0.91U
M257_ Vdd n__O__t_56_6 #fb700# Vdd pmos W=0.1625U L=0.13U
M258_keeper Vdd GND #698 Vdd pmos W=0.0975U L=0.91U
M259_ Vdd n__O__f_56_6 #fb703# Vdd pmos W=0.1625U L=0.13U
M260_keeper Vdd GND #701 Vdd pmos W=0.0975U L=0.91U
M261_ Vdd n__O__t_57_6 #fb706# Vdd pmos W=0.1625U L=0.13U
M262_keeper Vdd GND #704 Vdd pmos W=0.0975U L=0.91U
M263_ Vdd n__O__f_57_6 #fb709# Vdd pmos W=0.1625U L=0.13U
M264_keeper Vdd GND #707 Vdd pmos W=0.0975U L=0.91U
M265_ Vdd n__O__t_58_6 #fb712# Vdd pmos W=0.1625U L=0.13U
M266_keeper Vdd GND #710 Vdd pmos W=0.0975U L=0.91U
M267_ Vdd n__O__f_58_6 #fb715# Vdd pmos W=0.1625U L=0.13U
M268_keeper Vdd GND #713 Vdd pmos W=0.0975U L=0.91U
M269_ Vdd n__O__t_59_6 #fb718# Vdd pmos W=0.1625U L=0.13U
M270_keeper Vdd GND #716 Vdd pmos W=0.0975U L=0.91U
M271_ Vdd n__O__f_59_6 #fb721# Vdd pmos W=0.1625U L=0.13U
M272_keeper Vdd GND #719 Vdd pmos W=0.0975U L=0.91U
M273_ Vdd n__O__t_510_6 #fb724# Vdd pmos W=0.1625U L=0.13U
M274_keeper Vdd GND #722 Vdd pmos W=0.0975U L=0.91U
M275_ Vdd n__O__f_510_6 #fb727# Vdd pmos W=0.1625U L=0.13U
M276_keeper Vdd GND #725 Vdd pmos W=0.0975U L=0.91U
M277_ Vdd n__O__t_511_6 #fb730# Vdd pmos W=0.1625U L=0.13U
M278_keeper Vdd GND #728 Vdd pmos W=0.0975U L=0.91U
M279_ Vdd n__O__f_511_6 #fb733# Vdd pmos W=0.1625U L=0.13U
M280_keeper Vdd GND #731 Vdd pmos W=0.0975U L=0.91U
M281_ Vdd n__O__t_512_6 #fb736# Vdd pmos W=0.1625U L=0.13U
M282_keeper Vdd GND #734 Vdd pmos W=0.0975U L=0.91U
M283_ Vdd n__O__f_512_6 #fb739# Vdd pmos W=0.1625U L=0.13U
M284_keeper Vdd GND #737 Vdd pmos W=0.0975U L=0.91U
M285_ Vdd n__O__t_513_6 #fb742# Vdd pmos W=0.1625U L=0.13U
M286_keeper Vdd GND #740 Vdd pmos W=0.0975U L=0.91U
M287_ Vdd n__O__f_513_6 #fb745# Vdd pmos W=0.1625U L=0.13U
M288_keeper Vdd GND #743 Vdd pmos W=0.0975U L=0.91U
M289_ Vdd n__O__t_514_6 #fb748# Vdd pmos W=0.1625U L=0.13U
M290_keeper Vdd GND #746 Vdd pmos W=0.0975U L=0.91U
M291_ Vdd n__O__f_514_6 #fb751# Vdd pmos W=0.1625U L=0.13U
M292_keeper Vdd GND #749 Vdd pmos W=0.0975U L=0.91U
M293_ Vdd n__O__t_515_6 #fb754# Vdd pmos W=0.1625U L=0.13U
M294_keeper Vdd GND #752 Vdd pmos W=0.0975U L=0.91U
M295_ Vdd n__O__f_515_6 #fb757# Vdd pmos W=0.1625U L=0.13U
M296_keeper Vdd GND #755 Vdd pmos W=0.0975U L=0.91U
M297_ Vdd n__O__t_516_6 #fb760# Vdd pmos W=0.1625U L=0.13U
M298_keeper Vdd GND #758 Vdd pmos W=0.0975U L=0.91U
M299_ Vdd n__O__f_516_6 #fb763# Vdd pmos W=0.1625U L=0.13U
M300_keeper Vdd GND #761 Vdd pmos W=0.0975U L=0.91U
M301_ Vdd n__O__t_517_6 #fb766# Vdd pmos W=0.1625U L=0.13U
M302_keeper Vdd GND #764 Vdd pmos W=0.0975U L=0.91U
M303_ Vdd n__O__f_517_6 #fb769# Vdd pmos W=0.1625U L=0.13U
M304_keeper Vdd GND #767 Vdd pmos W=0.0975U L=0.91U
M305_ Vdd n__O__t_518_6 #fb772# Vdd pmos W=0.1625U L=0.13U
M306_keeper Vdd GND #770 Vdd pmos W=0.0975U L=0.91U
M307_ Vdd n__O__f_518_6 #fb775# Vdd pmos W=0.1625U L=0.13U
M308_keeper Vdd GND #773 Vdd pmos W=0.0975U L=0.91U
M309_ Vdd n__O__t_519_6 #fb778# Vdd pmos W=0.1625U L=0.13U
M310_keeper Vdd GND #776 Vdd pmos W=0.0975U L=0.91U
M311_ Vdd n__O__f_519_6 #fb781# Vdd pmos W=0.1625U L=0.13U
M312_keeper Vdd GND #779 Vdd pmos W=0.0975U L=0.91U
M313_ Vdd n__O__t_520_6 #fb784# Vdd pmos W=0.1625U L=0.13U
M314_keeper Vdd GND #782 Vdd pmos W=0.0975U L=0.91U
M315_ Vdd n__O__f_520_6 #fb787# Vdd pmos W=0.1625U L=0.13U
M316_keeper Vdd GND #785 Vdd pmos W=0.0975U L=0.91U
M317_ Vdd n__O__t_521_6 #fb790# Vdd pmos W=0.1625U L=0.13U
M318_keeper Vdd GND #788 Vdd pmos W=0.0975U L=0.91U
M319_ Vdd n__O__f_521_6 #fb793# Vdd pmos W=0.1625U L=0.13U
M320_keeper Vdd GND #791 Vdd pmos W=0.0975U L=0.91U
M321_ Vdd n__O__t_522_6 #fb796# Vdd pmos W=0.1625U L=0.13U
M322_keeper Vdd GND #794 Vdd pmos W=0.0975U L=0.91U
M323_ Vdd n__O__f_522_6 #fb799# Vdd pmos W=0.1625U L=0.13U
M324_keeper Vdd GND #797 Vdd pmos W=0.0975U L=0.91U
M325_ Vdd n__O__t_523_6 #fb802# Vdd pmos W=0.1625U L=0.13U
M326_keeper Vdd GND #800 Vdd pmos W=0.0975U L=0.91U
M327_ Vdd n__O__f_523_6 #fb805# Vdd pmos W=0.1625U L=0.13U
M328_keeper Vdd GND #803 Vdd pmos W=0.0975U L=0.91U
M329_ Vdd n__O__t_524_6 #fb808# Vdd pmos W=0.1625U L=0.13U
M330_keeper Vdd GND #806 Vdd pmos W=0.0975U L=0.91U
M331_ Vdd n__O__f_524_6 #fb811# Vdd pmos W=0.1625U L=0.13U
M332_keeper Vdd GND #809 Vdd pmos W=0.0975U L=0.91U
M333_ Vdd n__O__t_525_6 #fb814# Vdd pmos W=0.1625U L=0.13U
M334_keeper Vdd GND #812 Vdd pmos W=0.0975U L=0.91U
M335_ Vdd n__O__f_525_6 #fb817# Vdd pmos W=0.1625U L=0.13U
M336_keeper Vdd GND #815 Vdd pmos W=0.0975U L=0.91U
M337_ Vdd n__O__t_526_6 #fb820# Vdd pmos W=0.1625U L=0.13U
M338_keeper Vdd GND #818 Vdd pmos W=0.0975U L=0.91U
M339_ Vdd n__O__f_526_6 #fb823# Vdd pmos W=0.1625U L=0.13U
M340_keeper Vdd GND #821 Vdd pmos W=0.0975U L=0.91U
M341_ Vdd n__O__t_527_6 #fb826# Vdd pmos W=0.1625U L=0.13U
M342_keeper Vdd GND #824 Vdd pmos W=0.0975U L=0.91U
M343_ Vdd n__O__f_527_6 #fb829# Vdd pmos W=0.1625U L=0.13U
M344_keeper Vdd GND #827 Vdd pmos W=0.0975U L=0.91U
M345_ Vdd n__O__t_528_6 #fb832# Vdd pmos W=0.1625U L=0.13U
M346_keeper Vdd GND #830 Vdd pmos W=0.0975U L=0.91U
M347_ Vdd n__O__f_528_6 #fb835# Vdd pmos W=0.1625U L=0.13U
M348_keeper Vdd GND #833 Vdd pmos W=0.0975U L=0.91U
M349_ Vdd n__O__t_529_6 #fb838# Vdd pmos W=0.1625U L=0.13U
M350_keeper Vdd GND #836 Vdd pmos W=0.0975U L=0.91U
M351_ Vdd n__O__f_529_6 #fb841# Vdd pmos W=0.1625U L=0.13U
M352_keeper Vdd GND #839 Vdd pmos W=0.0975U L=0.91U
M353_ Vdd n__O__t_530_6 #fb844# Vdd pmos W=0.1625U L=0.13U
M354_keeper Vdd GND #842 Vdd pmos W=0.0975U L=0.91U
M355_ Vdd n__O__f_530_6 #fb847# Vdd pmos W=0.1625U L=0.13U
M356_keeper Vdd GND #845 Vdd pmos W=0.0975U L=0.91U
M357_ Vdd n__O__t_531_6 #fb850# Vdd pmos W=0.1625U L=0.13U
M358_keeper Vdd GND #848 Vdd pmos W=0.0975U L=0.91U
M359_ Vdd n__O__f_531_6 #fb853# Vdd pmos W=0.1625U L=0.13U
M360_keeper Vdd GND #851 Vdd pmos W=0.0975U L=0.91U
M361_keeper Vdd GND #854 Vdd pmos W=0.0975U L=0.91U
M362_ GND n__I0__a #12 GND nmos W=0.0975U L=0.065U
M363_ GND n__s #24 GND nmos W=0.0975U L=0.065U
M364_ GND reset w0i GND nmos W=0.0975U L=0.065U
M365_ GND n__w0 #36 GND nmos W=0.0975U L=0.065U
M366_ GND reset f GND nmos W=0.0975U L=0.065U
M367_ GND n__s #37 GND nmos W=0.0975U L=0.065U
M368_ GND n__s #44 GND nmos W=0.0975U L=0.065U
M369_ GND w1 #50 GND nmos W=0.0975U L=0.065U
M370_ GND reset n__s GND nmos W=0.0975U L=0.065U
M371_ GND p #55 GND nmos W=0.0975U L=0.065U
M372_ GND inv__p #61 GND nmos W=0.0975U L=0.065U
M373_ GND n__s #65 GND nmos W=0.0975U L=0.065U
M374_ GND n__s #71 GND nmos W=0.0975U L=0.065U
M375_ GND n__s #77 GND nmos W=0.0975U L=0.065U
M376_ GND n__s #85 GND nmos W=0.0975U L=0.065U
M377_ GND n__s #93 GND nmos W=0.0975U L=0.065U
M378_ GND n__s #101 GND nmos W=0.0975U L=0.065U
M379_ GND n__s #109 GND nmos W=0.0975U L=0.065U
M380_ GND n__s #117 GND nmos W=0.0975U L=0.065U
M381_ GND n__s #125 GND nmos W=0.0975U L=0.065U
M382_ GND n__s #133 GND nmos W=0.0975U L=0.065U
M383_ GND n__s #141 GND nmos W=0.0975U L=0.065U
M384_ GND n__s #149 GND nmos W=0.0975U L=0.065U
M385_ GND n__s #157 GND nmos W=0.0975U L=0.065U
M386_ GND n__s #165 GND nmos W=0.0975U L=0.065U
M387_ GND n__s #173 GND nmos W=0.0975U L=0.065U
M388_ GND n__s #181 GND nmos W=0.0975U L=0.065U
M389_ GND n__s #189 GND nmos W=0.0975U L=0.065U
M390_ GND n__s #197 GND nmos W=0.0975U L=0.065U
M391_ GND n__s #205 GND nmos W=0.0975U L=0.065U
M392_ GND n__s #213 GND nmos W=0.0975U L=0.065U
M393_ GND n__s #221 GND nmos W=0.0975U L=0.065U
M394_ GND n__s #229 GND nmos W=0.0975U L=0.065U
M395_ GND n__s #237 GND nmos W=0.0975U L=0.065U
M396_ GND n__s #245 GND nmos W=0.0975U L=0.065U
M397_ GND n__s #253 GND nmos W=0.0975U L=0.065U
M398_ GND n__s #261 GND nmos W=0.0975U L=0.065U
M399_ GND n__s #269 GND nmos W=0.0975U L=0.065U
M400_ GND n__s #277 GND nmos W=0.0975U L=0.065U
M401_ GND n__s #285 GND nmos W=0.0975U L=0.065U
M402_ GND n__s #293 GND nmos W=0.0975U L=0.065U
M403_ GND n__s #301 GND nmos W=0.0975U L=0.065U
M404_ GND n__s #309 GND nmos W=0.0975U L=0.065U
M405_ GND n__s #317 GND nmos W=0.0975U L=0.065U
M406_ GND n__s #325 GND nmos W=0.0975U L=0.065U
M407_ GND n__s #333 GND nmos W=0.0975U L=0.065U
M408_ GND n__s #341 GND nmos W=0.0975U L=0.065U
M409_ GND n__s #349 GND nmos W=0.0975U L=0.065U
M410_ GND n__s #357 GND nmos W=0.0975U L=0.065U
M411_ GND n__s #365 GND nmos W=0.0975U L=0.065U
M412_ GND n__s #373 GND nmos W=0.0975U L=0.065U
M413_ GND n__s #381 GND nmos W=0.0975U L=0.065U
M414_ GND n__s #389 GND nmos W=0.0975U L=0.065U
M415_ GND n__s #397 GND nmos W=0.0975U L=0.065U
M416_ GND n__s #405 GND nmos W=0.0975U L=0.065U
M417_ GND n__s #413 GND nmos W=0.0975U L=0.065U
M418_ GND n__s #421 GND nmos W=0.0975U L=0.065U
M419_ GND n__s #429 GND nmos W=0.0975U L=0.065U
M420_ GND n__s #437 GND nmos W=0.0975U L=0.065U
M421_ GND n__s #445 GND nmos W=0.0975U L=0.065U
M422_ GND n__s #453 GND nmos W=0.0975U L=0.065U
M423_ GND n__s #461 GND nmos W=0.0975U L=0.065U
M424_ GND n__s #469 GND nmos W=0.0975U L=0.065U
M425_ GND n__s #477 GND nmos W=0.0975U L=0.065U
M426_ GND n__s #485 GND nmos W=0.0975U L=0.065U
M427_ GND n__s #493 GND nmos W=0.0975U L=0.065U
M428_ GND n__s #501 GND nmos W=0.0975U L=0.065U
M429_ GND n__s #509 GND nmos W=0.0975U L=0.065U
M430_ GND n__s #517 GND nmos W=0.0975U L=0.065U
M431_ GND n__s #525 GND nmos W=0.0975U L=0.065U
M432_ GND n__s #533 GND nmos W=0.0975U L=0.065U
M433_ GND n__s #541 GND nmos W=0.0975U L=0.065U
M434_ GND n__s #549 GND nmos W=0.0975U L=0.065U
M435_ GND n__s #557 GND nmos W=0.0975U L=0.065U
M436_ GND n__s #565 GND nmos W=0.0975U L=0.065U
M437_ GND I0_at_531_6 #572 GND nmos W=0.0975U L=0.065U
M438_ GND I0_af_531_6 #572 GND nmos W=0.0975U L=0.065U
M439_ GND I1_at_531_6 #574 GND nmos W=0.0975U L=0.065U
M440_ GND I1_af_531_6 #574 GND nmos W=0.0975U L=0.065U
M441_ GND p inv__p GND nmos W=0.0975U L=0.065U
M442_ GND n__s s GND nmos W=0.0975U L=0.065U
M443_ GND w0i inv__w0i GND nmos W=0.0975U L=0.065U
M444_ GND n__w0 w0 GND nmos W=0.0975U L=0.065U
M445_ GND n__w1 w1 GND nmos W=0.0975U L=0.065U
M446_ GND f inv__f GND nmos W=0.0975U L=0.065U
M447_ GND reset inv__reset GND nmos W=0.0975U L=0.065U
M448_ GND n__u u GND nmos W=0.0975U L=0.065U
M449_ GND n__v v GND nmos W=0.0975U L=0.065U
M450_ GND n__I0__a I0_aa GND nmos W=0.0975U L=0.065U
M451_ GND n__I1__a I1_aa GND nmos W=0.0975U L=0.065U
M452_ GND n__O__t_50_6 O_at_50_6 GND nmos W=0.0975U L=0.065U
M453_ GND n__O__f_50_6 O_af_50_6 GND nmos W=0.0975U L=0.065U
M454_ GND n__O__t_51_6 O_at_51_6 GND nmos W=0.0975U L=0.065U
M455_ GND n__O__f_51_6 O_af_51_6 GND nmos W=0.0975U L=0.065U
M456_ GND n__O__t_52_6 O_at_52_6 GND nmos W=0.0975U L=0.065U
M457_ GND n__O__f_52_6 O_af_52_6 GND nmos W=0.0975U L=0.065U
M458_ GND n__O__t_53_6 O_at_53_6 GND nmos W=0.0975U L=0.065U
M459_ GND n__O__f_53_6 O_af_53_6 GND nmos W=0.0975U L=0.065U
M460_ GND n__O__t_54_6 O_at_54_6 GND nmos W=0.0975U L=0.065U
M461_ GND n__O__f_54_6 O_af_54_6 GND nmos W=0.0975U L=0.065U
M462_ GND n__O__t_55_6 O_at_55_6 GND nmos W=0.0975U L=0.065U
M463_ GND n__O__f_55_6 O_af_55_6 GND nmos W=0.0975U L=0.065U
M464_ GND n__O__t_56_6 O_at_56_6 GND nmos W=0.0975U L=0.065U
M465_ GND n__O__f_56_6 O_af_56_6 GND nmos W=0.0975U L=0.065U
M466_ GND n__O__t_57_6 O_at_57_6 GND nmos W=0.0975U L=0.065U
M467_ GND n__O__f_57_6 O_af_57_6 GND nmos W=0.0975U L=0.065U
M468_ GND n__O__t_58_6 O_at_58_6 GND nmos W=0.0975U L=0.065U
M469_ GND n__O__f_58_6 O_af_58_6 GND nmos W=0.0975U L=0.065U
M470_ GND n__O__t_59_6 O_at_59_6 GND nmos W=0.0975U L=0.065U
M471_ GND n__O__f_59_6 O_af_59_6 GND nmos W=0.0975U L=0.065U
M472_ GND n__O__t_510_6 O_at_510_6 GND nmos W=0.0975U L=0.065U
M473_ GND n__O__f_510_6 O_af_510_6 GND nmos W=0.0975U L=0.065U
M474_ GND n__O__t_511_6 O_at_511_6 GND nmos W=0.0975U L=0.065U
M475_ GND n__O__f_511_6 O_af_511_6 GND nmos W=0.0975U L=0.065U
M476_ GND n__O__t_512_6 O_at_512_6 GND nmos W=0.0975U L=0.065U
M477_ GND n__O__f_512_6 O_af_512_6 GND nmos W=0.0975U L=0.065U
M478_ GND n__O__t_513_6 O_at_513_6 GND nmos W=0.0975U L=0.065U
M479_ GND n__O__f_513_6 O_af_513_6 GND nmos W=0.0975U L=0.065U
M480_ GND n__O__t_514_6 O_at_514_6 GND nmos W=0.0975U L=0.065U
M481_ GND n__O__f_514_6 O_af_514_6 GND nmos W=0.0975U L=0.065U
M482_ GND n__O__t_515_6 O_at_515_6 GND nmos W=0.0975U L=0.065U
M483_ GND n__O__f_515_6 O_af_515_6 GND nmos W=0.0975U L=0.065U
M484_ GND n__O__t_516_6 O_at_516_6 GND nmos W=0.0975U L=0.065U
M485_ GND n__O__f_516_6 O_af_516_6 GND nmos W=0.0975U L=0.065U
M486_ GND n__O__t_517_6 O_at_517_6 GND nmos W=0.0975U L=0.065U
M487_ GND n__O__f_517_6 O_af_517_6 GND nmos W=0.0975U L=0.065U
M488_ GND n__O__t_518_6 O_at_518_6 GND nmos W=0.0975U L=0.065U
M489_ GND n__O__f_518_6 O_af_518_6 GND nmos W=0.0975U L=0.065U
M490_ GND n__O__t_519_6 O_at_519_6 GND nmos W=0.0975U L=0.065U
M491_ GND n__O__f_519_6 O_af_519_6 GND nmos W=0.0975U L=0.065U
M492_ GND n__O__t_520_6 O_at_520_6 GND nmos W=0.0975U L=0.065U
M493_ GND n__O__f_520_6 O_af_520_6 GND nmos W=0.0975U L=0.065U
M494_ GND n__O__t_521_6 O_at_521_6 GND nmos W=0.0975U L=0.065U
M495_ GND n__O__f_521_6 O_af_521_6 GND nmos W=0.0975U L=0.065U
M496_ GND n__O__t_522_6 O_at_522_6 GND nmos W=0.0975U L=0.065U
M497_ GND n__O__f_522_6 O_af_522_6 GND nmos W=0.0975U L=0.065U
M498_ GND n__O__t_523_6 O_at_523_6 GND nmos W=0.0975U L=0.065U
M499_ GND n__O__f_523_6 O_af_523_6 GND nmos W=0.0975U L=0.065U
M500_ GND n__O__t_524_6 O_at_524_6 GND nmos W=0.0975U L=0.065U
M501_ GND n__O__f_524_6 O_af_524_6 GND nmos W=0.0975U L=0.065U
M502_ GND n__O__t_525_6 O_at_525_6 GND nmos W=0.0975U L=0.065U
M503_ GND n__O__f_525_6 O_af_525_6 GND nmos W=0.0975U L=0.065U
M504_ GND n__O__t_526_6 O_at_526_6 GND nmos W=0.0975U L=0.065U
M505_ GND n__O__f_526_6 O_af_526_6 GND nmos W=0.0975U L=0.065U
M506_ GND n__O__t_527_6 O_at_527_6 GND nmos W=0.0975U L=0.065U
M507_ GND n__O__f_527_6 O_af_527_6 GND nmos W=0.0975U L=0.065U
M508_ GND n__O__t_528_6 O_at_528_6 GND nmos W=0.0975U L=0.065U
M509_ GND n__O__f_528_6 O_af_528_6 GND nmos W=0.0975U L=0.065U
M510_ GND n__O__t_529_6 O_at_529_6 GND nmos W=0.0975U L=0.065U
M511_ GND n__O__f_529_6 O_af_529_6 GND nmos W=0.0975U L=0.065U
M512_ GND n__O__t_530_6 O_at_530_6 GND nmos W=0.0975U L=0.065U
M513_ GND n__O__f_530_6 O_af_530_6 GND nmos W=0.0975U L=0.065U
M514_ GND n__O__t_531_6 O_at_531_6 GND nmos W=0.0975U L=0.065U
M515_ GND n__O__f_531_6 O_af_531_6 GND nmos W=0.0975U L=0.065U
M516_ GND p #fb640# GND nmos W=0.0975U L=0.13U
M517_ GND n__s #fb643# GND nmos W=0.0975U L=0.13U
M518_keeper GND Vdd #642 GND nmos W=0.0975U L=3.055U
M519_ GND n__I0__a #fb646# GND nmos W=0.0975U L=0.13U
M520_keeper GND Vdd #645 GND nmos W=0.0975U L=0.715U
M521_ GND n__I1__a #fb649# GND nmos W=0.0975U L=0.13U
M522_keeper GND Vdd #648 GND nmos W=0.0975U L=2.275U
M523_ GND w0i #fb652# GND nmos W=0.0975U L=0.13U
M524_keeper GND Vdd #651 GND nmos W=0.0975U L=2.275U
M525_ GND f #fb655# GND nmos W=0.0975U L=0.13U
M526_keeper GND Vdd #654 GND nmos W=0.0975U L=2.275U
M527_ GND n__w0 #fb658# GND nmos W=0.0975U L=0.13U
M528_keeper GND Vdd #657 GND nmos W=0.0975U L=3.835U
M529_ GND n__w1 #fb661# GND nmos W=0.0975U L=0.13U
M530_keeper GND Vdd #660 GND nmos W=0.0975U L=1.495U
M531_ GND n__O__t_50_6 #fb664# GND nmos W=0.0975U L=0.13U
M532_keeper GND Vdd #663 GND nmos W=0.0975U L=1.495U
M533_ GND n__O__f_50_6 #fb667# GND nmos W=0.0975U L=0.13U
M534_keeper GND Vdd #666 GND nmos W=0.0975U L=1.495U
M535_ GND n__O__t_51_6 #fb670# GND nmos W=0.0975U L=0.13U
M536_keeper GND Vdd #669 GND nmos W=0.0975U L=1.495U
M537_ GND n__O__f_51_6 #fb673# GND nmos W=0.0975U L=0.13U
M538_keeper GND Vdd #672 GND nmos W=0.0975U L=1.495U
M539_ GND n__O__t_52_6 #fb676# GND nmos W=0.0975U L=0.13U
M540_keeper GND Vdd #675 GND nmos W=0.0975U L=1.495U
M541_ GND n__O__f_52_6 #fb679# GND nmos W=0.0975U L=0.13U
M542_keeper GND Vdd #678 GND nmos W=0.0975U L=1.495U
M543_ GND n__O__t_53_6 #fb682# GND nmos W=0.0975U L=0.13U
M544_keeper GND Vdd #681 GND nmos W=0.0975U L=1.495U
M545_ GND n__O__f_53_6 #fb685# GND nmos W=0.0975U L=0.13U
M546_keeper GND Vdd #684 GND nmos W=0.0975U L=1.495U
M547_ GND n__O__t_54_6 #fb688# GND nmos W=0.0975U L=0.13U
M548_keeper GND Vdd #687 GND nmos W=0.0975U L=1.495U
M549_ GND n__O__f_54_6 #fb691# GND nmos W=0.0975U L=0.13U
M550_keeper GND Vdd #690 GND nmos W=0.0975U L=1.495U
M551_ GND n__O__t_55_6 #fb694# GND nmos W=0.0975U L=0.13U
M552_keeper GND Vdd #693 GND nmos W=0.0975U L=1.495U
M553_ GND n__O__f_55_6 #fb697# GND nmos W=0.0975U L=0.13U
M554_keeper GND Vdd #696 GND nmos W=0.0975U L=1.495U
M555_ GND n__O__t_56_6 #fb700# GND nmos W=0.0975U L=0.13U
M556_keeper GND Vdd #699 GND nmos W=0.0975U L=1.495U
M557_ GND n__O__f_56_6 #fb703# GND nmos W=0.0975U L=0.13U
M558_keeper GND Vdd #702 GND nmos W=0.0975U L=1.495U
M559_ GND n__O__t_57_6 #fb706# GND nmos W=0.0975U L=0.13U
M560_keeper GND Vdd #705 GND nmos W=0.0975U L=1.495U
M561_ GND n__O__f_57_6 #fb709# GND nmos W=0.0975U L=0.13U
M562_keeper GND Vdd #708 GND nmos W=0.0975U L=1.495U
M563_ GND n__O__t_58_6 #fb712# GND nmos W=0.0975U L=0.13U
M564_keeper GND Vdd #711 GND nmos W=0.0975U L=1.495U
M565_ GND n__O__f_58_6 #fb715# GND nmos W=0.0975U L=0.13U
M566_keeper GND Vdd #714 GND nmos W=0.0975U L=1.495U
M567_ GND n__O__t_59_6 #fb718# GND nmos W=0.0975U L=0.13U
M568_keeper GND Vdd #717 GND nmos W=0.0975U L=1.495U
M569_ GND n__O__f_59_6 #fb721# GND nmos W=0.0975U L=0.13U
M570_keeper GND Vdd #720 GND nmos W=0.0975U L=1.495U
M571_ GND n__O__t_510_6 #fb724# GND nmos W=0.0975U L=0.13U
M572_keeper GND Vdd #723 GND nmos W=0.0975U L=1.495U
M573_ GND n__O__f_510_6 #fb727# GND nmos W=0.0975U L=0.13U
M574_keeper GND Vdd #726 GND nmos W=0.0975U L=1.495U
M575_ GND n__O__t_511_6 #fb730# GND nmos W=0.0975U L=0.13U
M576_keeper GND Vdd #729 GND nmos W=0.0975U L=1.495U
M577_ GND n__O__f_511_6 #fb733# GND nmos W=0.0975U L=0.13U
M578_keeper GND Vdd #732 GND nmos W=0.0975U L=1.495U
M579_ GND n__O__t_512_6 #fb736# GND nmos W=0.0975U L=0.13U
M580_keeper GND Vdd #735 GND nmos W=0.0975U L=1.495U
M581_ GND n__O__f_512_6 #fb739# GND nmos W=0.0975U L=0.13U
M582_keeper GND Vdd #738 GND nmos W=0.0975U L=1.495U
M583_ GND n__O__t_513_6 #fb742# GND nmos W=0.0975U L=0.13U
M584_keeper GND Vdd #741 GND nmos W=0.0975U L=1.495U
M585_ GND n__O__f_513_6 #fb745# GND nmos W=0.0975U L=0.13U
M586_keeper GND Vdd #744 GND nmos W=0.0975U L=1.495U
M587_ GND n__O__t_514_6 #fb748# GND nmos W=0.0975U L=0.13U
M588_keeper GND Vdd #747 GND nmos W=0.0975U L=1.495U
M589_ GND n__O__f_514_6 #fb751# GND nmos W=0.0975U L=0.13U
M590_keeper GND Vdd #750 GND nmos W=0.0975U L=1.495U
M591_ GND n__O__t_515_6 #fb754# GND nmos W=0.0975U L=0.13U
M592_keeper GND Vdd #753 GND nmos W=0.0975U L=1.495U
M593_ GND n__O__f_515_6 #fb757# GND nmos W=0.0975U L=0.13U
M594_keeper GND Vdd #756 GND nmos W=0.0975U L=1.495U
M595_ GND n__O__t_516_6 #fb760# GND nmos W=0.0975U L=0.13U
M596_keeper GND Vdd #759 GND nmos W=0.0975U L=1.495U
M597_ GND n__O__f_516_6 #fb763# GND nmos W=0.0975U L=0.13U
M598_keeper GND Vdd #762 GND nmos W=0.0975U L=1.495U
M599_ GND n__O__t_517_6 #fb766# GND nmos W=0.0975U L=0.13U
M600_keeper GND Vdd #765 GND nmos W=0.0975U L=1.495U
M601_ GND n__O__f_517_6 #fb769# GND nmos W=0.0975U L=0.13U
M602_keeper GND Vdd #768 GND nmos W=0.0975U L=1.495U
M603_ GND n__O__t_518_6 #fb772# GND nmos W=0.0975U L=0.13U
M604_keeper GND Vdd #771 GND nmos W=0.0975U L=1.495U
M605_ GND n__O__f_518_6 #fb775# GND nmos W=0.0975U L=0.13U
M606_keeper GND Vdd #774 GND nmos W=0.0975U L=1.495U
M607_ GND n__O__t_519_6 #fb778# GND nmos W=0.0975U L=0.13U
M608_keeper GND Vdd #777 GND nmos W=0.0975U L=1.495U
M609_ GND n__O__f_519_6 #fb781# GND nmos W=0.0975U L=0.13U
M610_keeper GND Vdd #780 GND nmos W=0.0975U L=1.495U
M611_ GND n__O__t_520_6 #fb784# GND nmos W=0.0975U L=0.13U
M612_keeper GND Vdd #783 GND nmos W=0.0975U L=1.495U
M613_ GND n__O__f_520_6 #fb787# GND nmos W=0.0975U L=0.13U
M614_keeper GND Vdd #786 GND nmos W=0.0975U L=1.495U
M615_ GND n__O__t_521_6 #fb790# GND nmos W=0.0975U L=0.13U
M616_keeper GND Vdd #789 GND nmos W=0.0975U L=1.495U
M617_ GND n__O__f_521_6 #fb793# GND nmos W=0.0975U L=0.13U
M618_keeper GND Vdd #792 GND nmos W=0.0975U L=1.495U
M619_ GND n__O__t_522_6 #fb796# GND nmos W=0.0975U L=0.13U
M620_keeper GND Vdd #795 GND nmos W=0.0975U L=1.495U
M621_ GND n__O__f_522_6 #fb799# GND nmos W=0.0975U L=0.13U
M622_keeper GND Vdd #798 GND nmos W=0.0975U L=1.495U
M623_ GND n__O__t_523_6 #fb802# GND nmos W=0.0975U L=0.13U
M624_keeper GND Vdd #801 GND nmos W=0.0975U L=1.495U
M625_ GND n__O__f_523_6 #fb805# GND nmos W=0.0975U L=0.13U
M626_keeper GND Vdd #804 GND nmos W=0.0975U L=1.495U
M627_ GND n__O__t_524_6 #fb808# GND nmos W=0.0975U L=0.13U
M628_keeper GND Vdd #807 GND nmos W=0.0975U L=1.495U
M629_ GND n__O__f_524_6 #fb811# GND nmos W=0.0975U L=0.13U
M630_keeper GND Vdd #810 GND nmos W=0.0975U L=1.495U
M631_ GND n__O__t_525_6 #fb814# GND nmos W=0.0975U L=0.13U
M632_keeper GND Vdd #813 GND nmos W=0.0975U L=1.495U
M633_ GND n__O__f_525_6 #fb817# GND nmos W=0.0975U L=0.13U
M634_keeper GND Vdd #816 GND nmos W=0.0975U L=1.495U
M635_ GND n__O__t_526_6 #fb820# GND nmos W=0.0975U L=0.13U
M636_keeper GND Vdd #819 GND nmos W=0.0975U L=1.495U
M637_ GND n__O__f_526_6 #fb823# GND nmos W=0.0975U L=0.13U
M638_keeper GND Vdd #822 GND nmos W=0.0975U L=1.495U
M639_ GND n__O__t_527_6 #fb826# GND nmos W=0.0975U L=0.13U
M640_keeper GND Vdd #825 GND nmos W=0.0975U L=1.495U
M641_ GND n__O__f_527_6 #fb829# GND nmos W=0.0975U L=0.13U
M642_keeper GND Vdd #828 GND nmos W=0.0975U L=1.495U
M643_ GND n__O__t_528_6 #fb832# GND nmos W=0.0975U L=0.13U
M644_keeper GND Vdd #831 GND nmos W=0.0975U L=1.495U
M645_ GND n__O__f_528_6 #fb835# GND nmos W=0.0975U L=0.13U
M646_keeper GND Vdd #834 GND nmos W=0.0975U L=1.495U
M647_ GND n__O__t_529_6 #fb838# GND nmos W=0.0975U L=0.13U
M648_keeper GND Vdd #837 GND nmos W=0.0975U L=1.495U
M649_ GND n__O__f_529_6 #fb841# GND nmos W=0.0975U L=0.13U
M650_keeper GND Vdd #840 GND nmos W=0.0975U L=1.495U
M651_ GND n__O__t_530_6 #fb844# GND nmos W=0.0975U L=0.13U
M652_keeper GND Vdd #843 GND nmos W=0.0975U L=1.495U
M653_ GND n__O__f_530_6 #fb847# GND nmos W=0.0975U L=0.13U
M654_keeper GND Vdd #846 GND nmos W=0.0975U L=1.495U
M655_ GND n__O__t_531_6 #fb850# GND nmos W=0.0975U L=0.13U
M656_keeper GND Vdd #849 GND nmos W=0.0975U L=1.495U
M657_ GND n__O__f_531_6 #fb853# GND nmos W=0.0975U L=0.13U
M658_keeper GND Vdd #852 GND nmos W=0.0975U L=1.495U
M659_keeper GND Vdd #855 GND nmos W=0.0975U L=1.495U
M660_ #7 n__s p Vdd pmos W=0.1625U L=0.065U
M661_ #15 s p GND nmos W=0.0975U L=0.065U
M662_keeper #641 #fb640# p Vdd pmos W=0.0975U L=0.065U
M663_keeper #642 #fb640# p GND nmos W=0.0975U L=0.065U
M664_ #4 I1_aa #3 Vdd pmos W=0.1625U L=0.065U
M665_ #3 n__u #7 Vdd pmos W=0.1625U L=0.065U
M666_ #572 n__v n__u GND nmos W=0.0975U L=0.065U
M667_ #573 I0_af_531_6 n__u Vdd pmos W=0.1625U L=0.065U
M668_ #50 f n__s GND nmos W=0.0975U L=0.065U
M669_keeper #644 #fb643# n__s Vdd pmos W=0.0975U L=0.065U
M670_keeper #645 #fb643# n__s GND nmos W=0.0975U L=0.065U
M671_ #12 n__I1__a #11 GND nmos W=0.0975U L=0.065U
M672_ #11 v #15 GND nmos W=0.0975U L=0.065U
M673_ #53 inv__w0i n__I0__a GND nmos W=0.0975U L=0.065U
M674_ #58 w1 n__I0__a Vdd pmos W=0.1625U L=0.065U
M675_keeper #647 #fb646# n__I0__a Vdd pmos W=0.0975U L=0.065U
M676_keeper #648 #fb646# n__I0__a GND nmos W=0.0975U L=0.065U
M677_ #59 inv__w0i n__I1__a GND nmos W=0.0975U L=0.065U
M678_ #63 w1 n__I1__a Vdd pmos W=0.1625U L=0.065U
M679_keeper #650 #fb649# n__I1__a Vdd pmos W=0.0975U L=0.065U
M680_keeper #651 #fb649# n__I1__a GND nmos W=0.0975U L=0.065U
M681_ #20 inv__p w0i Vdd pmos W=0.1625U L=0.065U
M682_ #22 p w0i Vdd pmos W=0.1625U L=0.065U
M683_ #24 O_aa w0i GND nmos W=0.0975U L=0.065U
M684_keeper #653 #fb652# w0i Vdd pmos W=0.0975U L=0.065U
M685_keeper #654 #fb652# w0i GND nmos W=0.0975U L=0.065U
M686_ #19 n__u #20 Vdd pmos W=0.1625U L=0.065U
M687_ #19 n__v #22 Vdd pmos W=0.1625U L=0.065U
M688_ #574 n__u n__v GND nmos W=0.0975U L=0.065U
M689_ #575 I1_af_531_6 n__v Vdd pmos W=0.1625U L=0.065U
M690_ #33 inv__p f Vdd pmos W=0.1625U L=0.065U
M691_ #35 p f Vdd pmos W=0.1625U L=0.065U
M692_ #36 n__w1 f GND nmos W=0.0975U L=0.065U
M693_keeper #656 #fb655# f Vdd pmos W=0.0975U L=0.065U
M694_keeper #657 #fb655# f GND nmos W=0.0975U L=0.065U
M695_ #29 n__w0 #28 Vdd pmos W=0.1625U L=0.065U
M696_ #29 n__w1 #28 Vdd pmos W=0.1625U L=0.065U
M697_ #28 u #33 Vdd pmos W=0.1625U L=0.065U
M698_ #28 v #35 Vdd pmos W=0.1625U L=0.065U
M699_ #30 n__I0__a #29 Vdd pmos W=0.1625U L=0.065U
M700_ #30 n__I1__a #29 Vdd pmos W=0.1625U L=0.065U
M701_ #38 p n__w0 GND nmos W=0.0975U L=0.065U
M702_ #40 inv__p n__w0 GND nmos W=0.0975U L=0.065U
M703_ #42 inv__f n__w0 Vdd pmos W=0.1625U L=0.065U
M704_keeper #659 #fb658# n__w0 Vdd pmos W=0.0975U L=0.065U
M705_keeper #660 #fb658# n__w0 GND nmos W=0.0975U L=0.065U
M706_ #45 p n__w1 GND nmos W=0.0975U L=0.065U
M707_ #47 inv__p n__w1 GND nmos W=0.0975U L=0.065U
M708_ #49 inv__f n__w1 Vdd pmos W=0.1625U L=0.065U
M709_keeper #662 #fb661# n__w1 Vdd pmos W=0.0975U L=0.065U
M710_keeper #663 #fb661# n__w1 GND nmos W=0.0975U L=0.065U
M711_ #37 I0_af_50_6 #38 GND nmos W=0.0975U L=0.065U
M712_ #37 I1_af_50_6 #40 GND nmos W=0.0975U L=0.065U
M713_ #44 I0_at_50_6 #45 GND nmos W=0.0975U L=0.065U
M714_ #44 I1_at_50_6 #47 GND nmos W=0.0975U L=0.065U
M715_ #54 w1 #53 GND nmos W=0.0975U L=0.065U
M716_ #54 w0 #53 GND nmos W=0.0975U L=0.065U
M717_ #55 O_aa #54 GND nmos W=0.0975U L=0.065U
M718_ #57 w0 #58 Vdd pmos W=0.1625U L=0.065U
M719_ #60 w1 #59 GND nmos W=0.0975U L=0.065U
M720_ #60 w0 #59 GND nmos W=0.0975U L=0.065U
M721_ #61 O_aa #60 GND nmos W=0.0975U L=0.065U
M722_ #62 w0 #63 Vdd pmos W=0.1625U L=0.065U
M723_ #66 I0_at_50_6 n__O__t_50_6 GND nmos W=0.0975U L=0.065U
M724_ #67 I1_at_50_6 n__O__t_50_6 GND nmos W=0.0975U L=0.065U
M725_ #68 I0_at_50_6 n__O__t_50_6 Vdd pmos W=0.1625U L=0.065U
M726_ #69 I1_at_50_6 n__O__t_50_6 Vdd pmos W=0.1625U L=0.065U
M727_keeper #665 #fb664# n__O__t_50_6 Vdd pmos W=0.0975U L=0.065U
M728_keeper #666 #fb664# n__O__t_50_6 GND nmos W=0.0975U L=0.065U
M729_ #65 p #66 GND nmos W=0.0975U L=0.065U
M730_ #65 inv__p #67 GND nmos W=0.0975U L=0.065U
M731_ #72 I0_af_50_6 n__O__f_50_6 GND nmos W=0.0975U L=0.065U
M732_ #73 I1_af_50_6 n__O__f_50_6 GND nmos W=0.0975U L=0.065U
M733_ #74 I0_af_50_6 n__O__f_50_6 Vdd pmos W=0.1625U L=0.065U
M734_ #75 I1_af_50_6 n__O__f_50_6 Vdd pmos W=0.1625U L=0.065U
M735_keeper #668 #fb667# n__O__f_50_6 Vdd pmos W=0.0975U L=0.065U
M736_keeper #669 #fb667# n__O__f_50_6 GND nmos W=0.0975U L=0.065U
M737_ #71 p #72 GND nmos W=0.0975U L=0.065U
M738_ #71 inv__p #73 GND nmos W=0.0975U L=0.065U
M739_ #78 I0_at_51_6 n__O__t_51_6 GND nmos W=0.0975U L=0.065U
M740_ #80 I1_at_51_6 n__O__t_51_6 GND nmos W=0.0975U L=0.065U
M741_ #82 I0_at_51_6 n__O__t_51_6 Vdd pmos W=0.1625U L=0.065U
M742_ #83 I1_at_51_6 n__O__t_51_6 Vdd pmos W=0.1625U L=0.065U
M743_keeper #671 #fb670# n__O__t_51_6 Vdd pmos W=0.0975U L=0.065U
M744_keeper #672 #fb670# n__O__t_51_6 GND nmos W=0.0975U L=0.065U
M745_ #77 p #78 GND nmos W=0.0975U L=0.065U
M746_ #77 inv__p #80 GND nmos W=0.0975U L=0.065U
M747_ #86 I0_af_51_6 n__O__f_51_6 GND nmos W=0.0975U L=0.065U
M748_ #88 I1_af_51_6 n__O__f_51_6 GND nmos W=0.0975U L=0.065U
M749_ #90 I0_af_51_6 n__O__f_51_6 Vdd pmos W=0.1625U L=0.065U
M750_ #91 I1_af_51_6 n__O__f_51_6 Vdd pmos W=0.1625U L=0.065U
M751_keeper #674 #fb673# n__O__f_51_6 Vdd pmos W=0.0975U L=0.065U
M752_keeper #675 #fb673# n__O__f_51_6 GND nmos W=0.0975U L=0.065U
M753_ #85 p #86 GND nmos W=0.0975U L=0.065U
M754_ #85 inv__p #88 GND nmos W=0.0975U L=0.065U
M755_ #94 I0_at_52_6 n__O__t_52_6 GND nmos W=0.0975U L=0.065U
M756_ #96 I1_at_52_6 n__O__t_52_6 GND nmos W=0.0975U L=0.065U
M757_ #98 I0_at_52_6 n__O__t_52_6 Vdd pmos W=0.1625U L=0.065U
M758_ #99 I1_at_52_6 n__O__t_52_6 Vdd pmos W=0.1625U L=0.065U
M759_keeper #677 #fb676# n__O__t_52_6 Vdd pmos W=0.0975U L=0.065U
M760_keeper #678 #fb676# n__O__t_52_6 GND nmos W=0.0975U L=0.065U
M761_ #93 p #94 GND nmos W=0.0975U L=0.065U
M762_ #93 inv__p #96 GND nmos W=0.0975U L=0.065U
M763_ #102 I0_af_52_6 n__O__f_52_6 GND nmos W=0.0975U L=0.065U
M764_ #104 I1_af_52_6 n__O__f_52_6 GND nmos W=0.0975U L=0.065U
M765_ #106 I0_af_52_6 n__O__f_52_6 Vdd pmos W=0.1625U L=0.065U
M766_ #107 I1_af_52_6 n__O__f_52_6 Vdd pmos W=0.1625U L=0.065U
M767_keeper #680 #fb679# n__O__f_52_6 Vdd pmos W=0.0975U L=0.065U
M768_keeper #681 #fb679# n__O__f_52_6 GND nmos W=0.0975U L=0.065U
M769_ #101 p #102 GND nmos W=0.0975U L=0.065U
M770_ #101 inv__p #104 GND nmos W=0.0975U L=0.065U
M771_ #110 I0_at_53_6 n__O__t_53_6 GND nmos W=0.0975U L=0.065U
M772_ #112 I1_at_53_6 n__O__t_53_6 GND nmos W=0.0975U L=0.065U
M773_ #114 I0_at_53_6 n__O__t_53_6 Vdd pmos W=0.1625U L=0.065U
M774_ #115 I1_at_53_6 n__O__t_53_6 Vdd pmos W=0.1625U L=0.065U
M775_keeper #683 #fb682# n__O__t_53_6 Vdd pmos W=0.0975U L=0.065U
M776_keeper #684 #fb682# n__O__t_53_6 GND nmos W=0.0975U L=0.065U
M777_ #109 p #110 GND nmos W=0.0975U L=0.065U
M778_ #109 inv__p #112 GND nmos W=0.0975U L=0.065U
M779_ #118 I0_af_53_6 n__O__f_53_6 GND nmos W=0.0975U L=0.065U
M780_ #120 I1_af_53_6 n__O__f_53_6 GND nmos W=0.0975U L=0.065U
M781_ #122 I0_af_53_6 n__O__f_53_6 Vdd pmos W=0.1625U L=0.065U
M782_ #123 I1_af_53_6 n__O__f_53_6 Vdd pmos W=0.1625U L=0.065U
M783_keeper #686 #fb685# n__O__f_53_6 Vdd pmos W=0.0975U L=0.065U
M784_keeper #687 #fb685# n__O__f_53_6 GND nmos W=0.0975U L=0.065U
M785_ #117 p #118 GND nmos W=0.0975U L=0.065U
M786_ #117 inv__p #120 GND nmos W=0.0975U L=0.065U
M787_ #126 I0_at_54_6 n__O__t_54_6 GND nmos W=0.0975U L=0.065U
M788_ #128 I1_at_54_6 n__O__t_54_6 GND nmos W=0.0975U L=0.065U
M789_ #130 I0_at_54_6 n__O__t_54_6 Vdd pmos W=0.1625U L=0.065U
M790_ #131 I1_at_54_6 n__O__t_54_6 Vdd pmos W=0.1625U L=0.065U
M791_keeper #689 #fb688# n__O__t_54_6 Vdd pmos W=0.0975U L=0.065U
M792_keeper #690 #fb688# n__O__t_54_6 GND nmos W=0.0975U L=0.065U
M793_ #125 p #126 GND nmos W=0.0975U L=0.065U
M794_ #125 inv__p #128 GND nmos W=0.0975U L=0.065U
M795_ #134 I0_af_54_6 n__O__f_54_6 GND nmos W=0.0975U L=0.065U
M796_ #136 I1_af_54_6 n__O__f_54_6 GND nmos W=0.0975U L=0.065U
M797_ #138 I0_af_54_6 n__O__f_54_6 Vdd pmos W=0.1625U L=0.065U
M798_ #139 I1_af_54_6 n__O__f_54_6 Vdd pmos W=0.1625U L=0.065U
M799_keeper #692 #fb691# n__O__f_54_6 Vdd pmos W=0.0975U L=0.065U
M800_keeper #693 #fb691# n__O__f_54_6 GND nmos W=0.0975U L=0.065U
M801_ #133 p #134 GND nmos W=0.0975U L=0.065U
M802_ #133 inv__p #136 GND nmos W=0.0975U L=0.065U
M803_ #142 I0_at_55_6 n__O__t_55_6 GND nmos W=0.0975U L=0.065U
M804_ #144 I1_at_55_6 n__O__t_55_6 GND nmos W=0.0975U L=0.065U
M805_ #146 I0_at_55_6 n__O__t_55_6 Vdd pmos W=0.1625U L=0.065U
M806_ #147 I1_at_55_6 n__O__t_55_6 Vdd pmos W=0.1625U L=0.065U
M807_keeper #695 #fb694# n__O__t_55_6 Vdd pmos W=0.0975U L=0.065U
M808_keeper #696 #fb694# n__O__t_55_6 GND nmos W=0.0975U L=0.065U
M809_ #141 p #142 GND nmos W=0.0975U L=0.065U
M810_ #141 inv__p #144 GND nmos W=0.0975U L=0.065U
M811_ #150 I0_af_55_6 n__O__f_55_6 GND nmos W=0.0975U L=0.065U
M812_ #152 I1_af_55_6 n__O__f_55_6 GND nmos W=0.0975U L=0.065U
M813_ #154 I0_af_55_6 n__O__f_55_6 Vdd pmos W=0.1625U L=0.065U
M814_ #155 I1_af_55_6 n__O__f_55_6 Vdd pmos W=0.1625U L=0.065U
M815_keeper #698 #fb697# n__O__f_55_6 Vdd pmos W=0.0975U L=0.065U
M816_keeper #699 #fb697# n__O__f_55_6 GND nmos W=0.0975U L=0.065U
M817_ #149 p #150 GND nmos W=0.0975U L=0.065U
M818_ #149 inv__p #152 GND nmos W=0.0975U L=0.065U
M819_ #158 I0_at_56_6 n__O__t_56_6 GND nmos W=0.0975U L=0.065U
M820_ #160 I1_at_56_6 n__O__t_56_6 GND nmos W=0.0975U L=0.065U
M821_ #162 I0_at_56_6 n__O__t_56_6 Vdd pmos W=0.1625U L=0.065U
M822_ #163 I1_at_56_6 n__O__t_56_6 Vdd pmos W=0.1625U L=0.065U
M823_keeper #701 #fb700# n__O__t_56_6 Vdd pmos W=0.0975U L=0.065U
M824_keeper #702 #fb700# n__O__t_56_6 GND nmos W=0.0975U L=0.065U
M825_ #157 p #158 GND nmos W=0.0975U L=0.065U
M826_ #157 inv__p #160 GND nmos W=0.0975U L=0.065U
M827_ #166 I0_af_56_6 n__O__f_56_6 GND nmos W=0.0975U L=0.065U
M828_ #168 I1_af_56_6 n__O__f_56_6 GND nmos W=0.0975U L=0.065U
M829_ #170 I0_af_56_6 n__O__f_56_6 Vdd pmos W=0.1625U L=0.065U
M830_ #171 I1_af_56_6 n__O__f_56_6 Vdd pmos W=0.1625U L=0.065U
M831_keeper #704 #fb703# n__O__f_56_6 Vdd pmos W=0.0975U L=0.065U
M832_keeper #705 #fb703# n__O__f_56_6 GND nmos W=0.0975U L=0.065U
M833_ #165 p #166 GND nmos W=0.0975U L=0.065U
M834_ #165 inv__p #168 GND nmos W=0.0975U L=0.065U
M835_ #174 I0_at_57_6 n__O__t_57_6 GND nmos W=0.0975U L=0.065U
M836_ #176 I1_at_57_6 n__O__t_57_6 GND nmos W=0.0975U L=0.065U
M837_ #178 I0_at_57_6 n__O__t_57_6 Vdd pmos W=0.1625U L=0.065U
M838_ #179 I1_at_57_6 n__O__t_57_6 Vdd pmos W=0.1625U L=0.065U
M839_keeper #707 #fb706# n__O__t_57_6 Vdd pmos W=0.0975U L=0.065U
M840_keeper #708 #fb706# n__O__t_57_6 GND nmos W=0.0975U L=0.065U
M841_ #173 p #174 GND nmos W=0.0975U L=0.065U
M842_ #173 inv__p #176 GND nmos W=0.0975U L=0.065U
M843_ #182 I0_af_57_6 n__O__f_57_6 GND nmos W=0.0975U L=0.065U
M844_ #184 I1_af_57_6 n__O__f_57_6 GND nmos W=0.0975U L=0.065U
M845_ #186 I0_af_57_6 n__O__f_57_6 Vdd pmos W=0.1625U L=0.065U
M846_ #187 I1_af_57_6 n__O__f_57_6 Vdd pmos W=0.1625U L=0.065U
M847_keeper #710 #fb709# n__O__f_57_6 Vdd pmos W=0.0975U L=0.065U
M848_keeper #711 #fb709# n__O__f_57_6 GND nmos W=0.0975U L=0.065U
M849_ #181 p #182 GND nmos W=0.0975U L=0.065U
M850_ #181 inv__p #184 GND nmos W=0.0975U L=0.065U
M851_ #190 I0_at_58_6 n__O__t_58_6 GND nmos W=0.0975U L=0.065U
M852_ #192 I1_at_58_6 n__O__t_58_6 GND nmos W=0.0975U L=0.065U
M853_ #194 I0_at_58_6 n__O__t_58_6 Vdd pmos W=0.1625U L=0.065U
M854_ #195 I1_at_58_6 n__O__t_58_6 Vdd pmos W=0.1625U L=0.065U
M855_keeper #713 #fb712# n__O__t_58_6 Vdd pmos W=0.0975U L=0.065U
M856_keeper #714 #fb712# n__O__t_58_6 GND nmos W=0.0975U L=0.065U
M857_ #189 p #190 GND nmos W=0.0975U L=0.065U
M858_ #189 inv__p #192 GND nmos W=0.0975U L=0.065U
M859_ #198 I0_af_58_6 n__O__f_58_6 GND nmos W=0.0975U L=0.065U
M860_ #200 I1_af_58_6 n__O__f_58_6 GND nmos W=0.0975U L=0.065U
M861_ #202 I0_af_58_6 n__O__f_58_6 Vdd pmos W=0.1625U L=0.065U
M862_ #203 I1_af_58_6 n__O__f_58_6 Vdd pmos W=0.1625U L=0.065U
M863_keeper #716 #fb715# n__O__f_58_6 Vdd pmos W=0.0975U L=0.065U
M864_keeper #717 #fb715# n__O__f_58_6 GND nmos W=0.0975U L=0.065U
M865_ #197 p #198 GND nmos W=0.0975U L=0.065U
M866_ #197 inv__p #200 GND nmos W=0.0975U L=0.065U
M867_ #206 I0_at_59_6 n__O__t_59_6 GND nmos W=0.0975U L=0.065U
M868_ #208 I1_at_59_6 n__O__t_59_6 GND nmos W=0.0975U L=0.065U
M869_ #210 I0_at_59_6 n__O__t_59_6 Vdd pmos W=0.1625U L=0.065U
M870_ #211 I1_at_59_6 n__O__t_59_6 Vdd pmos W=0.1625U L=0.065U
M871_keeper #719 #fb718# n__O__t_59_6 Vdd pmos W=0.0975U L=0.065U
M872_keeper #720 #fb718# n__O__t_59_6 GND nmos W=0.0975U L=0.065U
M873_ #205 p #206 GND nmos W=0.0975U L=0.065U
M874_ #205 inv__p #208 GND nmos W=0.0975U L=0.065U
M875_ #214 I0_af_59_6 n__O__f_59_6 GND nmos W=0.0975U L=0.065U
M876_ #216 I1_af_59_6 n__O__f_59_6 GND nmos W=0.0975U L=0.065U
M877_ #218 I0_af_59_6 n__O__f_59_6 Vdd pmos W=0.1625U L=0.065U
M878_ #219 I1_af_59_6 n__O__f_59_6 Vdd pmos W=0.1625U L=0.065U
M879_keeper #722 #fb721# n__O__f_59_6 Vdd pmos W=0.0975U L=0.065U
M880_keeper #723 #fb721# n__O__f_59_6 GND nmos W=0.0975U L=0.065U
M881_ #213 p #214 GND nmos W=0.0975U L=0.065U
M882_ #213 inv__p #216 GND nmos W=0.0975U L=0.065U
M883_ #222 I0_at_510_6 n__O__t_510_6 GND nmos W=0.0975U L=0.065U
M884_ #224 I1_at_510_6 n__O__t_510_6 GND nmos W=0.0975U L=0.065U
M885_ #226 I0_at_510_6 n__O__t_510_6 Vdd pmos W=0.1625U L=0.065U
M886_ #227 I1_at_510_6 n__O__t_510_6 Vdd pmos W=0.1625U L=0.065U
M887_keeper #725 #fb724# n__O__t_510_6 Vdd pmos W=0.0975U L=0.065U
M888_keeper #726 #fb724# n__O__t_510_6 GND nmos W=0.0975U L=0.065U
M889_ #221 p #222 GND nmos W=0.0975U L=0.065U
M890_ #221 inv__p #224 GND nmos W=0.0975U L=0.065U
M891_ #230 I0_af_510_6 n__O__f_510_6 GND nmos W=0.0975U L=0.065U
M892_ #232 I1_af_510_6 n__O__f_510_6 GND nmos W=0.0975U L=0.065U
M893_ #234 I0_af_510_6 n__O__f_510_6 Vdd pmos W=0.1625U L=0.065U
M894_ #235 I1_af_510_6 n__O__f_510_6 Vdd pmos W=0.1625U L=0.065U
M895_keeper #728 #fb727# n__O__f_510_6 Vdd pmos W=0.0975U L=0.065U
M896_keeper #729 #fb727# n__O__f_510_6 GND nmos W=0.0975U L=0.065U
M897_ #229 p #230 GND nmos W=0.0975U L=0.065U
M898_ #229 inv__p #232 GND nmos W=0.0975U L=0.065U
M899_ #238 I0_at_511_6 n__O__t_511_6 GND nmos W=0.0975U L=0.065U
M900_ #240 I1_at_511_6 n__O__t_511_6 GND nmos W=0.0975U L=0.065U
M901_ #242 I0_at_511_6 n__O__t_511_6 Vdd pmos W=0.1625U L=0.065U
M902_ #243 I1_at_511_6 n__O__t_511_6 Vdd pmos W=0.1625U L=0.065U
M903_keeper #731 #fb730# n__O__t_511_6 Vdd pmos W=0.0975U L=0.065U
M904_keeper #732 #fb730# n__O__t_511_6 GND nmos W=0.0975U L=0.065U
M905_ #237 p #238 GND nmos W=0.0975U L=0.065U
M906_ #237 inv__p #240 GND nmos W=0.0975U L=0.065U
M907_ #246 I0_af_511_6 n__O__f_511_6 GND nmos W=0.0975U L=0.065U
M908_ #248 I1_af_511_6 n__O__f_511_6 GND nmos W=0.0975U L=0.065U
M909_ #250 I0_af_511_6 n__O__f_511_6 Vdd pmos W=0.1625U L=0.065U
M910_ #251 I1_af_511_6 n__O__f_511_6 Vdd pmos W=0.1625U L=0.065U
M911_keeper #734 #fb733# n__O__f_511_6 Vdd pmos W=0.0975U L=0.065U
M912_keeper #735 #fb733# n__O__f_511_6 GND nmos W=0.0975U L=0.065U
M913_ #245 p #246 GND nmos W=0.0975U L=0.065U
M914_ #245 inv__p #248 GND nmos W=0.0975U L=0.065U
M915_ #254 I0_at_512_6 n__O__t_512_6 GND nmos W=0.0975U L=0.065U
M916_ #256 I1_at_512_6 n__O__t_512_6 GND nmos W=0.0975U L=0.065U
M917_ #258 I0_at_512_6 n__O__t_512_6 Vdd pmos W=0.1625U L=0.065U
M918_ #259 I1_at_512_6 n__O__t_512_6 Vdd pmos W=0.1625U L=0.065U
M919_keeper #737 #fb736# n__O__t_512_6 Vdd pmos W=0.0975U L=0.065U
M920_keeper #738 #fb736# n__O__t_512_6 GND nmos W=0.0975U L=0.065U
M921_ #253 p #254 GND nmos W=0.0975U L=0.065U
M922_ #253 inv__p #256 GND nmos W=0.0975U L=0.065U
M923_ #262 I0_af_512_6 n__O__f_512_6 GND nmos W=0.0975U L=0.065U
M924_ #264 I1_af_512_6 n__O__f_512_6 GND nmos W=0.0975U L=0.065U
M925_ #266 I0_af_512_6 n__O__f_512_6 Vdd pmos W=0.1625U L=0.065U
M926_ #267 I1_af_512_6 n__O__f_512_6 Vdd pmos W=0.1625U L=0.065U
M927_keeper #740 #fb739# n__O__f_512_6 Vdd pmos W=0.0975U L=0.065U
M928_keeper #741 #fb739# n__O__f_512_6 GND nmos W=0.0975U L=0.065U
M929_ #261 p #262 GND nmos W=0.0975U L=0.065U
M930_ #261 inv__p #264 GND nmos W=0.0975U L=0.065U
M931_ #270 I0_at_513_6 n__O__t_513_6 GND nmos W=0.0975U L=0.065U
M932_ #272 I1_at_513_6 n__O__t_513_6 GND nmos W=0.0975U L=0.065U
M933_ #274 I0_at_513_6 n__O__t_513_6 Vdd pmos W=0.1625U L=0.065U
M934_ #275 I1_at_513_6 n__O__t_513_6 Vdd pmos W=0.1625U L=0.065U
M935_keeper #743 #fb742# n__O__t_513_6 Vdd pmos W=0.0975U L=0.065U
M936_keeper #744 #fb742# n__O__t_513_6 GND nmos W=0.0975U L=0.065U
M937_ #269 p #270 GND nmos W=0.0975U L=0.065U
M938_ #269 inv__p #272 GND nmos W=0.0975U L=0.065U
M939_ #278 I0_af_513_6 n__O__f_513_6 GND nmos W=0.0975U L=0.065U
M940_ #280 I1_af_513_6 n__O__f_513_6 GND nmos W=0.0975U L=0.065U
M941_ #282 I0_af_513_6 n__O__f_513_6 Vdd pmos W=0.1625U L=0.065U
M942_ #283 I1_af_513_6 n__O__f_513_6 Vdd pmos W=0.1625U L=0.065U
M943_keeper #746 #fb745# n__O__f_513_6 Vdd pmos W=0.0975U L=0.065U
M944_keeper #747 #fb745# n__O__f_513_6 GND nmos W=0.0975U L=0.065U
M945_ #277 p #278 GND nmos W=0.0975U L=0.065U
M946_ #277 inv__p #280 GND nmos W=0.0975U L=0.065U
M947_ #286 I0_at_514_6 n__O__t_514_6 GND nmos W=0.0975U L=0.065U
M948_ #288 I1_at_514_6 n__O__t_514_6 GND nmos W=0.0975U L=0.065U
M949_ #290 I0_at_514_6 n__O__t_514_6 Vdd pmos W=0.1625U L=0.065U
M950_ #291 I1_at_514_6 n__O__t_514_6 Vdd pmos W=0.1625U L=0.065U
M951_keeper #749 #fb748# n__O__t_514_6 Vdd pmos W=0.0975U L=0.065U
M952_keeper #750 #fb748# n__O__t_514_6 GND nmos W=0.0975U L=0.065U
M953_ #285 p #286 GND nmos W=0.0975U L=0.065U
M954_ #285 inv__p #288 GND nmos W=0.0975U L=0.065U
M955_ #294 I0_af_514_6 n__O__f_514_6 GND nmos W=0.0975U L=0.065U
M956_ #296 I1_af_514_6 n__O__f_514_6 GND nmos W=0.0975U L=0.065U
M957_ #298 I0_af_514_6 n__O__f_514_6 Vdd pmos W=0.1625U L=0.065U
M958_ #299 I1_af_514_6 n__O__f_514_6 Vdd pmos W=0.1625U L=0.065U
M959_keeper #752 #fb751# n__O__f_514_6 Vdd pmos W=0.0975U L=0.065U
M960_keeper #753 #fb751# n__O__f_514_6 GND nmos W=0.0975U L=0.065U
M961_ #293 p #294 GND nmos W=0.0975U L=0.065U
M962_ #293 inv__p #296 GND nmos W=0.0975U L=0.065U
M963_ #302 I0_at_515_6 n__O__t_515_6 GND nmos W=0.0975U L=0.065U
M964_ #304 I1_at_515_6 n__O__t_515_6 GND nmos W=0.0975U L=0.065U
M965_ #306 I0_at_515_6 n__O__t_515_6 Vdd pmos W=0.1625U L=0.065U
M966_ #307 I1_at_515_6 n__O__t_515_6 Vdd pmos W=0.1625U L=0.065U
M967_keeper #755 #fb754# n__O__t_515_6 Vdd pmos W=0.0975U L=0.065U
M968_keeper #756 #fb754# n__O__t_515_6 GND nmos W=0.0975U L=0.065U
M969_ #301 p #302 GND nmos W=0.0975U L=0.065U
M970_ #301 inv__p #304 GND nmos W=0.0975U L=0.065U
M971_ #310 I0_af_515_6 n__O__f_515_6 GND nmos W=0.0975U L=0.065U
M972_ #312 I1_af_515_6 n__O__f_515_6 GND nmos W=0.0975U L=0.065U
M973_ #314 I0_af_515_6 n__O__f_515_6 Vdd pmos W=0.1625U L=0.065U
M974_ #315 I1_af_515_6 n__O__f_515_6 Vdd pmos W=0.1625U L=0.065U
M975_keeper #758 #fb757# n__O__f_515_6 Vdd pmos W=0.0975U L=0.065U
M976_keeper #759 #fb757# n__O__f_515_6 GND nmos W=0.0975U L=0.065U
M977_ #309 p #310 GND nmos W=0.0975U L=0.065U
M978_ #309 inv__p #312 GND nmos W=0.0975U L=0.065U
M979_ #318 I0_at_516_6 n__O__t_516_6 GND nmos W=0.0975U L=0.065U
M980_ #320 I1_at_516_6 n__O__t_516_6 GND nmos W=0.0975U L=0.065U
M981_ #322 I0_at_516_6 n__O__t_516_6 Vdd pmos W=0.1625U L=0.065U
M982_ #323 I1_at_516_6 n__O__t_516_6 Vdd pmos W=0.1625U L=0.065U
M983_keeper #761 #fb760# n__O__t_516_6 Vdd pmos W=0.0975U L=0.065U
M984_keeper #762 #fb760# n__O__t_516_6 GND nmos W=0.0975U L=0.065U
M985_ #317 p #318 GND nmos W=0.0975U L=0.065U
M986_ #317 inv__p #320 GND nmos W=0.0975U L=0.065U
M987_ #326 I0_af_516_6 n__O__f_516_6 GND nmos W=0.0975U L=0.065U
M988_ #328 I1_af_516_6 n__O__f_516_6 GND nmos W=0.0975U L=0.065U
M989_ #330 I0_af_516_6 n__O__f_516_6 Vdd pmos W=0.1625U L=0.065U
M990_ #331 I1_af_516_6 n__O__f_516_6 Vdd pmos W=0.1625U L=0.065U
M991_keeper #764 #fb763# n__O__f_516_6 Vdd pmos W=0.0975U L=0.065U
M992_keeper #765 #fb763# n__O__f_516_6 GND nmos W=0.0975U L=0.065U
M993_ #325 p #326 GND nmos W=0.0975U L=0.065U
M994_ #325 inv__p #328 GND nmos W=0.0975U L=0.065U
M995_ #334 I0_at_517_6 n__O__t_517_6 GND nmos W=0.0975U L=0.065U
M996_ #336 I1_at_517_6 n__O__t_517_6 GND nmos W=0.0975U L=0.065U
M997_ #338 I0_at_517_6 n__O__t_517_6 Vdd pmos W=0.1625U L=0.065U
M998_ #339 I1_at_517_6 n__O__t_517_6 Vdd pmos W=0.1625U L=0.065U
M999_keeper #767 #fb766# n__O__t_517_6 Vdd pmos W=0.0975U L=0.065U
M1000_keeper #768 #fb766# n__O__t_517_6 GND nmos W=0.0975U L=0.065U
M1001_ #333 p #334 GND nmos W=0.0975U L=0.065U
M1002_ #333 inv__p #336 GND nmos W=0.0975U L=0.065U
M1003_ #342 I0_af_517_6 n__O__f_517_6 GND nmos W=0.0975U L=0.065U
M1004_ #344 I1_af_517_6 n__O__f_517_6 GND nmos W=0.0975U L=0.065U
M1005_ #346 I0_af_517_6 n__O__f_517_6 Vdd pmos W=0.1625U L=0.065U
M1006_ #347 I1_af_517_6 n__O__f_517_6 Vdd pmos W=0.1625U L=0.065U
M1007_keeper #770 #fb769# n__O__f_517_6 Vdd pmos W=0.0975U L=0.065U
M1008_keeper #771 #fb769# n__O__f_517_6 GND nmos W=0.0975U L=0.065U
M1009_ #341 p #342 GND nmos W=0.0975U L=0.065U
M1010_ #341 inv__p #344 GND nmos W=0.0975U L=0.065U
M1011_ #350 I0_at_518_6 n__O__t_518_6 GND nmos W=0.0975U L=0.065U
M1012_ #352 I1_at_518_6 n__O__t_518_6 GND nmos W=0.0975U L=0.065U
M1013_ #354 I0_at_518_6 n__O__t_518_6 Vdd pmos W=0.1625U L=0.065U
M1014_ #355 I1_at_518_6 n__O__t_518_6 Vdd pmos W=0.1625U L=0.065U
M1015_keeper #773 #fb772# n__O__t_518_6 Vdd pmos W=0.0975U L=0.065U
M1016_keeper #774 #fb772# n__O__t_518_6 GND nmos W=0.0975U L=0.065U
M1017_ #349 p #350 GND nmos W=0.0975U L=0.065U
M1018_ #349 inv__p #352 GND nmos W=0.0975U L=0.065U
M1019_ #358 I0_af_518_6 n__O__f_518_6 GND nmos W=0.0975U L=0.065U
M1020_ #360 I1_af_518_6 n__O__f_518_6 GND nmos W=0.0975U L=0.065U
M1021_ #362 I0_af_518_6 n__O__f_518_6 Vdd pmos W=0.1625U L=0.065U
M1022_ #363 I1_af_518_6 n__O__f_518_6 Vdd pmos W=0.1625U L=0.065U
M1023_keeper #776 #fb775# n__O__f_518_6 Vdd pmos W=0.0975U L=0.065U
M1024_keeper #777 #fb775# n__O__f_518_6 GND nmos W=0.0975U L=0.065U
M1025_ #357 p #358 GND nmos W=0.0975U L=0.065U
M1026_ #357 inv__p #360 GND nmos W=0.0975U L=0.065U
M1027_ #366 I0_at_519_6 n__O__t_519_6 GND nmos W=0.0975U L=0.065U
M1028_ #368 I1_at_519_6 n__O__t_519_6 GND nmos W=0.0975U L=0.065U
M1029_ #370 I0_at_519_6 n__O__t_519_6 Vdd pmos W=0.1625U L=0.065U
M1030_ #371 I1_at_519_6 n__O__t_519_6 Vdd pmos W=0.1625U L=0.065U
M1031_keeper #779 #fb778# n__O__t_519_6 Vdd pmos W=0.0975U L=0.065U
M1032_keeper #780 #fb778# n__O__t_519_6 GND nmos W=0.0975U L=0.065U
M1033_ #365 p #366 GND nmos W=0.0975U L=0.065U
M1034_ #365 inv__p #368 GND nmos W=0.0975U L=0.065U
M1035_ #374 I0_af_519_6 n__O__f_519_6 GND nmos W=0.0975U L=0.065U
M1036_ #376 I1_af_519_6 n__O__f_519_6 GND nmos W=0.0975U L=0.065U
M1037_ #378 I0_af_519_6 n__O__f_519_6 Vdd pmos W=0.1625U L=0.065U
M1038_ #379 I1_af_519_6 n__O__f_519_6 Vdd pmos W=0.1625U L=0.065U
M1039_keeper #782 #fb781# n__O__f_519_6 Vdd pmos W=0.0975U L=0.065U
M1040_keeper #783 #fb781# n__O__f_519_6 GND nmos W=0.0975U L=0.065U
M1041_ #373 p #374 GND nmos W=0.0975U L=0.065U
M1042_ #373 inv__p #376 GND nmos W=0.0975U L=0.065U
M1043_ #382 I0_at_520_6 n__O__t_520_6 GND nmos W=0.0975U L=0.065U
M1044_ #384 I1_at_520_6 n__O__t_520_6 GND nmos W=0.0975U L=0.065U
M1045_ #386 I0_at_520_6 n__O__t_520_6 Vdd pmos W=0.1625U L=0.065U
M1046_ #387 I1_at_520_6 n__O__t_520_6 Vdd pmos W=0.1625U L=0.065U
M1047_keeper #785 #fb784# n__O__t_520_6 Vdd pmos W=0.0975U L=0.065U
M1048_keeper #786 #fb784# n__O__t_520_6 GND nmos W=0.0975U L=0.065U
M1049_ #381 p #382 GND nmos W=0.0975U L=0.065U
M1050_ #381 inv__p #384 GND nmos W=0.0975U L=0.065U
M1051_ #390 I0_af_520_6 n__O__f_520_6 GND nmos W=0.0975U L=0.065U
M1052_ #392 I1_af_520_6 n__O__f_520_6 GND nmos W=0.0975U L=0.065U
M1053_ #394 I0_af_520_6 n__O__f_520_6 Vdd pmos W=0.1625U L=0.065U
M1054_ #395 I1_af_520_6 n__O__f_520_6 Vdd pmos W=0.1625U L=0.065U
M1055_keeper #788 #fb787# n__O__f_520_6 Vdd pmos W=0.0975U L=0.065U
M1056_keeper #789 #fb787# n__O__f_520_6 GND nmos W=0.0975U L=0.065U
M1057_ #389 p #390 GND nmos W=0.0975U L=0.065U
M1058_ #389 inv__p #392 GND nmos W=0.0975U L=0.065U
M1059_ #398 I0_at_521_6 n__O__t_521_6 GND nmos W=0.0975U L=0.065U
M1060_ #400 I1_at_521_6 n__O__t_521_6 GND nmos W=0.0975U L=0.065U
M1061_ #402 I0_at_521_6 n__O__t_521_6 Vdd pmos W=0.1625U L=0.065U
M1062_ #403 I1_at_521_6 n__O__t_521_6 Vdd pmos W=0.1625U L=0.065U
M1063_keeper #791 #fb790# n__O__t_521_6 Vdd pmos W=0.0975U L=0.065U
M1064_keeper #792 #fb790# n__O__t_521_6 GND nmos W=0.0975U L=0.065U
M1065_ #397 p #398 GND nmos W=0.0975U L=0.065U
M1066_ #397 inv__p #400 GND nmos W=0.0975U L=0.065U
M1067_ #406 I0_af_521_6 n__O__f_521_6 GND nmos W=0.0975U L=0.065U
M1068_ #408 I1_af_521_6 n__O__f_521_6 GND nmos W=0.0975U L=0.065U
M1069_ #410 I0_af_521_6 n__O__f_521_6 Vdd pmos W=0.1625U L=0.065U
M1070_ #411 I1_af_521_6 n__O__f_521_6 Vdd pmos W=0.1625U L=0.065U
M1071_keeper #794 #fb793# n__O__f_521_6 Vdd pmos W=0.0975U L=0.065U
M1072_keeper #795 #fb793# n__O__f_521_6 GND nmos W=0.0975U L=0.065U
M1073_ #405 p #406 GND nmos W=0.0975U L=0.065U
M1074_ #405 inv__p #408 GND nmos W=0.0975U L=0.065U
M1075_ #414 I0_at_522_6 n__O__t_522_6 GND nmos W=0.0975U L=0.065U
M1076_ #416 I1_at_522_6 n__O__t_522_6 GND nmos W=0.0975U L=0.065U
M1077_ #418 I0_at_522_6 n__O__t_522_6 Vdd pmos W=0.1625U L=0.065U
M1078_ #419 I1_at_522_6 n__O__t_522_6 Vdd pmos W=0.1625U L=0.065U
M1079_keeper #797 #fb796# n__O__t_522_6 Vdd pmos W=0.0975U L=0.065U
M1080_keeper #798 #fb796# n__O__t_522_6 GND nmos W=0.0975U L=0.065U
M1081_ #413 p #414 GND nmos W=0.0975U L=0.065U
M1082_ #413 inv__p #416 GND nmos W=0.0975U L=0.065U
M1083_ #422 I0_af_522_6 n__O__f_522_6 GND nmos W=0.0975U L=0.065U
M1084_ #424 I1_af_522_6 n__O__f_522_6 GND nmos W=0.0975U L=0.065U
M1085_ #426 I0_af_522_6 n__O__f_522_6 Vdd pmos W=0.1625U L=0.065U
M1086_ #427 I1_af_522_6 n__O__f_522_6 Vdd pmos W=0.1625U L=0.065U
M1087_keeper #800 #fb799# n__O__f_522_6 Vdd pmos W=0.0975U L=0.065U
M1088_keeper #801 #fb799# n__O__f_522_6 GND nmos W=0.0975U L=0.065U
M1089_ #421 p #422 GND nmos W=0.0975U L=0.065U
M1090_ #421 inv__p #424 GND nmos W=0.0975U L=0.065U
M1091_ #430 I0_at_523_6 n__O__t_523_6 GND nmos W=0.0975U L=0.065U
M1092_ #432 I1_at_523_6 n__O__t_523_6 GND nmos W=0.0975U L=0.065U
M1093_ #434 I0_at_523_6 n__O__t_523_6 Vdd pmos W=0.1625U L=0.065U
M1094_ #435 I1_at_523_6 n__O__t_523_6 Vdd pmos W=0.1625U L=0.065U
M1095_keeper #803 #fb802# n__O__t_523_6 Vdd pmos W=0.0975U L=0.065U
M1096_keeper #804 #fb802# n__O__t_523_6 GND nmos W=0.0975U L=0.065U
M1097_ #429 p #430 GND nmos W=0.0975U L=0.065U
M1098_ #429 inv__p #432 GND nmos W=0.0975U L=0.065U
M1099_ #438 I0_af_523_6 n__O__f_523_6 GND nmos W=0.0975U L=0.065U
M1100_ #440 I1_af_523_6 n__O__f_523_6 GND nmos W=0.0975U L=0.065U
M1101_ #442 I0_af_523_6 n__O__f_523_6 Vdd pmos W=0.1625U L=0.065U
M1102_ #443 I1_af_523_6 n__O__f_523_6 Vdd pmos W=0.1625U L=0.065U
M1103_keeper #806 #fb805# n__O__f_523_6 Vdd pmos W=0.0975U L=0.065U
M1104_keeper #807 #fb805# n__O__f_523_6 GND nmos W=0.0975U L=0.065U
M1105_ #437 p #438 GND nmos W=0.0975U L=0.065U
M1106_ #437 inv__p #440 GND nmos W=0.0975U L=0.065U
M1107_ #446 I0_at_524_6 n__O__t_524_6 GND nmos W=0.0975U L=0.065U
M1108_ #448 I1_at_524_6 n__O__t_524_6 GND nmos W=0.0975U L=0.065U
M1109_ #450 I0_at_524_6 n__O__t_524_6 Vdd pmos W=0.1625U L=0.065U
M1110_ #451 I1_at_524_6 n__O__t_524_6 Vdd pmos W=0.1625U L=0.065U
M1111_keeper #809 #fb808# n__O__t_524_6 Vdd pmos W=0.0975U L=0.065U
M1112_keeper #810 #fb808# n__O__t_524_6 GND nmos W=0.0975U L=0.065U
M1113_ #445 p #446 GND nmos W=0.0975U L=0.065U
M1114_ #445 inv__p #448 GND nmos W=0.0975U L=0.065U
M1115_ #454 I0_af_524_6 n__O__f_524_6 GND nmos W=0.0975U L=0.065U
M1116_ #456 I1_af_524_6 n__O__f_524_6 GND nmos W=0.0975U L=0.065U
M1117_ #458 I0_af_524_6 n__O__f_524_6 Vdd pmos W=0.1625U L=0.065U
M1118_ #459 I1_af_524_6 n__O__f_524_6 Vdd pmos W=0.1625U L=0.065U
M1119_keeper #812 #fb811# n__O__f_524_6 Vdd pmos W=0.0975U L=0.065U
M1120_keeper #813 #fb811# n__O__f_524_6 GND nmos W=0.0975U L=0.065U
M1121_ #453 p #454 GND nmos W=0.0975U L=0.065U
M1122_ #453 inv__p #456 GND nmos W=0.0975U L=0.065U
M1123_ #462 I0_at_525_6 n__O__t_525_6 GND nmos W=0.0975U L=0.065U
M1124_ #464 I1_at_525_6 n__O__t_525_6 GND nmos W=0.0975U L=0.065U
M1125_ #466 I0_at_525_6 n__O__t_525_6 Vdd pmos W=0.1625U L=0.065U
M1126_ #467 I1_at_525_6 n__O__t_525_6 Vdd pmos W=0.1625U L=0.065U
M1127_keeper #815 #fb814# n__O__t_525_6 Vdd pmos W=0.0975U L=0.065U
M1128_keeper #816 #fb814# n__O__t_525_6 GND nmos W=0.0975U L=0.065U
M1129_ #461 p #462 GND nmos W=0.0975U L=0.065U
M1130_ #461 inv__p #464 GND nmos W=0.0975U L=0.065U
M1131_ #470 I0_af_525_6 n__O__f_525_6 GND nmos W=0.0975U L=0.065U
M1132_ #472 I1_af_525_6 n__O__f_525_6 GND nmos W=0.0975U L=0.065U
M1133_ #474 I0_af_525_6 n__O__f_525_6 Vdd pmos W=0.1625U L=0.065U
M1134_ #475 I1_af_525_6 n__O__f_525_6 Vdd pmos W=0.1625U L=0.065U
M1135_keeper #818 #fb817# n__O__f_525_6 Vdd pmos W=0.0975U L=0.065U
M1136_keeper #819 #fb817# n__O__f_525_6 GND nmos W=0.0975U L=0.065U
M1137_ #469 p #470 GND nmos W=0.0975U L=0.065U
M1138_ #469 inv__p #472 GND nmos W=0.0975U L=0.065U
M1139_ #478 I0_at_526_6 n__O__t_526_6 GND nmos W=0.0975U L=0.065U
M1140_ #480 I1_at_526_6 n__O__t_526_6 GND nmos W=0.0975U L=0.065U
M1141_ #482 I0_at_526_6 n__O__t_526_6 Vdd pmos W=0.1625U L=0.065U
M1142_ #483 I1_at_526_6 n__O__t_526_6 Vdd pmos W=0.1625U L=0.065U
M1143_keeper #821 #fb820# n__O__t_526_6 Vdd pmos W=0.0975U L=0.065U
M1144_keeper #822 #fb820# n__O__t_526_6 GND nmos W=0.0975U L=0.065U
M1145_ #477 p #478 GND nmos W=0.0975U L=0.065U
M1146_ #477 inv__p #480 GND nmos W=0.0975U L=0.065U
M1147_ #486 I0_af_526_6 n__O__f_526_6 GND nmos W=0.0975U L=0.065U
M1148_ #488 I1_af_526_6 n__O__f_526_6 GND nmos W=0.0975U L=0.065U
M1149_ #490 I0_af_526_6 n__O__f_526_6 Vdd pmos W=0.1625U L=0.065U
M1150_ #491 I1_af_526_6 n__O__f_526_6 Vdd pmos W=0.1625U L=0.065U
M1151_keeper #824 #fb823# n__O__f_526_6 Vdd pmos W=0.0975U L=0.065U
M1152_keeper #825 #fb823# n__O__f_526_6 GND nmos W=0.0975U L=0.065U
M1153_ #485 p #486 GND nmos W=0.0975U L=0.065U
M1154_ #485 inv__p #488 GND nmos W=0.0975U L=0.065U
M1155_ #494 I0_at_527_6 n__O__t_527_6 GND nmos W=0.0975U L=0.065U
M1156_ #496 I1_at_527_6 n__O__t_527_6 GND nmos W=0.0975U L=0.065U
M1157_ #498 I0_at_527_6 n__O__t_527_6 Vdd pmos W=0.1625U L=0.065U
M1158_ #499 I1_at_527_6 n__O__t_527_6 Vdd pmos W=0.1625U L=0.065U
M1159_keeper #827 #fb826# n__O__t_527_6 Vdd pmos W=0.0975U L=0.065U
M1160_keeper #828 #fb826# n__O__t_527_6 GND nmos W=0.0975U L=0.065U
M1161_ #493 p #494 GND nmos W=0.0975U L=0.065U
M1162_ #493 inv__p #496 GND nmos W=0.0975U L=0.065U
M1163_ #502 I0_af_527_6 n__O__f_527_6 GND nmos W=0.0975U L=0.065U
M1164_ #504 I1_af_527_6 n__O__f_527_6 GND nmos W=0.0975U L=0.065U
M1165_ #506 I0_af_527_6 n__O__f_527_6 Vdd pmos W=0.1625U L=0.065U
M1166_ #507 I1_af_527_6 n__O__f_527_6 Vdd pmos W=0.1625U L=0.065U
M1167_keeper #830 #fb829# n__O__f_527_6 Vdd pmos W=0.0975U L=0.065U
M1168_keeper #831 #fb829# n__O__f_527_6 GND nmos W=0.0975U L=0.065U
M1169_ #501 p #502 GND nmos W=0.0975U L=0.065U
M1170_ #501 inv__p #504 GND nmos W=0.0975U L=0.065U
M1171_ #510 I0_at_528_6 n__O__t_528_6 GND nmos W=0.0975U L=0.065U
M1172_ #512 I1_at_528_6 n__O__t_528_6 GND nmos W=0.0975U L=0.065U
M1173_ #514 I0_at_528_6 n__O__t_528_6 Vdd pmos W=0.1625U L=0.065U
M1174_ #515 I1_at_528_6 n__O__t_528_6 Vdd pmos W=0.1625U L=0.065U
M1175_keeper #833 #fb832# n__O__t_528_6 Vdd pmos W=0.0975U L=0.065U
M1176_keeper #834 #fb832# n__O__t_528_6 GND nmos W=0.0975U L=0.065U
M1177_ #509 p #510 GND nmos W=0.0975U L=0.065U
M1178_ #509 inv__p #512 GND nmos W=0.0975U L=0.065U
M1179_ #518 I0_af_528_6 n__O__f_528_6 GND nmos W=0.0975U L=0.065U
M1180_ #520 I1_af_528_6 n__O__f_528_6 GND nmos W=0.0975U L=0.065U
M1181_ #522 I0_af_528_6 n__O__f_528_6 Vdd pmos W=0.1625U L=0.065U
M1182_ #523 I1_af_528_6 n__O__f_528_6 Vdd pmos W=0.1625U L=0.065U
M1183_keeper #836 #fb835# n__O__f_528_6 Vdd pmos W=0.0975U L=0.065U
M1184_keeper #837 #fb835# n__O__f_528_6 GND nmos W=0.0975U L=0.065U
M1185_ #517 p #518 GND nmos W=0.0975U L=0.065U
M1186_ #517 inv__p #520 GND nmos W=0.0975U L=0.065U
M1187_ #526 I0_at_529_6 n__O__t_529_6 GND nmos W=0.0975U L=0.065U
M1188_ #528 I1_at_529_6 n__O__t_529_6 GND nmos W=0.0975U L=0.065U
M1189_ #530 I0_at_529_6 n__O__t_529_6 Vdd pmos W=0.1625U L=0.065U
M1190_ #531 I1_at_529_6 n__O__t_529_6 Vdd pmos W=0.1625U L=0.065U
M1191_keeper #839 #fb838# n__O__t_529_6 Vdd pmos W=0.0975U L=0.065U
M1192_keeper #840 #fb838# n__O__t_529_6 GND nmos W=0.0975U L=0.065U
M1193_ #525 p #526 GND nmos W=0.0975U L=0.065U
M1194_ #525 inv__p #528 GND nmos W=0.0975U L=0.065U
M1195_ #534 I0_af_529_6 n__O__f_529_6 GND nmos W=0.0975U L=0.065U
M1196_ #536 I1_af_529_6 n__O__f_529_6 GND nmos W=0.0975U L=0.065U
M1197_ #538 I0_af_529_6 n__O__f_529_6 Vdd pmos W=0.1625U L=0.065U
M1198_ #539 I1_af_529_6 n__O__f_529_6 Vdd pmos W=0.1625U L=0.065U
M1199_keeper #842 #fb841# n__O__f_529_6 Vdd pmos W=0.0975U L=0.065U
M1200_keeper #843 #fb841# n__O__f_529_6 GND nmos W=0.0975U L=0.065U
M1201_ #533 p #534 GND nmos W=0.0975U L=0.065U
M1202_ #533 inv__p #536 GND nmos W=0.0975U L=0.065U
M1203_ #542 I0_at_530_6 n__O__t_530_6 GND nmos W=0.0975U L=0.065U
M1204_ #544 I1_at_530_6 n__O__t_530_6 GND nmos W=0.0975U L=0.065U
M1205_ #546 I0_at_530_6 n__O__t_530_6 Vdd pmos W=0.1625U L=0.065U
M1206_ #547 I1_at_530_6 n__O__t_530_6 Vdd pmos W=0.1625U L=0.065U
M1207_keeper #845 #fb844# n__O__t_530_6 Vdd pmos W=0.0975U L=0.065U
M1208_keeper #846 #fb844# n__O__t_530_6 GND nmos W=0.0975U L=0.065U
M1209_ #541 p #542 GND nmos W=0.0975U L=0.065U
M1210_ #541 inv__p #544 GND nmos W=0.0975U L=0.065U
M1211_ #550 I0_af_530_6 n__O__f_530_6 GND nmos W=0.0975U L=0.065U
M1212_ #552 I1_af_530_6 n__O__f_530_6 GND nmos W=0.0975U L=0.065U
M1213_ #554 I0_af_530_6 n__O__f_530_6 Vdd pmos W=0.1625U L=0.065U
M1214_ #555 I1_af_530_6 n__O__f_530_6 Vdd pmos W=0.1625U L=0.065U
M1215_keeper #848 #fb847# n__O__f_530_6 Vdd pmos W=0.0975U L=0.065U
M1216_keeper #849 #fb847# n__O__f_530_6 GND nmos W=0.0975U L=0.065U
M1217_ #549 p #550 GND nmos W=0.0975U L=0.065U
M1218_ #549 inv__p #552 GND nmos W=0.0975U L=0.065U
M1219_ #558 I0_at_531_6 n__O__t_531_6 GND nmos W=0.0975U L=0.065U
M1220_ #560 I1_at_531_6 n__O__t_531_6 GND nmos W=0.0975U L=0.065U
M1221_ #562 I0_at_531_6 n__O__t_531_6 Vdd pmos W=0.1625U L=0.065U
M1222_ #563 I1_at_531_6 n__O__t_531_6 Vdd pmos W=0.1625U L=0.065U
M1223_keeper #851 #fb850# n__O__t_531_6 Vdd pmos W=0.0975U L=0.065U
M1224_keeper #852 #fb850# n__O__t_531_6 GND nmos W=0.0975U L=0.065U
M1225_ #557 p #558 GND nmos W=0.0975U L=0.065U
M1226_ #557 inv__p #560 GND nmos W=0.0975U L=0.065U
M1227_ #566 I0_af_531_6 n__O__f_531_6 GND nmos W=0.0975U L=0.065U
M1228_ #568 I1_af_531_6 n__O__f_531_6 GND nmos W=0.0975U L=0.065U
M1229_ #570 I0_af_531_6 n__O__f_531_6 Vdd pmos W=0.1625U L=0.065U
M1230_ #571 I1_af_531_6 n__O__f_531_6 Vdd pmos W=0.1625U L=0.065U
M1231_keeper #854 #fb853# n__O__f_531_6 Vdd pmos W=0.0975U L=0.065U
M1232_keeper #855 #fb853# n__O__f_531_6 GND nmos W=0.0975U L=0.065U
M1233_ #565 p #566 GND nmos W=0.0975U L=0.065U
M1234_ #565 inv__p #568 GND nmos W=0.0975U L=0.065U
.ends
*---- end of process: Arb2<> -----
*
*---- act defproc: Arb<> -----
* raw ports:  reset C0.t[0] C0.t[1] C0.t[2] C0.t[3] C0.t[4] C0.t[5] C0.t[6] C0.t[7] C0.t[8] C0.t[9] C0.t[10] C0.t[11] C0.t[12] C0.t[13] C0.t[14] C0.t[15] C0.t[16] C0.t[17] C0.t[18] C0.t[19] C0.t[20] C0.t[21] C0.t[22] C0.t[23] C0.t[24] C0.t[25] C0.t[26] C0.t[27] C0.t[28] C0.t[29] C0.t[30] C0.t[31] C0.f[0] C0.f[1] C0.f[2] C0.f[3] C0.f[4] C0.f[5] C0.f[6] C0.f[7] C0.f[8] C0.f[9] C0.f[10] C0.f[11] C0.f[12] C0.f[13] C0.f[14] C0.f[15] C0.f[16] C0.f[17] C0.f[18] C0.f[19] C0.f[20] C0.f[21] C0.f[22] C0.f[23] C0.f[24] C0.f[25] C0.f[26] C0.f[27] C0.f[28] C0.f[29] C0.f[30] C0.f[31] C0.a C1.t[0] C1.t[1] C1.t[2] C1.t[3] C1.t[4] C1.t[5] C1.t[6] C1.t[7] C1.t[8] C1.t[9] C1.t[10] C1.t[11] C1.t[12] C1.t[13] C1.t[14] C1.t[15] C1.t[16] C1.t[17] C1.t[18] C1.t[19] C1.t[20] C1.t[21] C1.t[22] C1.t[23] C1.t[24] C1.t[25] C1.t[26] C1.t[27] C1.t[28] C1.t[29] C1.t[30] C1.t[31] C1.f[0] C1.f[1] C1.f[2] C1.f[3] C1.f[4] C1.f[5] C1.f[6] C1.f[7] C1.f[8] C1.f[9] C1.f[10] C1.f[11] C1.f[12] C1.f[13] C1.f[14] C1.f[15] C1.f[16] C1.f[17] C1.f[18] C1.f[19] C1.f[20] C1.f[21] C1.f[22] C1.f[23] C1.f[24] C1.f[25] C1.f[26] C1.f[27] C1.f[28] C1.f[29] C1.f[30] C1.f[31] C1.a C2.t[0] C2.t[1] C2.t[2] C2.t[3] C2.t[4] C2.t[5] C2.t[6] C2.t[7] C2.t[8] C2.t[9] C2.t[10] C2.t[11] C2.t[12] C2.t[13] C2.t[14] C2.t[15] C2.t[16] C2.t[17] C2.t[18] C2.t[19] C2.t[20] C2.t[21] C2.t[22] C2.t[23] C2.t[24] C2.t[25] C2.t[26] C2.t[27] C2.t[28] C2.t[29] C2.t[30] C2.t[31] C2.f[0] C2.f[1] C2.f[2] C2.f[3] C2.f[4] C2.f[5] C2.f[6] C2.f[7] C2.f[8] C2.f[9] C2.f[10] C2.f[11] C2.f[12] C2.f[13] C2.f[14] C2.f[15] C2.f[16] C2.f[17] C2.f[18] C2.f[19] C2.f[20] C2.f[21] C2.f[22] C2.f[23] C2.f[24] C2.f[25] C2.f[26] C2.f[27] C2.f[28] C2.f[29] C2.f[30] C2.f[31] C2.a C3.t[0] C3.t[1] C3.t[2] C3.t[3] C3.t[4] C3.t[5] C3.t[6] C3.t[7] C3.t[8] C3.t[9] C3.t[10] C3.t[11] C3.t[12] C3.t[13] C3.t[14] C3.t[15] C3.t[16] C3.t[17] C3.t[18] C3.t[19] C3.t[20] C3.t[21] C3.t[22] C3.t[23] C3.t[24] C3.t[25] C3.t[26] C3.t[27] C3.t[28] C3.t[29] C3.t[30] C3.t[31] C3.f[0] C3.f[1] C3.f[2] C3.f[3] C3.f[4] C3.f[5] C3.f[6] C3.f[7] C3.f[8] C3.f[9] C3.f[10] C3.f[11] C3.f[12] C3.f[13] C3.f[14] C3.f[15] C3.f[16] C3.f[17] C3.f[18] C3.f[19] C3.f[20] C3.f[21] C3.f[22] C3.f[23] C3.f[24] C3.f[25] C3.f[26] C3.f[27] C3.f[28] C3.f[29] C3.f[30] C3.f[31] C3.a P.t[0] P.t[1] P.t[2] P.t[3] P.t[4] P.t[5] P.t[6] P.t[7] P.t[8] P.t[9] P.t[10] P.t[11] P.t[12] P.t[13] P.t[14] P.t[15] P.t[16] P.t[17] P.t[18] P.t[19] P.t[20] P.t[21] P.t[22] P.t[23] P.t[24] P.t[25] P.t[26] P.t[27] P.t[28] P.t[29] P.t[30] P.t[31] P.f[0] P.f[1] P.f[2] P.f[3] P.f[4] P.f[5] P.f[6] P.f[7] P.f[8] P.f[9] P.f[10] P.f[11] P.f[12] P.f[13] P.f[14] P.f[15] P.f[16] P.f[17] P.f[18] P.f[19] P.f[20] P.f[21] P.f[22] P.f[23] P.f[24] P.f[25] P.f[26] P.f[27] P.f[28] P.f[29] P.f[30] P.f[31] P.a M.t[0] M.t[1] M.t[2] M.t[3] M.t[4] M.t[5] M.t[6] M.t[7] M.t[8] M.t[9] M.t[10] M.t[11] M.t[12] M.t[13] M.t[14] M.t[15] M.t[16] M.t[17] M.t[18] M.t[19] M.t[20] M.t[21] M.t[22] M.t[23] M.t[24] M.t[25] M.t[26] M.t[27] M.t[28] M.t[29] M.t[30] M.t[31] M.f[0] M.f[1] M.f[2] M.f[3] M.f[4] M.f[5] M.f[6] M.f[7] M.f[8] M.f[9] M.f[10] M.f[11] M.f[12] M.f[13] M.f[14] M.f[15] M.f[16] M.f[17] M.f[18] M.f[19] M.f[20] M.f[21] M.f[22] M.f[23] M.f[24] M.f[25] M.f[26] M.f[27] M.f[28] M.f[29] M.f[30] M.f[31] M.a O.t[0] O.t[1] O.t[2] O.t[3] O.t[4] O.t[5] O.t[6] O.t[7] O.t[8] O.t[9] O.t[10] O.t[11] O.t[12] O.t[13] O.t[14] O.t[15] O.t[16] O.t[17] O.t[18] O.t[19] O.t[20] O.t[21] O.t[22] O.t[23] O.t[24] O.t[25] O.t[26] O.t[27] O.t[28] O.t[29] O.t[30] O.t[31] O.f[0] O.f[1] O.f[2] O.f[3] O.f[4] O.f[5] O.f[6] O.f[7] O.f[8] O.f[9] O.f[10] O.f[11] O.f[12] O.f[13] O.f[14] O.f[15] O.f[16] O.f[17] O.f[18] O.f[19] O.f[20] O.f[21] O.f[22] O.f[23] O.f[24] O.f[25] O.f[26] O.f[27] O.f[28] O.f[29] O.f[30] O.f[31] O.a
*
.subckt Arb reset C0_at_50_6 C0_at_51_6 C0_at_52_6 C0_at_53_6 C0_at_54_6 C0_at_55_6 C0_at_56_6 C0_at_57_6 C0_at_58_6 C0_at_59_6 C0_at_510_6 C0_at_511_6 C0_at_512_6 C0_at_513_6 C0_at_514_6 C0_at_515_6 C0_at_516_6 C0_at_517_6 C0_at_518_6 C0_at_519_6 C0_at_520_6 C0_at_521_6 C0_at_522_6 C0_at_523_6 C0_at_524_6 C0_at_525_6 C0_at_526_6 C0_at_527_6 C0_at_528_6 C0_at_529_6 C0_at_530_6 C0_at_531_6 C0_af_50_6 C0_af_51_6 C0_af_52_6 C0_af_53_6 C0_af_54_6 C0_af_55_6 C0_af_56_6 C0_af_57_6 C0_af_58_6 C0_af_59_6 C0_af_510_6 C0_af_511_6 C0_af_512_6 C0_af_513_6 C0_af_514_6 C0_af_515_6 C0_af_516_6 C0_af_517_6 C0_af_518_6 C0_af_519_6 C0_af_520_6 C0_af_521_6 C0_af_522_6 C0_af_523_6 C0_af_524_6 C0_af_525_6 C0_af_526_6 C0_af_527_6 C0_af_528_6 C0_af_529_6 C0_af_530_6 C0_af_531_6 C0_aa C1_at_50_6 C1_at_51_6 C1_at_52_6 C1_at_53_6 C1_at_54_6 C1_at_55_6 C1_at_56_6 C1_at_57_6 C1_at_58_6 C1_at_59_6 C1_at_510_6 C1_at_511_6 C1_at_512_6 C1_at_513_6 C1_at_514_6 C1_at_515_6 C1_at_516_6 C1_at_517_6 C1_at_518_6 C1_at_519_6 C1_at_520_6 C1_at_521_6 C1_at_522_6 C1_at_523_6 C1_at_524_6 C1_at_525_6 C1_at_526_6 C1_at_527_6 C1_at_528_6 C1_at_529_6 C1_at_530_6 C1_at_531_6 C1_af_50_6 C1_af_51_6 C1_af_52_6 C1_af_53_6 C1_af_54_6 C1_af_55_6 C1_af_56_6 C1_af_57_6 C1_af_58_6 C1_af_59_6 C1_af_510_6 C1_af_511_6 C1_af_512_6 C1_af_513_6 C1_af_514_6 C1_af_515_6 C1_af_516_6 C1_af_517_6 C1_af_518_6 C1_af_519_6 C1_af_520_6 C1_af_521_6 C1_af_522_6 C1_af_523_6 C1_af_524_6 C1_af_525_6 C1_af_526_6 C1_af_527_6 C1_af_528_6 C1_af_529_6 C1_af_530_6 C1_af_531_6 C1_aa C2_at_50_6 C2_at_51_6 C2_at_52_6 C2_at_53_6 C2_at_54_6 C2_at_55_6 C2_at_56_6 C2_at_57_6 C2_at_58_6 C2_at_59_6 C2_at_510_6 C2_at_511_6 C2_at_512_6 C2_at_513_6 C2_at_514_6 C2_at_515_6 C2_at_516_6 C2_at_517_6 C2_at_518_6 C2_at_519_6 C2_at_520_6 C2_at_521_6 C2_at_522_6 C2_at_523_6 C2_at_524_6 C2_at_525_6 C2_at_526_6 C2_at_527_6 C2_at_528_6 C2_at_529_6 C2_at_530_6 C2_at_531_6 C2_af_50_6 C2_af_51_6 C2_af_52_6 C2_af_53_6 C2_af_54_6 C2_af_55_6 C2_af_56_6 C2_af_57_6 C2_af_58_6 C2_af_59_6 C2_af_510_6 C2_af_511_6 C2_af_512_6 C2_af_513_6 C2_af_514_6 C2_af_515_6 C2_af_516_6 C2_af_517_6 C2_af_518_6 C2_af_519_6 C2_af_520_6 C2_af_521_6 C2_af_522_6 C2_af_523_6 C2_af_524_6 C2_af_525_6 C2_af_526_6 C2_af_527_6 C2_af_528_6 C2_af_529_6 C2_af_530_6 C2_af_531_6 C2_aa C3_at_50_6 C3_at_51_6 C3_at_52_6 C3_at_53_6 C3_at_54_6 C3_at_55_6 C3_at_56_6 C3_at_57_6 C3_at_58_6 C3_at_59_6 C3_at_510_6 C3_at_511_6 C3_at_512_6 C3_at_513_6 C3_at_514_6 C3_at_515_6 C3_at_516_6 C3_at_517_6 C3_at_518_6 C3_at_519_6 C3_at_520_6 C3_at_521_6 C3_at_522_6 C3_at_523_6 C3_at_524_6 C3_at_525_6 C3_at_526_6 C3_at_527_6 C3_at_528_6 C3_at_529_6 C3_at_530_6 C3_at_531_6 C3_af_50_6 C3_af_51_6 C3_af_52_6 C3_af_53_6 C3_af_54_6 C3_af_55_6 C3_af_56_6 C3_af_57_6 C3_af_58_6 C3_af_59_6 C3_af_510_6 C3_af_511_6 C3_af_512_6 C3_af_513_6 C3_af_514_6 C3_af_515_6 C3_af_516_6 C3_af_517_6 C3_af_518_6 C3_af_519_6 C3_af_520_6 C3_af_521_6 C3_af_522_6 C3_af_523_6 C3_af_524_6 C3_af_525_6 C3_af_526_6 C3_af_527_6 C3_af_528_6 C3_af_529_6 C3_af_530_6 C3_af_531_6 C3_aa P_at_50_6 P_at_51_6 P_at_52_6 P_at_53_6 P_at_54_6 P_at_55_6 P_at_56_6 P_at_57_6 P_at_58_6 P_at_59_6 P_at_510_6 P_at_511_6 P_at_512_6 P_at_513_6 P_at_514_6 P_at_515_6 P_at_516_6 P_at_517_6 P_at_518_6 P_at_519_6 P_at_520_6 P_at_521_6 P_at_522_6 P_at_523_6 P_at_524_6 P_at_525_6 P_at_526_6 P_at_527_6 P_at_528_6 P_at_529_6 P_at_530_6 P_at_531_6 P_af_50_6 P_af_51_6 P_af_52_6 P_af_53_6 P_af_54_6 P_af_55_6 P_af_56_6 P_af_57_6 P_af_58_6 P_af_59_6 P_af_510_6 P_af_511_6 P_af_512_6 P_af_513_6 P_af_514_6 P_af_515_6 P_af_516_6 P_af_517_6 P_af_518_6 P_af_519_6 P_af_520_6 P_af_521_6 P_af_522_6 P_af_523_6 P_af_524_6 P_af_525_6 P_af_526_6 P_af_527_6 P_af_528_6 P_af_529_6 P_af_530_6 P_af_531_6 P_aa M_at_50_6 M_at_51_6 M_at_52_6 M_at_53_6 M_at_54_6 M_at_55_6 M_at_56_6 M_at_57_6 M_at_58_6 M_at_59_6 M_at_510_6 M_at_511_6 M_at_512_6 M_at_513_6 M_at_514_6 M_at_515_6 M_at_516_6 M_at_517_6 M_at_518_6 M_at_519_6 M_at_520_6 M_at_521_6 M_at_522_6 M_at_523_6 M_at_524_6 M_at_525_6 M_at_526_6 M_at_527_6 M_at_528_6 M_at_529_6 M_at_530_6 M_at_531_6 M_af_50_6 M_af_51_6 M_af_52_6 M_af_53_6 M_af_54_6 M_af_55_6 M_af_56_6 M_af_57_6 M_af_58_6 M_af_59_6 M_af_510_6 M_af_511_6 M_af_512_6 M_af_513_6 M_af_514_6 M_af_515_6 M_af_516_6 M_af_517_6 M_af_518_6 M_af_519_6 M_af_520_6 M_af_521_6 M_af_522_6 M_af_523_6 M_af_524_6 M_af_525_6 M_af_526_6 M_af_527_6 M_af_528_6 M_af_529_6 M_af_530_6 M_af_531_6 M_aa O_at_50_6 O_at_51_6 O_at_52_6 O_at_53_6 O_at_54_6 O_at_55_6 O_at_56_6 O_at_57_6 O_at_58_6 O_at_59_6 O_at_510_6 O_at_511_6 O_at_512_6 O_at_513_6 O_at_514_6 O_at_515_6 O_at_516_6 O_at_517_6 O_at_518_6 O_at_519_6 O_at_520_6 O_at_521_6 O_at_522_6 O_at_523_6 O_at_524_6 O_at_525_6 O_at_526_6 O_at_527_6 O_at_528_6 O_at_529_6 O_at_530_6 O_at_531_6 O_af_50_6 O_af_51_6 O_af_52_6 O_af_53_6 O_af_54_6 O_af_55_6 O_af_56_6 O_af_57_6 O_af_58_6 O_af_59_6 O_af_510_6 O_af_511_6 O_af_512_6 O_af_513_6 O_af_514_6 O_af_515_6 O_af_516_6 O_af_517_6 O_af_518_6 O_af_519_6 O_af_520_6 O_af_521_6 O_af_522_6 O_af_523_6 O_af_524_6 O_af_525_6 O_af_526_6 O_af_527_6 O_af_528_6 O_af_529_6 O_af_530_6 O_af_531_6 O_aa
*.PININFO reset:I C0_at_50_6:I C0_at_51_6:I C0_at_52_6:I C0_at_53_6:I C0_at_54_6:I C0_at_55_6:I C0_at_56_6:I C0_at_57_6:I C0_at_58_6:I C0_at_59_6:I C0_at_510_6:I C0_at_511_6:I C0_at_512_6:I C0_at_513_6:I C0_at_514_6:I C0_at_515_6:I C0_at_516_6:I C0_at_517_6:I C0_at_518_6:I C0_at_519_6:I C0_at_520_6:I C0_at_521_6:I C0_at_522_6:I C0_at_523_6:I C0_at_524_6:I C0_at_525_6:I C0_at_526_6:I C0_at_527_6:I C0_at_528_6:I C0_at_529_6:I C0_at_530_6:I C0_at_531_6:I C0_af_50_6:I C0_af_51_6:I C0_af_52_6:I C0_af_53_6:I C0_af_54_6:I C0_af_55_6:I C0_af_56_6:I C0_af_57_6:I C0_af_58_6:I C0_af_59_6:I C0_af_510_6:I C0_af_511_6:I C0_af_512_6:I C0_af_513_6:I C0_af_514_6:I C0_af_515_6:I C0_af_516_6:I C0_af_517_6:I C0_af_518_6:I C0_af_519_6:I C0_af_520_6:I C0_af_521_6:I C0_af_522_6:I C0_af_523_6:I C0_af_524_6:I C0_af_525_6:I C0_af_526_6:I C0_af_527_6:I C0_af_528_6:I C0_af_529_6:I C0_af_530_6:I C0_af_531_6:I C0_aa:O C1_at_50_6:I C1_at_51_6:I C1_at_52_6:I C1_at_53_6:I C1_at_54_6:I C1_at_55_6:I C1_at_56_6:I C1_at_57_6:I C1_at_58_6:I C1_at_59_6:I C1_at_510_6:I C1_at_511_6:I C1_at_512_6:I C1_at_513_6:I C1_at_514_6:I C1_at_515_6:I C1_at_516_6:I C1_at_517_6:I C1_at_518_6:I C1_at_519_6:I C1_at_520_6:I C1_at_521_6:I C1_at_522_6:I C1_at_523_6:I C1_at_524_6:I C1_at_525_6:I C1_at_526_6:I C1_at_527_6:I C1_at_528_6:I C1_at_529_6:I C1_at_530_6:I C1_at_531_6:I C1_af_50_6:I C1_af_51_6:I C1_af_52_6:I C1_af_53_6:I C1_af_54_6:I C1_af_55_6:I C1_af_56_6:I C1_af_57_6:I C1_af_58_6:I C1_af_59_6:I C1_af_510_6:I C1_af_511_6:I C1_af_512_6:I C1_af_513_6:I C1_af_514_6:I C1_af_515_6:I C1_af_516_6:I C1_af_517_6:I C1_af_518_6:I C1_af_519_6:I C1_af_520_6:I C1_af_521_6:I C1_af_522_6:I C1_af_523_6:I C1_af_524_6:I C1_af_525_6:I C1_af_526_6:I C1_af_527_6:I C1_af_528_6:I C1_af_529_6:I C1_af_530_6:I C1_af_531_6:I C1_aa:O C2_at_50_6:I C2_at_51_6:I C2_at_52_6:I C2_at_53_6:I C2_at_54_6:I C2_at_55_6:I C2_at_56_6:I C2_at_57_6:I C2_at_58_6:I C2_at_59_6:I C2_at_510_6:I C2_at_511_6:I C2_at_512_6:I C2_at_513_6:I C2_at_514_6:I C2_at_515_6:I C2_at_516_6:I C2_at_517_6:I C2_at_518_6:I C2_at_519_6:I C2_at_520_6:I C2_at_521_6:I C2_at_522_6:I C2_at_523_6:I C2_at_524_6:I C2_at_525_6:I C2_at_526_6:I C2_at_527_6:I C2_at_528_6:I C2_at_529_6:I C2_at_530_6:I C2_at_531_6:I C2_af_50_6:I C2_af_51_6:I C2_af_52_6:I C2_af_53_6:I C2_af_54_6:I C2_af_55_6:I C2_af_56_6:I C2_af_57_6:I C2_af_58_6:I C2_af_59_6:I C2_af_510_6:I C2_af_511_6:I C2_af_512_6:I C2_af_513_6:I C2_af_514_6:I C2_af_515_6:I C2_af_516_6:I C2_af_517_6:I C2_af_518_6:I C2_af_519_6:I C2_af_520_6:I C2_af_521_6:I C2_af_522_6:I C2_af_523_6:I C2_af_524_6:I C2_af_525_6:I C2_af_526_6:I C2_af_527_6:I C2_af_528_6:I C2_af_529_6:I C2_af_530_6:I C2_af_531_6:I C2_aa:O C3_at_50_6:I C3_at_51_6:I C3_at_52_6:I C3_at_53_6:I C3_at_54_6:I C3_at_55_6:I C3_at_56_6:I C3_at_57_6:I C3_at_58_6:I C3_at_59_6:I C3_at_510_6:I C3_at_511_6:I C3_at_512_6:I C3_at_513_6:I C3_at_514_6:I C3_at_515_6:I C3_at_516_6:I C3_at_517_6:I C3_at_518_6:I C3_at_519_6:I C3_at_520_6:I C3_at_521_6:I C3_at_522_6:I C3_at_523_6:I C3_at_524_6:I C3_at_525_6:I C3_at_526_6:I C3_at_527_6:I C3_at_528_6:I C3_at_529_6:I C3_at_530_6:I C3_at_531_6:I C3_af_50_6:I C3_af_51_6:I C3_af_52_6:I C3_af_53_6:I C3_af_54_6:I C3_af_55_6:I C3_af_56_6:I C3_af_57_6:I C3_af_58_6:I C3_af_59_6:I C3_af_510_6:I C3_af_511_6:I C3_af_512_6:I C3_af_513_6:I C3_af_514_6:I C3_af_515_6:I C3_af_516_6:I C3_af_517_6:I C3_af_518_6:I C3_af_519_6:I C3_af_520_6:I C3_af_521_6:I C3_af_522_6:I C3_af_523_6:I C3_af_524_6:I C3_af_525_6:I C3_af_526_6:I C3_af_527_6:I C3_af_528_6:I C3_af_529_6:I C3_af_530_6:I C3_af_531_6:I C3_aa:O P_at_50_6:I P_at_51_6:I P_at_52_6:I P_at_53_6:I P_at_54_6:I P_at_55_6:I P_at_56_6:I P_at_57_6:I P_at_58_6:I P_at_59_6:I P_at_510_6:I P_at_511_6:I P_at_512_6:I P_at_513_6:I P_at_514_6:I P_at_515_6:I P_at_516_6:I P_at_517_6:I P_at_518_6:I P_at_519_6:I P_at_520_6:I P_at_521_6:I P_at_522_6:I P_at_523_6:I P_at_524_6:I P_at_525_6:I P_at_526_6:I P_at_527_6:I P_at_528_6:I P_at_529_6:I P_at_530_6:I P_at_531_6:I P_af_50_6:I P_af_51_6:I P_af_52_6:I P_af_53_6:I P_af_54_6:I P_af_55_6:I P_af_56_6:I P_af_57_6:I P_af_58_6:I P_af_59_6:I P_af_510_6:I P_af_511_6:I P_af_512_6:I P_af_513_6:I P_af_514_6:I P_af_515_6:I P_af_516_6:I P_af_517_6:I P_af_518_6:I P_af_519_6:I P_af_520_6:I P_af_521_6:I P_af_522_6:I P_af_523_6:I P_af_524_6:I P_af_525_6:I P_af_526_6:I P_af_527_6:I P_af_528_6:I P_af_529_6:I P_af_530_6:I P_af_531_6:I P_aa:O M_at_50_6:I M_at_51_6:I M_at_52_6:I M_at_53_6:I M_at_54_6:I M_at_55_6:I M_at_56_6:I M_at_57_6:I M_at_58_6:I M_at_59_6:I M_at_510_6:I M_at_511_6:I M_at_512_6:I M_at_513_6:I M_at_514_6:I M_at_515_6:I M_at_516_6:I M_at_517_6:I M_at_518_6:I M_at_519_6:I M_at_520_6:I M_at_521_6:I M_at_522_6:I M_at_523_6:I M_at_524_6:I M_at_525_6:I M_at_526_6:I M_at_527_6:I M_at_528_6:I M_at_529_6:I M_at_530_6:I M_at_531_6:I M_af_50_6:I M_af_51_6:I M_af_52_6:I M_af_53_6:I M_af_54_6:I M_af_55_6:I M_af_56_6:I M_af_57_6:I M_af_58_6:I M_af_59_6:I M_af_510_6:I M_af_511_6:I M_af_512_6:I M_af_513_6:I M_af_514_6:I M_af_515_6:I M_af_516_6:I M_af_517_6:I M_af_518_6:I M_af_519_6:I M_af_520_6:I M_af_521_6:I M_af_522_6:I M_af_523_6:I M_af_524_6:I M_af_525_6:I M_af_526_6:I M_af_527_6:I M_af_528_6:I M_af_529_6:I M_af_530_6:I M_af_531_6:I M_aa:O O_at_50_6:O O_at_51_6:O O_at_52_6:O O_at_53_6:O O_at_54_6:O O_at_55_6:O O_at_56_6:O O_at_57_6:O O_at_58_6:O O_at_59_6:O O_at_510_6:O O_at_511_6:O O_at_512_6:O O_at_513_6:O O_at_514_6:O O_at_515_6:O O_at_516_6:O O_at_517_6:O O_at_518_6:O O_at_519_6:O O_at_520_6:O O_at_521_6:O O_at_522_6:O O_at_523_6:O O_at_524_6:O O_at_525_6:O O_at_526_6:O O_at_527_6:O O_at_528_6:O O_at_529_6:O O_at_530_6:O O_at_531_6:O O_af_50_6:O O_af_51_6:O O_af_52_6:O O_af_53_6:O O_af_54_6:O O_af_55_6:O O_af_56_6:O O_af_57_6:O O_af_58_6:O O_af_59_6:O O_af_510_6:O O_af_511_6:O O_af_512_6:O O_af_513_6:O O_af_514_6:O O_af_515_6:O O_af_516_6:O O_af_517_6:O O_af_518_6:O O_af_519_6:O O_af_520_6:O O_af_521_6:O O_af_522_6:O O_af_523_6:O O_af_524_6:O O_af_525_6:O O_af_526_6:O O_af_527_6:O O_af_528_6:O O_af_529_6:O O_af_530_6:O O_af_531_6:O O_aa:I
*.POWER VDD Vdd
*.POWER GND GND
*.POWER NSUB GND
*.POWER PSUB Vdd
xar4 reset ar2_aO_at_50_6 ar2_aO_at_51_6 ar2_aO_at_52_6 ar2_aO_at_53_6 ar2_aO_at_54_6 ar2_aO_at_55_6 ar2_aO_at_56_6 ar2_aO_at_57_6 ar2_aO_at_58_6 ar2_aO_at_59_6 ar2_aO_at_510_6 ar2_aO_at_511_6 ar2_aO_at_512_6 ar2_aO_at_513_6 ar2_aO_at_514_6 ar2_aO_at_515_6 ar2_aO_at_516_6 ar2_aO_at_517_6 ar2_aO_at_518_6 ar2_aO_at_519_6 ar2_aO_at_520_6 ar2_aO_at_521_6 ar2_aO_at_522_6 ar2_aO_at_523_6 ar2_aO_at_524_6 ar2_aO_at_525_6 ar2_aO_at_526_6 ar2_aO_at_527_6 ar2_aO_at_528_6 ar2_aO_at_529_6 ar2_aO_at_530_6 ar2_aO_at_531_6 ar2_aO_af_50_6 ar2_aO_af_51_6 ar2_aO_af_52_6 ar2_aO_af_53_6 ar2_aO_af_54_6 ar2_aO_af_55_6 ar2_aO_af_56_6 ar2_aO_af_57_6 ar2_aO_af_58_6 ar2_aO_af_59_6 ar2_aO_af_510_6 ar2_aO_af_511_6 ar2_aO_af_512_6 ar2_aO_af_513_6 ar2_aO_af_514_6 ar2_aO_af_515_6 ar2_aO_af_516_6 ar2_aO_af_517_6 ar2_aO_af_518_6 ar2_aO_af_519_6 ar2_aO_af_520_6 ar2_aO_af_521_6 ar2_aO_af_522_6 ar2_aO_af_523_6 ar2_aO_af_524_6 ar2_aO_af_525_6 ar2_aO_af_526_6 ar2_aO_af_527_6 ar2_aO_af_528_6 ar2_aO_af_529_6 ar2_aO_af_530_6 ar2_aO_af_531_6 ar2_aO_aa ar3_aO_at_50_6 ar3_aO_at_51_6 ar3_aO_at_52_6 ar3_aO_at_53_6 ar3_aO_at_54_6 ar3_aO_at_55_6 ar3_aO_at_56_6 ar3_aO_at_57_6 ar3_aO_at_58_6 ar3_aO_at_59_6 ar3_aO_at_510_6 ar3_aO_at_511_6 ar3_aO_at_512_6 ar3_aO_at_513_6 ar3_aO_at_514_6 ar3_aO_at_515_6 ar3_aO_at_516_6 ar3_aO_at_517_6 ar3_aO_at_518_6 ar3_aO_at_519_6 ar3_aO_at_520_6 ar3_aO_at_521_6 ar3_aO_at_522_6 ar3_aO_at_523_6 ar3_aO_at_524_6 ar3_aO_at_525_6 ar3_aO_at_526_6 ar3_aO_at_527_6 ar3_aO_at_528_6 ar3_aO_at_529_6 ar3_aO_at_530_6 ar3_aO_at_531_6 ar3_aO_af_50_6 ar3_aO_af_51_6 ar3_aO_af_52_6 ar3_aO_af_53_6 ar3_aO_af_54_6 ar3_aO_af_55_6 ar3_aO_af_56_6 ar3_aO_af_57_6 ar3_aO_af_58_6 ar3_aO_af_59_6 ar3_aO_af_510_6 ar3_aO_af_511_6 ar3_aO_af_512_6 ar3_aO_af_513_6 ar3_aO_af_514_6 ar3_aO_af_515_6 ar3_aO_af_516_6 ar3_aO_af_517_6 ar3_aO_af_518_6 ar3_aO_af_519_6 ar3_aO_af_520_6 ar3_aO_af_521_6 ar3_aO_af_522_6 ar3_aO_af_523_6 ar3_aO_af_524_6 ar3_aO_af_525_6 ar3_aO_af_526_6 ar3_aO_af_527_6 ar3_aO_af_528_6 ar3_aO_af_529_6 ar3_aO_af_530_6 ar3_aO_af_531_6 ar3_aO_aa O_at_50_6 O_at_51_6 O_at_52_6 O_at_53_6 O_at_54_6 O_at_55_6 O_at_56_6 O_at_57_6 O_at_58_6 O_at_59_6 O_at_510_6 O_at_511_6 O_at_512_6 O_at_513_6 O_at_514_6 O_at_515_6 O_at_516_6 O_at_517_6 O_at_518_6 O_at_519_6 O_at_520_6 O_at_521_6 O_at_522_6 O_at_523_6 O_at_524_6 O_at_525_6 O_at_526_6 O_at_527_6 O_at_528_6 O_at_529_6 O_at_530_6 O_at_531_6 O_af_50_6 O_af_51_6 O_af_52_6 O_af_53_6 O_af_54_6 O_af_55_6 O_af_56_6 O_af_57_6 O_af_58_6 O_af_59_6 O_af_510_6 O_af_511_6 O_af_512_6 O_af_513_6 O_af_514_6 O_af_515_6 O_af_516_6 O_af_517_6 O_af_518_6 O_af_519_6 O_af_520_6 O_af_521_6 O_af_522_6 O_af_523_6 O_af_524_6 O_af_525_6 O_af_526_6 O_af_527_6 O_af_528_6 O_af_529_6 O_af_530_6 O_af_531_6 O_aa Arb2
xar1 reset C2_at_50_6 C2_at_51_6 C2_at_52_6 C2_at_53_6 C2_at_54_6 C2_at_55_6 C2_at_56_6 C2_at_57_6 C2_at_58_6 C2_at_59_6 C2_at_510_6 C2_at_511_6 C2_at_512_6 C2_at_513_6 C2_at_514_6 C2_at_515_6 C2_at_516_6 C2_at_517_6 C2_at_518_6 C2_at_519_6 C2_at_520_6 C2_at_521_6 C2_at_522_6 C2_at_523_6 C2_at_524_6 C2_at_525_6 C2_at_526_6 C2_at_527_6 C2_at_528_6 C2_at_529_6 C2_at_530_6 C2_at_531_6 C2_af_50_6 C2_af_51_6 C2_af_52_6 C2_af_53_6 C2_af_54_6 C2_af_55_6 C2_af_56_6 C2_af_57_6 C2_af_58_6 C2_af_59_6 C2_af_510_6 C2_af_511_6 C2_af_512_6 C2_af_513_6 C2_af_514_6 C2_af_515_6 C2_af_516_6 C2_af_517_6 C2_af_518_6 C2_af_519_6 C2_af_520_6 C2_af_521_6 C2_af_522_6 C2_af_523_6 C2_af_524_6 C2_af_525_6 C2_af_526_6 C2_af_527_6 C2_af_528_6 C2_af_529_6 C2_af_530_6 C2_af_531_6 C2_aa C3_at_50_6 C3_at_51_6 C3_at_52_6 C3_at_53_6 C3_at_54_6 C3_at_55_6 C3_at_56_6 C3_at_57_6 C3_at_58_6 C3_at_59_6 C3_at_510_6 C3_at_511_6 C3_at_512_6 C3_at_513_6 C3_at_514_6 C3_at_515_6 C3_at_516_6 C3_at_517_6 C3_at_518_6 C3_at_519_6 C3_at_520_6 C3_at_521_6 C3_at_522_6 C3_at_523_6 C3_at_524_6 C3_at_525_6 C3_at_526_6 C3_at_527_6 C3_at_528_6 C3_at_529_6 C3_at_530_6 C3_at_531_6 C3_af_50_6 C3_af_51_6 C3_af_52_6 C3_af_53_6 C3_af_54_6 C3_af_55_6 C3_af_56_6 C3_af_57_6 C3_af_58_6 C3_af_59_6 C3_af_510_6 C3_af_511_6 C3_af_512_6 C3_af_513_6 C3_af_514_6 C3_af_515_6 C3_af_516_6 C3_af_517_6 C3_af_518_6 C3_af_519_6 C3_af_520_6 C3_af_521_6 C3_af_522_6 C3_af_523_6 C3_af_524_6 C3_af_525_6 C3_af_526_6 C3_af_527_6 C3_af_528_6 C3_af_529_6 C3_af_530_6 C3_af_531_6 C3_aa ar1_aO_at_50_6 ar1_aO_at_51_6 ar1_aO_at_52_6 ar1_aO_at_53_6 ar1_aO_at_54_6 ar1_aO_at_55_6 ar1_aO_at_56_6 ar1_aO_at_57_6 ar1_aO_at_58_6 ar1_aO_at_59_6 ar1_aO_at_510_6 ar1_aO_at_511_6 ar1_aO_at_512_6 ar1_aO_at_513_6 ar1_aO_at_514_6 ar1_aO_at_515_6 ar1_aO_at_516_6 ar1_aO_at_517_6 ar1_aO_at_518_6 ar1_aO_at_519_6 ar1_aO_at_520_6 ar1_aO_at_521_6 ar1_aO_at_522_6 ar1_aO_at_523_6 ar1_aO_at_524_6 ar1_aO_at_525_6 ar1_aO_at_526_6 ar1_aO_at_527_6 ar1_aO_at_528_6 ar1_aO_at_529_6 ar1_aO_at_530_6 ar1_aO_at_531_6 ar1_aO_af_50_6 ar1_aO_af_51_6 ar1_aO_af_52_6 ar1_aO_af_53_6 ar1_aO_af_54_6 ar1_aO_af_55_6 ar1_aO_af_56_6 ar1_aO_af_57_6 ar1_aO_af_58_6 ar1_aO_af_59_6 ar1_aO_af_510_6 ar1_aO_af_511_6 ar1_aO_af_512_6 ar1_aO_af_513_6 ar1_aO_af_514_6 ar1_aO_af_515_6 ar1_aO_af_516_6 ar1_aO_af_517_6 ar1_aO_af_518_6 ar1_aO_af_519_6 ar1_aO_af_520_6 ar1_aO_af_521_6 ar1_aO_af_522_6 ar1_aO_af_523_6 ar1_aO_af_524_6 ar1_aO_af_525_6 ar1_aO_af_526_6 ar1_aO_af_527_6 ar1_aO_af_528_6 ar1_aO_af_529_6 ar1_aO_af_530_6 ar1_aO_af_531_6 ar1_aO_aa Arb2
xar0 reset C0_at_50_6 C0_at_51_6 C0_at_52_6 C0_at_53_6 C0_at_54_6 C0_at_55_6 C0_at_56_6 C0_at_57_6 C0_at_58_6 C0_at_59_6 C0_at_510_6 C0_at_511_6 C0_at_512_6 C0_at_513_6 C0_at_514_6 C0_at_515_6 C0_at_516_6 C0_at_517_6 C0_at_518_6 C0_at_519_6 C0_at_520_6 C0_at_521_6 C0_at_522_6 C0_at_523_6 C0_at_524_6 C0_at_525_6 C0_at_526_6 C0_at_527_6 C0_at_528_6 C0_at_529_6 C0_at_530_6 C0_at_531_6 C0_af_50_6 C0_af_51_6 C0_af_52_6 C0_af_53_6 C0_af_54_6 C0_af_55_6 C0_af_56_6 C0_af_57_6 C0_af_58_6 C0_af_59_6 C0_af_510_6 C0_af_511_6 C0_af_512_6 C0_af_513_6 C0_af_514_6 C0_af_515_6 C0_af_516_6 C0_af_517_6 C0_af_518_6 C0_af_519_6 C0_af_520_6 C0_af_521_6 C0_af_522_6 C0_af_523_6 C0_af_524_6 C0_af_525_6 C0_af_526_6 C0_af_527_6 C0_af_528_6 C0_af_529_6 C0_af_530_6 C0_af_531_6 C0_aa C1_at_50_6 C1_at_51_6 C1_at_52_6 C1_at_53_6 C1_at_54_6 C1_at_55_6 C1_at_56_6 C1_at_57_6 C1_at_58_6 C1_at_59_6 C1_at_510_6 C1_at_511_6 C1_at_512_6 C1_at_513_6 C1_at_514_6 C1_at_515_6 C1_at_516_6 C1_at_517_6 C1_at_518_6 C1_at_519_6 C1_at_520_6 C1_at_521_6 C1_at_522_6 C1_at_523_6 C1_at_524_6 C1_at_525_6 C1_at_526_6 C1_at_527_6 C1_at_528_6 C1_at_529_6 C1_at_530_6 C1_at_531_6 C1_af_50_6 C1_af_51_6 C1_af_52_6 C1_af_53_6 C1_af_54_6 C1_af_55_6 C1_af_56_6 C1_af_57_6 C1_af_58_6 C1_af_59_6 C1_af_510_6 C1_af_511_6 C1_af_512_6 C1_af_513_6 C1_af_514_6 C1_af_515_6 C1_af_516_6 C1_af_517_6 C1_af_518_6 C1_af_519_6 C1_af_520_6 C1_af_521_6 C1_af_522_6 C1_af_523_6 C1_af_524_6 C1_af_525_6 C1_af_526_6 C1_af_527_6 C1_af_528_6 C1_af_529_6 C1_af_530_6 C1_af_531_6 C1_aa ar0_aO_at_50_6 ar0_aO_at_51_6 ar0_aO_at_52_6 ar0_aO_at_53_6 ar0_aO_at_54_6 ar0_aO_at_55_6 ar0_aO_at_56_6 ar0_aO_at_57_6 ar0_aO_at_58_6 ar0_aO_at_59_6 ar0_aO_at_510_6 ar0_aO_at_511_6 ar0_aO_at_512_6 ar0_aO_at_513_6 ar0_aO_at_514_6 ar0_aO_at_515_6 ar0_aO_at_516_6 ar0_aO_at_517_6 ar0_aO_at_518_6 ar0_aO_at_519_6 ar0_aO_at_520_6 ar0_aO_at_521_6 ar0_aO_at_522_6 ar0_aO_at_523_6 ar0_aO_at_524_6 ar0_aO_at_525_6 ar0_aO_at_526_6 ar0_aO_at_527_6 ar0_aO_at_528_6 ar0_aO_at_529_6 ar0_aO_at_530_6 ar0_aO_at_531_6 ar0_aO_af_50_6 ar0_aO_af_51_6 ar0_aO_af_52_6 ar0_aO_af_53_6 ar0_aO_af_54_6 ar0_aO_af_55_6 ar0_aO_af_56_6 ar0_aO_af_57_6 ar0_aO_af_58_6 ar0_aO_af_59_6 ar0_aO_af_510_6 ar0_aO_af_511_6 ar0_aO_af_512_6 ar0_aO_af_513_6 ar0_aO_af_514_6 ar0_aO_af_515_6 ar0_aO_af_516_6 ar0_aO_af_517_6 ar0_aO_af_518_6 ar0_aO_af_519_6 ar0_aO_af_520_6 ar0_aO_af_521_6 ar0_aO_af_522_6 ar0_aO_af_523_6 ar0_aO_af_524_6 ar0_aO_af_525_6 ar0_aO_af_526_6 ar0_aO_af_527_6 ar0_aO_af_528_6 ar0_aO_af_529_6 ar0_aO_af_530_6 ar0_aO_af_531_6 ar0_aO_aa Arb2
xar3 reset P_at_50_6 P_at_51_6 P_at_52_6 P_at_53_6 P_at_54_6 P_at_55_6 P_at_56_6 P_at_57_6 P_at_58_6 P_at_59_6 P_at_510_6 P_at_511_6 P_at_512_6 P_at_513_6 P_at_514_6 P_at_515_6 P_at_516_6 P_at_517_6 P_at_518_6 P_at_519_6 P_at_520_6 P_at_521_6 P_at_522_6 P_at_523_6 P_at_524_6 P_at_525_6 P_at_526_6 P_at_527_6 P_at_528_6 P_at_529_6 P_at_530_6 P_at_531_6 P_af_50_6 P_af_51_6 P_af_52_6 P_af_53_6 P_af_54_6 P_af_55_6 P_af_56_6 P_af_57_6 P_af_58_6 P_af_59_6 P_af_510_6 P_af_511_6 P_af_512_6 P_af_513_6 P_af_514_6 P_af_515_6 P_af_516_6 P_af_517_6 P_af_518_6 P_af_519_6 P_af_520_6 P_af_521_6 P_af_522_6 P_af_523_6 P_af_524_6 P_af_525_6 P_af_526_6 P_af_527_6 P_af_528_6 P_af_529_6 P_af_530_6 P_af_531_6 P_aa M_at_50_6 M_at_51_6 M_at_52_6 M_at_53_6 M_at_54_6 M_at_55_6 M_at_56_6 M_at_57_6 M_at_58_6 M_at_59_6 M_at_510_6 M_at_511_6 M_at_512_6 M_at_513_6 M_at_514_6 M_at_515_6 M_at_516_6 M_at_517_6 M_at_518_6 M_at_519_6 M_at_520_6 M_at_521_6 M_at_522_6 M_at_523_6 M_at_524_6 M_at_525_6 M_at_526_6 M_at_527_6 M_at_528_6 M_at_529_6 M_at_530_6 M_at_531_6 M_af_50_6 M_af_51_6 M_af_52_6 M_af_53_6 M_af_54_6 M_af_55_6 M_af_56_6 M_af_57_6 M_af_58_6 M_af_59_6 M_af_510_6 M_af_511_6 M_af_512_6 M_af_513_6 M_af_514_6 M_af_515_6 M_af_516_6 M_af_517_6 M_af_518_6 M_af_519_6 M_af_520_6 M_af_521_6 M_af_522_6 M_af_523_6 M_af_524_6 M_af_525_6 M_af_526_6 M_af_527_6 M_af_528_6 M_af_529_6 M_af_530_6 M_af_531_6 M_aa ar3_aO_at_50_6 ar3_aO_at_51_6 ar3_aO_at_52_6 ar3_aO_at_53_6 ar3_aO_at_54_6 ar3_aO_at_55_6 ar3_aO_at_56_6 ar3_aO_at_57_6 ar3_aO_at_58_6 ar3_aO_at_59_6 ar3_aO_at_510_6 ar3_aO_at_511_6 ar3_aO_at_512_6 ar3_aO_at_513_6 ar3_aO_at_514_6 ar3_aO_at_515_6 ar3_aO_at_516_6 ar3_aO_at_517_6 ar3_aO_at_518_6 ar3_aO_at_519_6 ar3_aO_at_520_6 ar3_aO_at_521_6 ar3_aO_at_522_6 ar3_aO_at_523_6 ar3_aO_at_524_6 ar3_aO_at_525_6 ar3_aO_at_526_6 ar3_aO_at_527_6 ar3_aO_at_528_6 ar3_aO_at_529_6 ar3_aO_at_530_6 ar3_aO_at_531_6 ar3_aO_af_50_6 ar3_aO_af_51_6 ar3_aO_af_52_6 ar3_aO_af_53_6 ar3_aO_af_54_6 ar3_aO_af_55_6 ar3_aO_af_56_6 ar3_aO_af_57_6 ar3_aO_af_58_6 ar3_aO_af_59_6 ar3_aO_af_510_6 ar3_aO_af_511_6 ar3_aO_af_512_6 ar3_aO_af_513_6 ar3_aO_af_514_6 ar3_aO_af_515_6 ar3_aO_af_516_6 ar3_aO_af_517_6 ar3_aO_af_518_6 ar3_aO_af_519_6 ar3_aO_af_520_6 ar3_aO_af_521_6 ar3_aO_af_522_6 ar3_aO_af_523_6 ar3_aO_af_524_6 ar3_aO_af_525_6 ar3_aO_af_526_6 ar3_aO_af_527_6 ar3_aO_af_528_6 ar3_aO_af_529_6 ar3_aO_af_530_6 ar3_aO_af_531_6 ar3_aO_aa Arb2
xar2 reset ar0_aO_at_50_6 ar0_aO_at_51_6 ar0_aO_at_52_6 ar0_aO_at_53_6 ar0_aO_at_54_6 ar0_aO_at_55_6 ar0_aO_at_56_6 ar0_aO_at_57_6 ar0_aO_at_58_6 ar0_aO_at_59_6 ar0_aO_at_510_6 ar0_aO_at_511_6 ar0_aO_at_512_6 ar0_aO_at_513_6 ar0_aO_at_514_6 ar0_aO_at_515_6 ar0_aO_at_516_6 ar0_aO_at_517_6 ar0_aO_at_518_6 ar0_aO_at_519_6 ar0_aO_at_520_6 ar0_aO_at_521_6 ar0_aO_at_522_6 ar0_aO_at_523_6 ar0_aO_at_524_6 ar0_aO_at_525_6 ar0_aO_at_526_6 ar0_aO_at_527_6 ar0_aO_at_528_6 ar0_aO_at_529_6 ar0_aO_at_530_6 ar0_aO_at_531_6 ar0_aO_af_50_6 ar0_aO_af_51_6 ar0_aO_af_52_6 ar0_aO_af_53_6 ar0_aO_af_54_6 ar0_aO_af_55_6 ar0_aO_af_56_6 ar0_aO_af_57_6 ar0_aO_af_58_6 ar0_aO_af_59_6 ar0_aO_af_510_6 ar0_aO_af_511_6 ar0_aO_af_512_6 ar0_aO_af_513_6 ar0_aO_af_514_6 ar0_aO_af_515_6 ar0_aO_af_516_6 ar0_aO_af_517_6 ar0_aO_af_518_6 ar0_aO_af_519_6 ar0_aO_af_520_6 ar0_aO_af_521_6 ar0_aO_af_522_6 ar0_aO_af_523_6 ar0_aO_af_524_6 ar0_aO_af_525_6 ar0_aO_af_526_6 ar0_aO_af_527_6 ar0_aO_af_528_6 ar0_aO_af_529_6 ar0_aO_af_530_6 ar0_aO_af_531_6 ar0_aO_aa ar1_aO_at_50_6 ar1_aO_at_51_6 ar1_aO_at_52_6 ar1_aO_at_53_6 ar1_aO_at_54_6 ar1_aO_at_55_6 ar1_aO_at_56_6 ar1_aO_at_57_6 ar1_aO_at_58_6 ar1_aO_at_59_6 ar1_aO_at_510_6 ar1_aO_at_511_6 ar1_aO_at_512_6 ar1_aO_at_513_6 ar1_aO_at_514_6 ar1_aO_at_515_6 ar1_aO_at_516_6 ar1_aO_at_517_6 ar1_aO_at_518_6 ar1_aO_at_519_6 ar1_aO_at_520_6 ar1_aO_at_521_6 ar1_aO_at_522_6 ar1_aO_at_523_6 ar1_aO_at_524_6 ar1_aO_at_525_6 ar1_aO_at_526_6 ar1_aO_at_527_6 ar1_aO_at_528_6 ar1_aO_at_529_6 ar1_aO_at_530_6 ar1_aO_at_531_6 ar1_aO_af_50_6 ar1_aO_af_51_6 ar1_aO_af_52_6 ar1_aO_af_53_6 ar1_aO_af_54_6 ar1_aO_af_55_6 ar1_aO_af_56_6 ar1_aO_af_57_6 ar1_aO_af_58_6 ar1_aO_af_59_6 ar1_aO_af_510_6 ar1_aO_af_511_6 ar1_aO_af_512_6 ar1_aO_af_513_6 ar1_aO_af_514_6 ar1_aO_af_515_6 ar1_aO_af_516_6 ar1_aO_af_517_6 ar1_aO_af_518_6 ar1_aO_af_519_6 ar1_aO_af_520_6 ar1_aO_af_521_6 ar1_aO_af_522_6 ar1_aO_af_523_6 ar1_aO_af_524_6 ar1_aO_af_525_6 ar1_aO_af_526_6 ar1_aO_af_527_6 ar1_aO_af_528_6 ar1_aO_af_529_6 ar1_aO_af_530_6 ar1_aO_af_531_6 ar1_aO_aa ar2_aO_at_50_6 ar2_aO_at_51_6 ar2_aO_at_52_6 ar2_aO_at_53_6 ar2_aO_at_54_6 ar2_aO_at_55_6 ar2_aO_at_56_6 ar2_aO_at_57_6 ar2_aO_at_58_6 ar2_aO_at_59_6 ar2_aO_at_510_6 ar2_aO_at_511_6 ar2_aO_at_512_6 ar2_aO_at_513_6 ar2_aO_at_514_6 ar2_aO_at_515_6 ar2_aO_at_516_6 ar2_aO_at_517_6 ar2_aO_at_518_6 ar2_aO_at_519_6 ar2_aO_at_520_6 ar2_aO_at_521_6 ar2_aO_at_522_6 ar2_aO_at_523_6 ar2_aO_at_524_6 ar2_aO_at_525_6 ar2_aO_at_526_6 ar2_aO_at_527_6 ar2_aO_at_528_6 ar2_aO_at_529_6 ar2_aO_at_530_6 ar2_aO_at_531_6 ar2_aO_af_50_6 ar2_aO_af_51_6 ar2_aO_af_52_6 ar2_aO_af_53_6 ar2_aO_af_54_6 ar2_aO_af_55_6 ar2_aO_af_56_6 ar2_aO_af_57_6 ar2_aO_af_58_6 ar2_aO_af_59_6 ar2_aO_af_510_6 ar2_aO_af_511_6 ar2_aO_af_512_6 ar2_aO_af_513_6 ar2_aO_af_514_6 ar2_aO_af_515_6 ar2_aO_af_516_6 ar2_aO_af_517_6 ar2_aO_af_518_6 ar2_aO_af_519_6 ar2_aO_af_520_6 ar2_aO_af_521_6 ar2_aO_af_522_6 ar2_aO_af_523_6 ar2_aO_af_524_6 ar2_aO_af_525_6 ar2_aO_af_526_6 ar2_aO_af_527_6 ar2_aO_af_528_6 ar2_aO_af_529_6 ar2_aO_af_530_6 ar2_aO_af_531_6 ar2_aO_aa Arb2
.ends
*---- end of process: Arb<> -----
*
*---- act defproc: MltcSel<> -----
* raw ports:  reset I.t[0] I.t[1] I.t[2] I.t[3] I.t[4] I.t[5] I.t[6] I.t[7] I.t[8] I.t[9] I.t[10] I.t[11] I.t[12] I.t[13] I.t[14] I.t[15] I.t[16] I.t[17] I.t[18] I.t[19] I.t[20] I.t[21] I.t[22] I.t[23] I.t[24] I.t[25] I.t[26] I.t[27] I.t[28] I.t[29] I.t[30] I.t[31] I.f[0] I.f[1] I.f[2] I.f[3] I.f[4] I.f[5] I.f[6] I.f[7] I.f[8] I.f[9] I.f[10] I.f[11] I.f[12] I.f[13] I.f[14] I.f[15] I.f[16] I.f[17] I.f[18] I.f[19] I.f[20] I.f[21] I.f[22] I.f[23] I.f[24] I.f[25] I.f[26] I.f[27] I.f[28] I.f[29] I.f[30] I.f[31] I.a O0.t[0] O0.t[1] O0.t[2] O0.t[3] O0.t[4] O0.t[5] O0.t[6] O0.t[7] O0.t[8] O0.t[9] O0.t[10] O0.t[11] O0.t[12] O0.t[13] O0.t[14] O0.t[15] O0.t[16] O0.t[17] O0.t[18] O0.t[19] O0.t[20] O0.t[21] O0.t[22] O0.t[23] O0.t[24] O0.t[25] O0.t[26] O0.t[27] O0.t[28] O0.t[29] O0.t[30] O0.t[31] O0.f[0] O0.f[1] O0.f[2] O0.f[3] O0.f[4] O0.f[5] O0.f[6] O0.f[7] O0.f[8] O0.f[9] O0.f[10] O0.f[11] O0.f[12] O0.f[13] O0.f[14] O0.f[15] O0.f[16] O0.f[17] O0.f[18] O0.f[19] O0.f[20] O0.f[21] O0.f[22] O0.f[23] O0.f[24] O0.f[25] O0.f[26] O0.f[27] O0.f[28] O0.f[29] O0.f[30] O0.f[31] O0.a O1.t[0] O1.t[1] O1.t[2] O1.t[3] O1.t[4] O1.t[5] O1.t[6] O1.t[7] O1.t[8] O1.t[9] O1.t[10] O1.t[11] O1.t[12] O1.t[13] O1.t[14] O1.t[15] O1.t[16] O1.t[17] O1.t[18] O1.t[19] O1.t[20] O1.t[21] O1.t[22] O1.t[23] O1.t[24] O1.t[25] O1.t[26] O1.t[27] O1.t[28] O1.t[29] O1.t[30] O1.t[31] O1.f[0] O1.f[1] O1.f[2] O1.f[3] O1.f[4] O1.f[5] O1.f[6] O1.f[7] O1.f[8] O1.f[9] O1.f[10] O1.f[11] O1.f[12] O1.f[13] O1.f[14] O1.f[15] O1.f[16] O1.f[17] O1.f[18] O1.f[19] O1.f[20] O1.f[21] O1.f[22] O1.f[23] O1.f[24] O1.f[25] O1.f[26] O1.f[27] O1.f[28] O1.f[29] O1.f[30] O1.f[31] O1.a
*
.subckt MltcSel reset I_at_50_6 I_at_51_6 I_at_52_6 I_at_53_6 I_at_54_6 I_at_55_6 I_at_56_6 I_at_57_6 I_at_58_6 I_at_59_6 I_at_510_6 I_at_511_6 I_at_512_6 I_at_513_6 I_at_514_6 I_at_515_6 I_at_516_6 I_at_517_6 I_at_518_6 I_at_519_6 I_at_520_6 I_at_521_6 I_at_522_6 I_at_523_6 I_at_524_6 I_at_525_6 I_at_526_6 I_at_527_6 I_at_528_6 I_at_529_6 I_at_530_6 I_at_531_6 I_af_50_6 I_af_51_6 I_af_52_6 I_af_53_6 I_af_54_6 I_af_55_6 I_af_56_6 I_af_57_6 I_af_58_6 I_af_59_6 I_af_510_6 I_af_511_6 I_af_512_6 I_af_513_6 I_af_514_6 I_af_515_6 I_af_516_6 I_af_517_6 I_af_518_6 I_af_519_6 I_af_520_6 I_af_521_6 I_af_522_6 I_af_523_6 I_af_524_6 I_af_525_6 I_af_526_6 I_af_527_6 I_af_528_6 I_af_529_6 I_af_530_6 I_af_531_6 I_aa O0_at_50_6 O0_at_51_6 O0_at_52_6 O0_at_53_6 O0_at_54_6 O0_at_55_6 O0_at_56_6 O0_at_57_6 O0_at_58_6 O0_at_59_6 O0_at_510_6 O0_at_511_6 O0_at_512_6 O0_at_513_6 O0_at_514_6 O0_at_515_6 O0_at_516_6 O0_at_517_6 O0_at_518_6 O0_at_519_6 O0_at_520_6 O0_at_521_6 O0_at_522_6 O0_at_523_6 O0_at_524_6 O0_at_525_6 O0_at_526_6 O0_at_527_6 O0_at_528_6 O0_at_529_6 O0_at_530_6 O0_at_531_6 O0_af_50_6 O0_af_51_6 O0_af_52_6 O0_af_53_6 O0_af_54_6 O0_af_55_6 O0_af_56_6 O0_af_57_6 O0_af_58_6 O0_af_59_6 O0_af_510_6 O0_af_511_6 O0_af_512_6 O0_af_513_6 O0_af_514_6 O0_af_515_6 O0_af_516_6 O0_af_517_6 O0_af_518_6 O0_af_519_6 O0_af_520_6 O0_af_521_6 O0_af_522_6 O0_af_523_6 O0_af_524_6 O0_af_525_6 O0_af_526_6 O0_af_527_6 O0_af_528_6 O0_af_529_6 O0_af_530_6 O0_af_531_6 O0_aa O1_at_50_6 O1_at_51_6 O1_at_52_6 O1_at_53_6 O1_at_54_6 O1_at_55_6 O1_at_56_6 O1_at_57_6 O1_at_58_6 O1_at_59_6 O1_at_510_6 O1_at_511_6 O1_at_512_6 O1_at_513_6 O1_at_514_6 O1_at_515_6 O1_at_516_6 O1_at_517_6 O1_at_518_6 O1_at_519_6 O1_at_520_6 O1_at_521_6 O1_at_522_6 O1_at_523_6 O1_at_524_6 O1_at_525_6 O1_at_526_6 O1_at_527_6 O1_at_528_6 O1_at_529_6 O1_at_530_6 O1_at_531_6 O1_af_50_6 O1_af_51_6 O1_af_52_6 O1_af_53_6 O1_af_54_6 O1_af_55_6 O1_af_56_6 O1_af_57_6 O1_af_58_6 O1_af_59_6 O1_af_510_6 O1_af_511_6 O1_af_512_6 O1_af_513_6 O1_af_514_6 O1_af_515_6 O1_af_516_6 O1_af_517_6 O1_af_518_6 O1_af_519_6 O1_af_520_6 O1_af_521_6 O1_af_522_6 O1_af_523_6 O1_af_524_6 O1_af_525_6 O1_af_526_6 O1_af_527_6 O1_af_528_6 O1_af_529_6 O1_af_530_6 O1_af_531_6 O1_aa
*.PININFO reset:I I_at_50_6:I I_at_51_6:I I_at_52_6:I I_at_53_6:I I_at_54_6:I I_at_55_6:I I_at_56_6:I I_at_57_6:I I_at_58_6:I I_at_59_6:I I_at_510_6:I I_at_511_6:I I_at_512_6:I I_at_513_6:I I_at_514_6:I I_at_515_6:I I_at_516_6:I I_at_517_6:I I_at_518_6:I I_at_519_6:I I_at_520_6:I I_at_521_6:I I_at_522_6:I I_at_523_6:I I_at_524_6:I I_at_525_6:I I_at_526_6:I I_at_527_6:I I_at_528_6:I I_at_529_6:I I_at_530_6:I I_at_531_6:I I_af_50_6:I I_af_51_6:I I_af_52_6:I I_af_53_6:I I_af_54_6:I I_af_55_6:I I_af_56_6:I I_af_57_6:I I_af_58_6:I I_af_59_6:I I_af_510_6:I I_af_511_6:I I_af_512_6:I I_af_513_6:I I_af_514_6:I I_af_515_6:I I_af_516_6:I I_af_517_6:I I_af_518_6:I I_af_519_6:I I_af_520_6:I I_af_521_6:I I_af_522_6:I I_af_523_6:I I_af_524_6:I I_af_525_6:I I_af_526_6:I I_af_527_6:I I_af_528_6:I I_af_529_6:I I_af_530_6:I I_af_531_6:I I_aa:O O0_at_50_6:O O0_at_51_6:O O0_at_52_6:O O0_at_53_6:O O0_at_54_6:O O0_at_55_6:O O0_at_56_6:O O0_at_57_6:O O0_at_58_6:O O0_at_59_6:O O0_at_510_6:O O0_at_511_6:O O0_at_512_6:O O0_at_513_6:O O0_at_514_6:O O0_at_515_6:O O0_at_516_6:O O0_at_517_6:O O0_at_518_6:O O0_at_519_6:O O0_at_520_6:O O0_at_521_6:O O0_at_522_6:O O0_at_523_6:O O0_at_524_6:O O0_at_525_6:O O0_at_526_6:O O0_at_527_6:O O0_at_528_6:O O0_at_529_6:O O0_at_530_6:O O0_at_531_6:O O0_af_50_6:O O0_af_51_6:O O0_af_52_6:O O0_af_53_6:O O0_af_54_6:O O0_af_55_6:O O0_af_56_6:O O0_af_57_6:O O0_af_58_6:O O0_af_59_6:O O0_af_510_6:O O0_af_511_6:O O0_af_512_6:O O0_af_513_6:O O0_af_514_6:O O0_af_515_6:O O0_af_516_6:O O0_af_517_6:O O0_af_518_6:O O0_af_519_6:O O0_af_520_6:O O0_af_521_6:O O0_af_522_6:O O0_af_523_6:O O0_af_524_6:O O0_af_525_6:O O0_af_526_6:O O0_af_527_6:O O0_af_528_6:O O0_af_529_6:O O0_af_530_6:O O0_af_531_6:O O0_aa:I O1_at_50_6:O O1_at_51_6:O O1_at_52_6:O O1_at_53_6:O O1_at_54_6:O O1_at_55_6:O O1_at_56_6:O O1_at_57_6:O O1_at_58_6:O O1_at_59_6:O O1_at_510_6:O O1_at_511_6:O O1_at_512_6:O O1_at_513_6:O O1_at_514_6:O O1_at_515_6:O O1_at_516_6:O O1_at_517_6:O O1_at_518_6:O O1_at_519_6:O O1_at_520_6:O O1_at_521_6:O O1_at_522_6:O O1_at_523_6:O O1_at_524_6:O O1_at_525_6:O O1_at_526_6:O O1_at_527_6:O O1_at_528_6:O O1_at_529_6:O O1_at_530_6:O O1_at_531_6:O O1_af_50_6:O O1_af_51_6:O O1_af_52_6:O O1_af_53_6:O O1_af_54_6:O O1_af_55_6:O O1_af_56_6:O O1_af_57_6:O O1_af_58_6:O O1_af_59_6:O O1_af_510_6:O O1_af_511_6:O O1_af_512_6:O O1_af_513_6:O O1_af_514_6:O O1_af_515_6:O O1_af_516_6:O O1_af_517_6:O O1_af_518_6:O O1_af_519_6:O O1_af_520_6:O O1_af_521_6:O O1_af_522_6:O O1_af_523_6:O O1_af_524_6:O O1_af_525_6:O O1_af_526_6:O O1_af_527_6:O O1_af_528_6:O O1_af_529_6:O O1_af_530_6:O O1_af_531_6:O O1_aa:I
*.POWER VDD Vdd
*.POWER GND GND
*.POWER NSUB GND
*.POWER PSUB Vdd
*
* --- node flags ---
*
* p (state-holding): pup_reff=0.8; pdn_reff=1.33333
* inv__I__t_51_6 (combinational)
* inv__s (combinational)
* inv__reset (combinational)
* s (state-holding): pup_reff=1.6; pdn_reff=0.666667
* w__0i (state-holding): pup_reff=1.2; pdn_reff=1.33333
* inv__p (combinational)
* inv__I__f_51_6 (combinational)
* n__w__0 (state-holding): pup_reff=1.6; pdn_reff=1.33333
* n__I__a (state-holding): pup_reff=1.6; pdn_reff=2
* n__w__1 (state-holding): pup_reff=1.6; pdn_reff=1.33333
* w__1 (combinational)
* w__0 (combinational)
* inv__w__0i (combinational)
* n__O0__t_50_6 (state-holding): pup_reff=0.4; pdn_reff=2
* n__O0__f_50_6 (state-holding): pup_reff=0.4; pdn_reff=2
* O1_at_50_6 (state-holding): pup_reff=1.2; pdn_reff=0.666667
* inv__I__t_50_6 (combinational)
* O1_af_50_6 (state-holding): pup_reff=1.2; pdn_reff=0.666667
* inv__I__f_50_6 (combinational)
* n__O0__t_51_6 (state-holding): pup_reff=0.4; pdn_reff=2
* n__O0__f_51_6 (state-holding): pup_reff=0.4; pdn_reff=2
* O1_at_51_6 (state-holding): pup_reff=1.2; pdn_reff=0.666667
* O1_af_51_6 (state-holding): pup_reff=1.2; pdn_reff=0.666667
* n__O0__t_52_6 (state-holding): pup_reff=0.4; pdn_reff=2
* n__O0__f_52_6 (state-holding): pup_reff=0.4; pdn_reff=2
* O1_at_52_6 (state-holding): pup_reff=1.2; pdn_reff=0.666667
* inv__I__t_52_6 (combinational)
* O1_af_52_6 (state-holding): pup_reff=1.2; pdn_reff=0.666667
* inv__I__f_52_6 (combinational)
* n__O0__t_53_6 (state-holding): pup_reff=0.4; pdn_reff=2
* n__O0__f_53_6 (state-holding): pup_reff=0.4; pdn_reff=2
* O1_at_53_6 (state-holding): pup_reff=1.2; pdn_reff=0.666667
* inv__I__t_53_6 (combinational)
* O1_af_53_6 (state-holding): pup_reff=1.2; pdn_reff=0.666667
* inv__I__f_53_6 (combinational)
* n__O0__t_54_6 (state-holding): pup_reff=0.4; pdn_reff=2
* n__O0__f_54_6 (state-holding): pup_reff=0.4; pdn_reff=2
* O1_at_54_6 (state-holding): pup_reff=1.2; pdn_reff=0.666667
* inv__I__t_54_6 (combinational)
* O1_af_54_6 (state-holding): pup_reff=1.2; pdn_reff=0.666667
* inv__I__f_54_6 (combinational)
* n__O0__t_55_6 (state-holding): pup_reff=0.4; pdn_reff=2
* n__O0__f_55_6 (state-holding): pup_reff=0.4; pdn_reff=2
* O1_at_55_6 (state-holding): pup_reff=1.2; pdn_reff=0.666667
* inv__I__t_55_6 (combinational)
* O1_af_55_6 (state-holding): pup_reff=1.2; pdn_reff=0.666667
* inv__I__f_55_6 (combinational)
* n__O0__t_56_6 (state-holding): pup_reff=0.4; pdn_reff=2
* n__O0__f_56_6 (state-holding): pup_reff=0.4; pdn_reff=2
* O1_at_56_6 (state-holding): pup_reff=1.2; pdn_reff=0.666667
* inv__I__t_56_6 (combinational)
* O1_af_56_6 (state-holding): pup_reff=1.2; pdn_reff=0.666667
* inv__I__f_56_6 (combinational)
* n__O0__t_57_6 (state-holding): pup_reff=0.4; pdn_reff=2
* n__O0__f_57_6 (state-holding): pup_reff=0.4; pdn_reff=2
* O1_at_57_6 (state-holding): pup_reff=1.2; pdn_reff=0.666667
* inv__I__t_57_6 (combinational)
* O1_af_57_6 (state-holding): pup_reff=1.2; pdn_reff=0.666667
* inv__I__f_57_6 (combinational)
* n__O0__t_58_6 (state-holding): pup_reff=0.4; pdn_reff=2
* n__O0__f_58_6 (state-holding): pup_reff=0.4; pdn_reff=2
* O1_at_58_6 (state-holding): pup_reff=1.2; pdn_reff=0.666667
* inv__I__t_58_6 (combinational)
* O1_af_58_6 (state-holding): pup_reff=1.2; pdn_reff=0.666667
* inv__I__f_58_6 (combinational)
* n__O0__t_59_6 (state-holding): pup_reff=0.4; pdn_reff=2
* n__O0__f_59_6 (state-holding): pup_reff=0.4; pdn_reff=2
* O1_at_59_6 (state-holding): pup_reff=1.2; pdn_reff=0.666667
* inv__I__t_59_6 (combinational)
* O1_af_59_6 (state-holding): pup_reff=1.2; pdn_reff=0.666667
* inv__I__f_59_6 (combinational)
* n__O0__t_510_6 (state-holding): pup_reff=0.4; pdn_reff=2
* n__O0__f_510_6 (state-holding): pup_reff=0.4; pdn_reff=2
* O1_at_510_6 (state-holding): pup_reff=1.2; pdn_reff=0.666667
* inv__I__t_510_6 (combinational)
* O1_af_510_6 (state-holding): pup_reff=1.2; pdn_reff=0.666667
* inv__I__f_510_6 (combinational)
* n__O0__t_511_6 (state-holding): pup_reff=0.4; pdn_reff=2
* n__O0__f_511_6 (state-holding): pup_reff=0.4; pdn_reff=2
* O1_at_511_6 (state-holding): pup_reff=1.2; pdn_reff=0.666667
* inv__I__t_511_6 (combinational)
* O1_af_511_6 (state-holding): pup_reff=1.2; pdn_reff=0.666667
* inv__I__f_511_6 (combinational)
* n__O0__t_512_6 (state-holding): pup_reff=0.4; pdn_reff=2
* n__O0__f_512_6 (state-holding): pup_reff=0.4; pdn_reff=2
* O1_at_512_6 (state-holding): pup_reff=1.2; pdn_reff=0.666667
* inv__I__t_512_6 (combinational)
* O1_af_512_6 (state-holding): pup_reff=1.2; pdn_reff=0.666667
* inv__I__f_512_6 (combinational)
* n__O0__t_513_6 (state-holding): pup_reff=0.4; pdn_reff=2
* n__O0__f_513_6 (state-holding): pup_reff=0.4; pdn_reff=2
* O1_at_513_6 (state-holding): pup_reff=1.2; pdn_reff=0.666667
* inv__I__t_513_6 (combinational)
* O1_af_513_6 (state-holding): pup_reff=1.2; pdn_reff=0.666667
* inv__I__f_513_6 (combinational)
* n__O0__t_514_6 (state-holding): pup_reff=0.4; pdn_reff=2
* n__O0__f_514_6 (state-holding): pup_reff=0.4; pdn_reff=2
* O1_at_514_6 (state-holding): pup_reff=1.2; pdn_reff=0.666667
* inv__I__t_514_6 (combinational)
* O1_af_514_6 (state-holding): pup_reff=1.2; pdn_reff=0.666667
* inv__I__f_514_6 (combinational)
* n__O0__t_515_6 (state-holding): pup_reff=0.4; pdn_reff=2
* n__O0__f_515_6 (state-holding): pup_reff=0.4; pdn_reff=2
* O1_at_515_6 (state-holding): pup_reff=1.2; pdn_reff=0.666667
* inv__I__t_515_6 (combinational)
* O1_af_515_6 (state-holding): pup_reff=1.2; pdn_reff=0.666667
* inv__I__f_515_6 (combinational)
* n__O0__t_516_6 (state-holding): pup_reff=0.4; pdn_reff=2
* n__O0__f_516_6 (state-holding): pup_reff=0.4; pdn_reff=2
* O1_at_516_6 (state-holding): pup_reff=1.2; pdn_reff=0.666667
* inv__I__t_516_6 (combinational)
* O1_af_516_6 (state-holding): pup_reff=1.2; pdn_reff=0.666667
* inv__I__f_516_6 (combinational)
* n__O0__t_517_6 (state-holding): pup_reff=0.4; pdn_reff=2
* n__O0__f_517_6 (state-holding): pup_reff=0.4; pdn_reff=2
* O1_at_517_6 (state-holding): pup_reff=1.2; pdn_reff=0.666667
* inv__I__t_517_6 (combinational)
* O1_af_517_6 (state-holding): pup_reff=1.2; pdn_reff=0.666667
* inv__I__f_517_6 (combinational)
* n__O0__t_518_6 (state-holding): pup_reff=0.4; pdn_reff=2
* n__O0__f_518_6 (state-holding): pup_reff=0.4; pdn_reff=2
* O1_at_518_6 (state-holding): pup_reff=1.2; pdn_reff=0.666667
* inv__I__t_518_6 (combinational)
* O1_af_518_6 (state-holding): pup_reff=1.2; pdn_reff=0.666667
* inv__I__f_518_6 (combinational)
* n__O0__t_519_6 (state-holding): pup_reff=0.4; pdn_reff=2
* n__O0__f_519_6 (state-holding): pup_reff=0.4; pdn_reff=2
* O1_at_519_6 (state-holding): pup_reff=1.2; pdn_reff=0.666667
* inv__I__t_519_6 (combinational)
* O1_af_519_6 (state-holding): pup_reff=1.2; pdn_reff=0.666667
* inv__I__f_519_6 (combinational)
* n__O0__t_520_6 (state-holding): pup_reff=0.4; pdn_reff=2
* n__O0__f_520_6 (state-holding): pup_reff=0.4; pdn_reff=2
* O1_at_520_6 (state-holding): pup_reff=1.2; pdn_reff=0.666667
* inv__I__t_520_6 (combinational)
* O1_af_520_6 (state-holding): pup_reff=1.2; pdn_reff=0.666667
* inv__I__f_520_6 (combinational)
* n__O0__t_521_6 (state-holding): pup_reff=0.4; pdn_reff=2
* n__O0__f_521_6 (state-holding): pup_reff=0.4; pdn_reff=2
* O1_at_521_6 (state-holding): pup_reff=1.2; pdn_reff=0.666667
* inv__I__t_521_6 (combinational)
* O1_af_521_6 (state-holding): pup_reff=1.2; pdn_reff=0.666667
* inv__I__f_521_6 (combinational)
* n__O0__t_522_6 (state-holding): pup_reff=0.4; pdn_reff=2
* n__O0__f_522_6 (state-holding): pup_reff=0.4; pdn_reff=2
* O1_at_522_6 (state-holding): pup_reff=1.2; pdn_reff=0.666667
* inv__I__t_522_6 (combinational)
* O1_af_522_6 (state-holding): pup_reff=1.2; pdn_reff=0.666667
* inv__I__f_522_6 (combinational)
* n__O0__t_523_6 (state-holding): pup_reff=0.4; pdn_reff=2
* n__O0__f_523_6 (state-holding): pup_reff=0.4; pdn_reff=2
* O1_at_523_6 (state-holding): pup_reff=1.2; pdn_reff=0.666667
* inv__I__t_523_6 (combinational)
* O1_af_523_6 (state-holding): pup_reff=1.2; pdn_reff=0.666667
* inv__I__f_523_6 (combinational)
* n__O0__t_524_6 (state-holding): pup_reff=0.4; pdn_reff=2
* n__O0__f_524_6 (state-holding): pup_reff=0.4; pdn_reff=2
* O1_at_524_6 (state-holding): pup_reff=1.2; pdn_reff=0.666667
* inv__I__t_524_6 (combinational)
* O1_af_524_6 (state-holding): pup_reff=1.2; pdn_reff=0.666667
* inv__I__f_524_6 (combinational)
* n__O0__t_525_6 (state-holding): pup_reff=0.4; pdn_reff=2
* n__O0__f_525_6 (state-holding): pup_reff=0.4; pdn_reff=2
* O1_at_525_6 (state-holding): pup_reff=1.2; pdn_reff=0.666667
* inv__I__t_525_6 (combinational)
* O1_af_525_6 (state-holding): pup_reff=1.2; pdn_reff=0.666667
* inv__I__f_525_6 (combinational)
* n__O0__t_526_6 (state-holding): pup_reff=0.4; pdn_reff=2
* n__O0__f_526_6 (state-holding): pup_reff=0.4; pdn_reff=2
* O1_at_526_6 (state-holding): pup_reff=1.2; pdn_reff=0.666667
* inv__I__t_526_6 (combinational)
* O1_af_526_6 (state-holding): pup_reff=1.2; pdn_reff=0.666667
* inv__I__f_526_6 (combinational)
* n__O0__t_527_6 (state-holding): pup_reff=0.4; pdn_reff=2
* n__O0__f_527_6 (state-holding): pup_reff=0.4; pdn_reff=2
* O1_at_527_6 (state-holding): pup_reff=1.2; pdn_reff=0.666667
* inv__I__t_527_6 (combinational)
* O1_af_527_6 (state-holding): pup_reff=1.2; pdn_reff=0.666667
* inv__I__f_527_6 (combinational)
* n__O0__t_528_6 (state-holding): pup_reff=0.4; pdn_reff=2
* n__O0__f_528_6 (state-holding): pup_reff=0.4; pdn_reff=2
* O1_at_528_6 (state-holding): pup_reff=1.2; pdn_reff=0.666667
* inv__I__t_528_6 (combinational)
* O1_af_528_6 (state-holding): pup_reff=1.2; pdn_reff=0.666667
* inv__I__f_528_6 (combinational)
* n__O0__t_529_6 (state-holding): pup_reff=0.4; pdn_reff=2
* n__O0__f_529_6 (state-holding): pup_reff=0.4; pdn_reff=2
* O1_at_529_6 (state-holding): pup_reff=1.2; pdn_reff=0.666667
* inv__I__t_529_6 (combinational)
* O1_af_529_6 (state-holding): pup_reff=1.2; pdn_reff=0.666667
* inv__I__f_529_6 (combinational)
* n__O0__t_530_6 (state-holding): pup_reff=0.4; pdn_reff=2
* n__O0__f_530_6 (state-holding): pup_reff=0.4; pdn_reff=2
* O1_at_530_6 (state-holding): pup_reff=1.2; pdn_reff=0.666667
* inv__I__t_530_6 (combinational)
* O1_af_530_6 (state-holding): pup_reff=1.2; pdn_reff=0.666667
* inv__I__f_530_6 (combinational)
* n__O0__t_531_6 (state-holding): pup_reff=0.4; pdn_reff=2
* n__O0__f_531_6 (state-holding): pup_reff=0.4; pdn_reff=2
* O1_at_531_6 (state-holding): pup_reff=1.2; pdn_reff=0.666667
* inv__I__t_531_6 (combinational)
* O1_af_531_6 (state-holding): pup_reff=1.2; pdn_reff=0.666667
* inv__I__f_531_6 (combinational)
* I_aa (combinational)
* O0_at_50_6 (combinational)
* O0_af_50_6 (combinational)
* O0_at_51_6 (combinational)
* O0_af_51_6 (combinational)
* O0_at_52_6 (combinational)
* O0_af_52_6 (combinational)
* O0_at_53_6 (combinational)
* O0_af_53_6 (combinational)
* O0_at_54_6 (combinational)
* O0_af_54_6 (combinational)
* O0_at_55_6 (combinational)
* O0_af_55_6 (combinational)
* O0_at_56_6 (combinational)
* O0_af_56_6 (combinational)
* O0_at_57_6 (combinational)
* O0_af_57_6 (combinational)
* O0_at_58_6 (combinational)
* O0_af_58_6 (combinational)
* O0_at_59_6 (combinational)
* O0_af_59_6 (combinational)
* O0_at_510_6 (combinational)
* O0_af_510_6 (combinational)
* O0_at_511_6 (combinational)
* O0_af_511_6 (combinational)
* O0_at_512_6 (combinational)
* O0_af_512_6 (combinational)
* O0_at_513_6 (combinational)
* O0_af_513_6 (combinational)
* O0_at_514_6 (combinational)
* O0_af_514_6 (combinational)
* O0_at_515_6 (combinational)
* O0_af_515_6 (combinational)
* O0_at_516_6 (combinational)
* O0_af_516_6 (combinational)
* O0_at_517_6 (combinational)
* O0_af_517_6 (combinational)
* O0_at_518_6 (combinational)
* O0_af_518_6 (combinational)
* O0_at_519_6 (combinational)
* O0_af_519_6 (combinational)
* O0_at_520_6 (combinational)
* O0_af_520_6 (combinational)
* O0_at_521_6 (combinational)
* O0_af_521_6 (combinational)
* O0_at_522_6 (combinational)
* O0_af_522_6 (combinational)
* O0_at_523_6 (combinational)
* O0_af_523_6 (combinational)
* O0_at_524_6 (combinational)
* O0_af_524_6 (combinational)
* O0_at_525_6 (combinational)
* O0_af_525_6 (combinational)
* O0_at_526_6 (combinational)
* O0_af_526_6 (combinational)
* O0_at_527_6 (combinational)
* O0_af_527_6 (combinational)
* O0_at_528_6 (combinational)
* O0_af_528_6 (combinational)
* O0_at_529_6 (combinational)
* O0_af_529_6 (combinational)
* O0_at_530_6 (combinational)
* O0_af_530_6 (combinational)
* O0_at_531_6 (combinational)
* O0_af_531_6 (combinational)
*
* --- end node flags ---
*
M0_ Vdd inv__I__t_51_6 #3 Vdd pmos W=0.1625U L=0.065U
M1_ Vdd inv__reset p Vdd pmos W=0.1625U L=0.065U
M2_ Vdd inv__s #11 Vdd pmos W=0.1625U L=0.065U
M3_ Vdd s #24 Vdd pmos W=0.1625U L=0.065U
M4_ Vdd inv__reset n__w__0 Vdd pmos W=0.1625U L=0.065U
M5_ Vdd inv__s #31 Vdd pmos W=0.1625U L=0.065U
M6_ Vdd inv__reset n__w__1 Vdd pmos W=0.1625U L=0.065U
M7_ Vdd n__w__1 #34 Vdd pmos W=0.1625U L=0.065U
M8_ Vdd inv__reset s Vdd pmos W=0.1625U L=0.065U
M9_ Vdd O0_aa #42 Vdd pmos W=0.1625U L=0.065U
M10_ Vdd I_at_50_6 n__O0__t_50_6 Vdd pmos W=0.1625U L=0.065U
M11_ Vdd I_af_50_6 n__O0__f_50_6 Vdd pmos W=0.1625U L=0.065U
M12_ Vdd p #52 Vdd pmos W=0.1625U L=0.065U
M13_ Vdd p #56 Vdd pmos W=0.1625U L=0.065U
M14_ Vdd I_at_51_6 n__O0__t_51_6 Vdd pmos W=0.1625U L=0.065U
M15_ Vdd I_af_51_6 n__O0__f_51_6 Vdd pmos W=0.1625U L=0.065U
M16_ Vdd p #67 Vdd pmos W=0.1625U L=0.065U
M17_ Vdd p #70 Vdd pmos W=0.1625U L=0.065U
M18_ Vdd I_at_52_6 n__O0__t_52_6 Vdd pmos W=0.1625U L=0.065U
M19_ Vdd I_af_52_6 n__O0__f_52_6 Vdd pmos W=0.1625U L=0.065U
M20_ Vdd p #81 Vdd pmos W=0.1625U L=0.065U
M21_ Vdd p #85 Vdd pmos W=0.1625U L=0.065U
M22_ Vdd I_at_53_6 n__O0__t_53_6 Vdd pmos W=0.1625U L=0.065U
M23_ Vdd I_af_53_6 n__O0__f_53_6 Vdd pmos W=0.1625U L=0.065U
M24_ Vdd p #97 Vdd pmos W=0.1625U L=0.065U
M25_ Vdd p #101 Vdd pmos W=0.1625U L=0.065U
M26_ Vdd I_at_54_6 n__O0__t_54_6 Vdd pmos W=0.1625U L=0.065U
M27_ Vdd I_af_54_6 n__O0__f_54_6 Vdd pmos W=0.1625U L=0.065U
M28_ Vdd p #113 Vdd pmos W=0.1625U L=0.065U
M29_ Vdd p #117 Vdd pmos W=0.1625U L=0.065U
M30_ Vdd I_at_55_6 n__O0__t_55_6 Vdd pmos W=0.1625U L=0.065U
M31_ Vdd I_af_55_6 n__O0__f_55_6 Vdd pmos W=0.1625U L=0.065U
M32_ Vdd p #129 Vdd pmos W=0.1625U L=0.065U
M33_ Vdd p #133 Vdd pmos W=0.1625U L=0.065U
M34_ Vdd I_at_56_6 n__O0__t_56_6 Vdd pmos W=0.1625U L=0.065U
M35_ Vdd I_af_56_6 n__O0__f_56_6 Vdd pmos W=0.1625U L=0.065U
M36_ Vdd p #145 Vdd pmos W=0.1625U L=0.065U
M37_ Vdd p #149 Vdd pmos W=0.1625U L=0.065U
M38_ Vdd I_at_57_6 n__O0__t_57_6 Vdd pmos W=0.1625U L=0.065U
M39_ Vdd I_af_57_6 n__O0__f_57_6 Vdd pmos W=0.1625U L=0.065U
M40_ Vdd p #161 Vdd pmos W=0.1625U L=0.065U
M41_ Vdd p #165 Vdd pmos W=0.1625U L=0.065U
M42_ Vdd I_at_58_6 n__O0__t_58_6 Vdd pmos W=0.1625U L=0.065U
M43_ Vdd I_af_58_6 n__O0__f_58_6 Vdd pmos W=0.1625U L=0.065U
M44_ Vdd p #177 Vdd pmos W=0.1625U L=0.065U
M45_ Vdd p #181 Vdd pmos W=0.1625U L=0.065U
M46_ Vdd I_at_59_6 n__O0__t_59_6 Vdd pmos W=0.1625U L=0.065U
M47_ Vdd I_af_59_6 n__O0__f_59_6 Vdd pmos W=0.1625U L=0.065U
M48_ Vdd p #193 Vdd pmos W=0.1625U L=0.065U
M49_ Vdd p #197 Vdd pmos W=0.1625U L=0.065U
M50_ Vdd I_at_510_6 n__O0__t_510_6 Vdd pmos W=0.1625U L=0.065U
M51_ Vdd I_af_510_6 n__O0__f_510_6 Vdd pmos W=0.1625U L=0.065U
M52_ Vdd p #209 Vdd pmos W=0.1625U L=0.065U
M53_ Vdd p #213 Vdd pmos W=0.1625U L=0.065U
M54_ Vdd I_at_511_6 n__O0__t_511_6 Vdd pmos W=0.1625U L=0.065U
M55_ Vdd I_af_511_6 n__O0__f_511_6 Vdd pmos W=0.1625U L=0.065U
M56_ Vdd p #225 Vdd pmos W=0.1625U L=0.065U
M57_ Vdd p #229 Vdd pmos W=0.1625U L=0.065U
M58_ Vdd I_at_512_6 n__O0__t_512_6 Vdd pmos W=0.1625U L=0.065U
M59_ Vdd I_af_512_6 n__O0__f_512_6 Vdd pmos W=0.1625U L=0.065U
M60_ Vdd p #241 Vdd pmos W=0.1625U L=0.065U
M61_ Vdd p #245 Vdd pmos W=0.1625U L=0.065U
M62_ Vdd I_at_513_6 n__O0__t_513_6 Vdd pmos W=0.1625U L=0.065U
M63_ Vdd I_af_513_6 n__O0__f_513_6 Vdd pmos W=0.1625U L=0.065U
M64_ Vdd p #257 Vdd pmos W=0.1625U L=0.065U
M65_ Vdd p #261 Vdd pmos W=0.1625U L=0.065U
M66_ Vdd I_at_514_6 n__O0__t_514_6 Vdd pmos W=0.1625U L=0.065U
M67_ Vdd I_af_514_6 n__O0__f_514_6 Vdd pmos W=0.1625U L=0.065U
M68_ Vdd p #273 Vdd pmos W=0.1625U L=0.065U
M69_ Vdd p #277 Vdd pmos W=0.1625U L=0.065U
M70_ Vdd I_at_515_6 n__O0__t_515_6 Vdd pmos W=0.1625U L=0.065U
M71_ Vdd I_af_515_6 n__O0__f_515_6 Vdd pmos W=0.1625U L=0.065U
M72_ Vdd p #289 Vdd pmos W=0.1625U L=0.065U
M73_ Vdd p #293 Vdd pmos W=0.1625U L=0.065U
M74_ Vdd I_at_516_6 n__O0__t_516_6 Vdd pmos W=0.1625U L=0.065U
M75_ Vdd I_af_516_6 n__O0__f_516_6 Vdd pmos W=0.1625U L=0.065U
M76_ Vdd p #305 Vdd pmos W=0.1625U L=0.065U
M77_ Vdd p #309 Vdd pmos W=0.1625U L=0.065U
M78_ Vdd I_at_517_6 n__O0__t_517_6 Vdd pmos W=0.1625U L=0.065U
M79_ Vdd I_af_517_6 n__O0__f_517_6 Vdd pmos W=0.1625U L=0.065U
M80_ Vdd p #321 Vdd pmos W=0.1625U L=0.065U
M81_ Vdd p #325 Vdd pmos W=0.1625U L=0.065U
M82_ Vdd I_at_518_6 n__O0__t_518_6 Vdd pmos W=0.1625U L=0.065U
M83_ Vdd I_af_518_6 n__O0__f_518_6 Vdd pmos W=0.1625U L=0.065U
M84_ Vdd p #337 Vdd pmos W=0.1625U L=0.065U
M85_ Vdd p #341 Vdd pmos W=0.1625U L=0.065U
M86_ Vdd I_at_519_6 n__O0__t_519_6 Vdd pmos W=0.1625U L=0.065U
M87_ Vdd I_af_519_6 n__O0__f_519_6 Vdd pmos W=0.1625U L=0.065U
M88_ Vdd p #353 Vdd pmos W=0.1625U L=0.065U
M89_ Vdd p #357 Vdd pmos W=0.1625U L=0.065U
M90_ Vdd I_at_520_6 n__O0__t_520_6 Vdd pmos W=0.1625U L=0.065U
M91_ Vdd I_af_520_6 n__O0__f_520_6 Vdd pmos W=0.1625U L=0.065U
M92_ Vdd p #369 Vdd pmos W=0.1625U L=0.065U
M93_ Vdd p #373 Vdd pmos W=0.1625U L=0.065U
M94_ Vdd I_at_521_6 n__O0__t_521_6 Vdd pmos W=0.1625U L=0.065U
M95_ Vdd I_af_521_6 n__O0__f_521_6 Vdd pmos W=0.1625U L=0.065U
M96_ Vdd p #385 Vdd pmos W=0.1625U L=0.065U
M97_ Vdd p #389 Vdd pmos W=0.1625U L=0.065U
M98_ Vdd I_at_522_6 n__O0__t_522_6 Vdd pmos W=0.1625U L=0.065U
M99_ Vdd I_af_522_6 n__O0__f_522_6 Vdd pmos W=0.1625U L=0.065U
M100_ Vdd p #401 Vdd pmos W=0.1625U L=0.065U
M101_ Vdd p #405 Vdd pmos W=0.1625U L=0.065U
M102_ Vdd I_at_523_6 n__O0__t_523_6 Vdd pmos W=0.1625U L=0.065U
M103_ Vdd I_af_523_6 n__O0__f_523_6 Vdd pmos W=0.1625U L=0.065U
M104_ Vdd p #417 Vdd pmos W=0.1625U L=0.065U
M105_ Vdd p #421 Vdd pmos W=0.1625U L=0.065U
M106_ Vdd I_at_524_6 n__O0__t_524_6 Vdd pmos W=0.1625U L=0.065U
M107_ Vdd I_af_524_6 n__O0__f_524_6 Vdd pmos W=0.1625U L=0.065U
M108_ Vdd p #433 Vdd pmos W=0.1625U L=0.065U
M109_ Vdd p #437 Vdd pmos W=0.1625U L=0.065U
M110_ Vdd I_at_525_6 n__O0__t_525_6 Vdd pmos W=0.1625U L=0.065U
M111_ Vdd I_af_525_6 n__O0__f_525_6 Vdd pmos W=0.1625U L=0.065U
M112_ Vdd p #449 Vdd pmos W=0.1625U L=0.065U
M113_ Vdd p #453 Vdd pmos W=0.1625U L=0.065U
M114_ Vdd I_at_526_6 n__O0__t_526_6 Vdd pmos W=0.1625U L=0.065U
M115_ Vdd I_af_526_6 n__O0__f_526_6 Vdd pmos W=0.1625U L=0.065U
M116_ Vdd p #465 Vdd pmos W=0.1625U L=0.065U
M117_ Vdd p #469 Vdd pmos W=0.1625U L=0.065U
M118_ Vdd I_at_527_6 n__O0__t_527_6 Vdd pmos W=0.1625U L=0.065U
M119_ Vdd I_af_527_6 n__O0__f_527_6 Vdd pmos W=0.1625U L=0.065U
M120_ Vdd p #481 Vdd pmos W=0.1625U L=0.065U
M121_ Vdd p #485 Vdd pmos W=0.1625U L=0.065U
M122_ Vdd I_at_528_6 n__O0__t_528_6 Vdd pmos W=0.1625U L=0.065U
M123_ Vdd I_af_528_6 n__O0__f_528_6 Vdd pmos W=0.1625U L=0.065U
M124_ Vdd p #497 Vdd pmos W=0.1625U L=0.065U
M125_ Vdd p #501 Vdd pmos W=0.1625U L=0.065U
M126_ Vdd I_at_529_6 n__O0__t_529_6 Vdd pmos W=0.1625U L=0.065U
M127_ Vdd I_af_529_6 n__O0__f_529_6 Vdd pmos W=0.1625U L=0.065U
M128_ Vdd p #513 Vdd pmos W=0.1625U L=0.065U
M129_ Vdd p #517 Vdd pmos W=0.1625U L=0.065U
M130_ Vdd I_at_530_6 n__O0__t_530_6 Vdd pmos W=0.1625U L=0.065U
M131_ Vdd I_af_530_6 n__O0__f_530_6 Vdd pmos W=0.1625U L=0.065U
M132_ Vdd p #529 Vdd pmos W=0.1625U L=0.065U
M133_ Vdd p #533 Vdd pmos W=0.1625U L=0.065U
M134_ Vdd I_at_531_6 n__O0__t_531_6 Vdd pmos W=0.1625U L=0.065U
M135_ Vdd I_af_531_6 n__O0__f_531_6 Vdd pmos W=0.1625U L=0.065U
M136_ Vdd p #545 Vdd pmos W=0.1625U L=0.065U
M137_ Vdd p #549 Vdd pmos W=0.1625U L=0.065U
M138_ Vdd s inv__s Vdd pmos W=0.1625U L=0.065U
M139_ Vdd reset inv__reset Vdd pmos W=0.1625U L=0.065U
M140_ Vdd p inv__p Vdd pmos W=0.1625U L=0.065U
M141_ Vdd w__0i inv__w__0i Vdd pmos W=0.1625U L=0.065U
M142_ Vdd n__w__0 w__0 Vdd pmos W=0.1625U L=0.065U
M143_ Vdd n__w__1 w__1 Vdd pmos W=0.1625U L=0.065U
M144_ Vdd I_at_50_6 inv__I__t_50_6 Vdd pmos W=0.1625U L=0.065U
M145_ Vdd I_af_50_6 inv__I__f_50_6 Vdd pmos W=0.1625U L=0.065U
M146_ Vdd I_at_51_6 inv__I__t_51_6 Vdd pmos W=0.1625U L=0.065U
M147_ Vdd I_af_51_6 inv__I__f_51_6 Vdd pmos W=0.1625U L=0.065U
M148_ Vdd I_at_52_6 inv__I__t_52_6 Vdd pmos W=0.1625U L=0.065U
M149_ Vdd I_af_52_6 inv__I__f_52_6 Vdd pmos W=0.1625U L=0.065U
M150_ Vdd I_at_53_6 inv__I__t_53_6 Vdd pmos W=0.1625U L=0.065U
M151_ Vdd I_af_53_6 inv__I__f_53_6 Vdd pmos W=0.1625U L=0.065U
M152_ Vdd I_at_54_6 inv__I__t_54_6 Vdd pmos W=0.1625U L=0.065U
M153_ Vdd I_af_54_6 inv__I__f_54_6 Vdd pmos W=0.1625U L=0.065U
M154_ Vdd I_at_55_6 inv__I__t_55_6 Vdd pmos W=0.1625U L=0.065U
M155_ Vdd I_af_55_6 inv__I__f_55_6 Vdd pmos W=0.1625U L=0.065U
M156_ Vdd I_at_56_6 inv__I__t_56_6 Vdd pmos W=0.1625U L=0.065U
M157_ Vdd I_af_56_6 inv__I__f_56_6 Vdd pmos W=0.1625U L=0.065U
M158_ Vdd I_at_57_6 inv__I__t_57_6 Vdd pmos W=0.1625U L=0.065U
M159_ Vdd I_af_57_6 inv__I__f_57_6 Vdd pmos W=0.1625U L=0.065U
M160_ Vdd I_at_58_6 inv__I__t_58_6 Vdd pmos W=0.1625U L=0.065U
M161_ Vdd I_af_58_6 inv__I__f_58_6 Vdd pmos W=0.1625U L=0.065U
M162_ Vdd I_at_59_6 inv__I__t_59_6 Vdd pmos W=0.1625U L=0.065U
M163_ Vdd I_af_59_6 inv__I__f_59_6 Vdd pmos W=0.1625U L=0.065U
M164_ Vdd I_at_510_6 inv__I__t_510_6 Vdd pmos W=0.1625U L=0.065U
M165_ Vdd I_af_510_6 inv__I__f_510_6 Vdd pmos W=0.1625U L=0.065U
M166_ Vdd I_at_511_6 inv__I__t_511_6 Vdd pmos W=0.1625U L=0.065U
M167_ Vdd I_af_511_6 inv__I__f_511_6 Vdd pmos W=0.1625U L=0.065U
M168_ Vdd I_at_512_6 inv__I__t_512_6 Vdd pmos W=0.1625U L=0.065U
M169_ Vdd I_af_512_6 inv__I__f_512_6 Vdd pmos W=0.1625U L=0.065U
M170_ Vdd I_at_513_6 inv__I__t_513_6 Vdd pmos W=0.1625U L=0.065U
M171_ Vdd I_af_513_6 inv__I__f_513_6 Vdd pmos W=0.1625U L=0.065U
M172_ Vdd I_at_514_6 inv__I__t_514_6 Vdd pmos W=0.1625U L=0.065U
M173_ Vdd I_af_514_6 inv__I__f_514_6 Vdd pmos W=0.1625U L=0.065U
M174_ Vdd I_at_515_6 inv__I__t_515_6 Vdd pmos W=0.1625U L=0.065U
M175_ Vdd I_af_515_6 inv__I__f_515_6 Vdd pmos W=0.1625U L=0.065U
M176_ Vdd I_at_516_6 inv__I__t_516_6 Vdd pmos W=0.1625U L=0.065U
M177_ Vdd I_af_516_6 inv__I__f_516_6 Vdd pmos W=0.1625U L=0.065U
M178_ Vdd I_at_517_6 inv__I__t_517_6 Vdd pmos W=0.1625U L=0.065U
M179_ Vdd I_af_517_6 inv__I__f_517_6 Vdd pmos W=0.1625U L=0.065U
M180_ Vdd I_at_518_6 inv__I__t_518_6 Vdd pmos W=0.1625U L=0.065U
M181_ Vdd I_af_518_6 inv__I__f_518_6 Vdd pmos W=0.1625U L=0.065U
M182_ Vdd I_at_519_6 inv__I__t_519_6 Vdd pmos W=0.1625U L=0.065U
M183_ Vdd I_af_519_6 inv__I__f_519_6 Vdd pmos W=0.1625U L=0.065U
M184_ Vdd I_at_520_6 inv__I__t_520_6 Vdd pmos W=0.1625U L=0.065U
M185_ Vdd I_af_520_6 inv__I__f_520_6 Vdd pmos W=0.1625U L=0.065U
M186_ Vdd I_at_521_6 inv__I__t_521_6 Vdd pmos W=0.1625U L=0.065U
M187_ Vdd I_af_521_6 inv__I__f_521_6 Vdd pmos W=0.1625U L=0.065U
M188_ Vdd I_at_522_6 inv__I__t_522_6 Vdd pmos W=0.1625U L=0.065U
M189_ Vdd I_af_522_6 inv__I__f_522_6 Vdd pmos W=0.1625U L=0.065U
M190_ Vdd I_at_523_6 inv__I__t_523_6 Vdd pmos W=0.1625U L=0.065U
M191_ Vdd I_af_523_6 inv__I__f_523_6 Vdd pmos W=0.1625U L=0.065U
M192_ Vdd I_at_524_6 inv__I__t_524_6 Vdd pmos W=0.1625U L=0.065U
M193_ Vdd I_af_524_6 inv__I__f_524_6 Vdd pmos W=0.1625U L=0.065U
M194_ Vdd I_at_525_6 inv__I__t_525_6 Vdd pmos W=0.1625U L=0.065U
M195_ Vdd I_af_525_6 inv__I__f_525_6 Vdd pmos W=0.1625U L=0.065U
M196_ Vdd I_at_526_6 inv__I__t_526_6 Vdd pmos W=0.1625U L=0.065U
M197_ Vdd I_af_526_6 inv__I__f_526_6 Vdd pmos W=0.1625U L=0.065U
M198_ Vdd I_at_527_6 inv__I__t_527_6 Vdd pmos W=0.1625U L=0.065U
M199_ Vdd I_af_527_6 inv__I__f_527_6 Vdd pmos W=0.1625U L=0.065U
M200_ Vdd I_at_528_6 inv__I__t_528_6 Vdd pmos W=0.1625U L=0.065U
M201_ Vdd I_af_528_6 inv__I__f_528_6 Vdd pmos W=0.1625U L=0.065U
M202_ Vdd I_at_529_6 inv__I__t_529_6 Vdd pmos W=0.1625U L=0.065U
M203_ Vdd I_af_529_6 inv__I__f_529_6 Vdd pmos W=0.1625U L=0.065U
M204_ Vdd I_at_530_6 inv__I__t_530_6 Vdd pmos W=0.1625U L=0.065U
M205_ Vdd I_af_530_6 inv__I__f_530_6 Vdd pmos W=0.1625U L=0.065U
M206_ Vdd I_at_531_6 inv__I__t_531_6 Vdd pmos W=0.1625U L=0.065U
M207_ Vdd I_af_531_6 inv__I__f_531_6 Vdd pmos W=0.1625U L=0.065U
M208_ Vdd n__I__a I_aa Vdd pmos W=0.1625U L=0.065U
M209_ Vdd n__O0__t_50_6 O0_at_50_6 Vdd pmos W=0.1625U L=0.065U
M210_ Vdd n__O0__f_50_6 O0_af_50_6 Vdd pmos W=0.1625U L=0.065U
M211_ Vdd n__O0__t_51_6 O0_at_51_6 Vdd pmos W=0.1625U L=0.065U
M212_ Vdd n__O0__f_51_6 O0_af_51_6 Vdd pmos W=0.1625U L=0.065U
M213_ Vdd n__O0__t_52_6 O0_at_52_6 Vdd pmos W=0.1625U L=0.065U
M214_ Vdd n__O0__f_52_6 O0_af_52_6 Vdd pmos W=0.1625U L=0.065U
M215_ Vdd n__O0__t_53_6 O0_at_53_6 Vdd pmos W=0.1625U L=0.065U
M216_ Vdd n__O0__f_53_6 O0_af_53_6 Vdd pmos W=0.1625U L=0.065U
M217_ Vdd n__O0__t_54_6 O0_at_54_6 Vdd pmos W=0.1625U L=0.065U
M218_ Vdd n__O0__f_54_6 O0_af_54_6 Vdd pmos W=0.1625U L=0.065U
M219_ Vdd n__O0__t_55_6 O0_at_55_6 Vdd pmos W=0.1625U L=0.065U
M220_ Vdd n__O0__f_55_6 O0_af_55_6 Vdd pmos W=0.1625U L=0.065U
M221_ Vdd n__O0__t_56_6 O0_at_56_6 Vdd pmos W=0.1625U L=0.065U
M222_ Vdd n__O0__f_56_6 O0_af_56_6 Vdd pmos W=0.1625U L=0.065U
M223_ Vdd n__O0__t_57_6 O0_at_57_6 Vdd pmos W=0.1625U L=0.065U
M224_ Vdd n__O0__f_57_6 O0_af_57_6 Vdd pmos W=0.1625U L=0.065U
M225_ Vdd n__O0__t_58_6 O0_at_58_6 Vdd pmos W=0.1625U L=0.065U
M226_ Vdd n__O0__f_58_6 O0_af_58_6 Vdd pmos W=0.1625U L=0.065U
M227_ Vdd n__O0__t_59_6 O0_at_59_6 Vdd pmos W=0.1625U L=0.065U
M228_ Vdd n__O0__f_59_6 O0_af_59_6 Vdd pmos W=0.1625U L=0.065U
M229_ Vdd n__O0__t_510_6 O0_at_510_6 Vdd pmos W=0.1625U L=0.065U
M230_ Vdd n__O0__f_510_6 O0_af_510_6 Vdd pmos W=0.1625U L=0.065U
M231_ Vdd n__O0__t_511_6 O0_at_511_6 Vdd pmos W=0.1625U L=0.065U
M232_ Vdd n__O0__f_511_6 O0_af_511_6 Vdd pmos W=0.1625U L=0.065U
M233_ Vdd n__O0__t_512_6 O0_at_512_6 Vdd pmos W=0.1625U L=0.065U
M234_ Vdd n__O0__f_512_6 O0_af_512_6 Vdd pmos W=0.1625U L=0.065U
M235_ Vdd n__O0__t_513_6 O0_at_513_6 Vdd pmos W=0.1625U L=0.065U
M236_ Vdd n__O0__f_513_6 O0_af_513_6 Vdd pmos W=0.1625U L=0.065U
M237_ Vdd n__O0__t_514_6 O0_at_514_6 Vdd pmos W=0.1625U L=0.065U
M238_ Vdd n__O0__f_514_6 O0_af_514_6 Vdd pmos W=0.1625U L=0.065U
M239_ Vdd n__O0__t_515_6 O0_at_515_6 Vdd pmos W=0.1625U L=0.065U
M240_ Vdd n__O0__f_515_6 O0_af_515_6 Vdd pmos W=0.1625U L=0.065U
M241_ Vdd n__O0__t_516_6 O0_at_516_6 Vdd pmos W=0.1625U L=0.065U
M242_ Vdd n__O0__f_516_6 O0_af_516_6 Vdd pmos W=0.1625U L=0.065U
M243_ Vdd n__O0__t_517_6 O0_at_517_6 Vdd pmos W=0.1625U L=0.065U
M244_ Vdd n__O0__f_517_6 O0_af_517_6 Vdd pmos W=0.1625U L=0.065U
M245_ Vdd n__O0__t_518_6 O0_at_518_6 Vdd pmos W=0.1625U L=0.065U
M246_ Vdd n__O0__f_518_6 O0_af_518_6 Vdd pmos W=0.1625U L=0.065U
M247_ Vdd n__O0__t_519_6 O0_at_519_6 Vdd pmos W=0.1625U L=0.065U
M248_ Vdd n__O0__f_519_6 O0_af_519_6 Vdd pmos W=0.1625U L=0.065U
M249_ Vdd n__O0__t_520_6 O0_at_520_6 Vdd pmos W=0.1625U L=0.065U
M250_ Vdd n__O0__f_520_6 O0_af_520_6 Vdd pmos W=0.1625U L=0.065U
M251_ Vdd n__O0__t_521_6 O0_at_521_6 Vdd pmos W=0.1625U L=0.065U
M252_ Vdd n__O0__f_521_6 O0_af_521_6 Vdd pmos W=0.1625U L=0.065U
M253_ Vdd n__O0__t_522_6 O0_at_522_6 Vdd pmos W=0.1625U L=0.065U
M254_ Vdd n__O0__f_522_6 O0_af_522_6 Vdd pmos W=0.1625U L=0.065U
M255_ Vdd n__O0__t_523_6 O0_at_523_6 Vdd pmos W=0.1625U L=0.065U
M256_ Vdd n__O0__f_523_6 O0_af_523_6 Vdd pmos W=0.1625U L=0.065U
M257_ Vdd n__O0__t_524_6 O0_at_524_6 Vdd pmos W=0.1625U L=0.065U
M258_ Vdd n__O0__f_524_6 O0_af_524_6 Vdd pmos W=0.1625U L=0.065U
M259_ Vdd n__O0__t_525_6 O0_at_525_6 Vdd pmos W=0.1625U L=0.065U
M260_ Vdd n__O0__f_525_6 O0_af_525_6 Vdd pmos W=0.1625U L=0.065U
M261_ Vdd n__O0__t_526_6 O0_at_526_6 Vdd pmos W=0.1625U L=0.065U
M262_ Vdd n__O0__f_526_6 O0_af_526_6 Vdd pmos W=0.1625U L=0.065U
M263_ Vdd n__O0__t_527_6 O0_at_527_6 Vdd pmos W=0.1625U L=0.065U
M264_ Vdd n__O0__f_527_6 O0_af_527_6 Vdd pmos W=0.1625U L=0.065U
M265_ Vdd n__O0__t_528_6 O0_at_528_6 Vdd pmos W=0.1625U L=0.065U
M266_ Vdd n__O0__f_528_6 O0_af_528_6 Vdd pmos W=0.1625U L=0.065U
M267_ Vdd n__O0__t_529_6 O0_at_529_6 Vdd pmos W=0.1625U L=0.065U
M268_ Vdd n__O0__f_529_6 O0_af_529_6 Vdd pmos W=0.1625U L=0.065U
M269_ Vdd n__O0__t_530_6 O0_at_530_6 Vdd pmos W=0.1625U L=0.065U
M270_ Vdd n__O0__f_530_6 O0_af_530_6 Vdd pmos W=0.1625U L=0.065U
M271_ Vdd n__O0__t_531_6 O0_at_531_6 Vdd pmos W=0.1625U L=0.065U
M272_ Vdd n__O0__f_531_6 O0_af_531_6 Vdd pmos W=0.1625U L=0.065U
M273_ Vdd p #fb616# Vdd pmos W=0.1625U L=0.13U
M274_ Vdd s #fb619# Vdd pmos W=0.1625U L=0.13U
M275_keeper Vdd GND #617 Vdd pmos W=0.0975U L=0.585U
M276_ Vdd w__0i #fb622# Vdd pmos W=0.1625U L=0.13U
M277_keeper Vdd GND #620 Vdd pmos W=0.0975U L=0.26U
M278_ Vdd n__w__0 #fb625# Vdd pmos W=0.1625U L=0.13U
M279_keeper Vdd GND #623 Vdd pmos W=0.0975U L=0.585U
M280_ Vdd n__I__a #fb628# Vdd pmos W=0.1625U L=0.13U
M281_keeper Vdd GND #626 Vdd pmos W=0.0975U L=0.585U
M282_ Vdd n__w__1 #fb631# Vdd pmos W=0.1625U L=0.13U
M283_keeper Vdd GND #629 Vdd pmos W=0.0975U L=0.91U
M284_ Vdd n__O0__t_50_6 #fb634# Vdd pmos W=0.1625U L=0.13U
M285_keeper Vdd GND #632 Vdd pmos W=0.0975U L=0.585U
M286_ Vdd n__O0__f_50_6 #fb637# Vdd pmos W=0.1625U L=0.13U
M287_keeper Vdd GND #635 Vdd pmos W=0.0975U L=0.91U
M288_ Vdd O1_at_50_6 #fb640# Vdd pmos W=0.1625U L=0.13U
M289_keeper Vdd GND #638 Vdd pmos W=0.0975U L=0.91U
M290_ Vdd O1_af_50_6 #fb643# Vdd pmos W=0.1625U L=0.13U
M291_keeper Vdd GND #641 Vdd pmos W=0.0975U L=0.26U
M292_ Vdd n__O0__t_51_6 #fb646# Vdd pmos W=0.1625U L=0.13U
M293_keeper Vdd GND #644 Vdd pmos W=0.0975U L=0.26U
M294_ Vdd n__O0__f_51_6 #fb649# Vdd pmos W=0.1625U L=0.13U
M295_keeper Vdd GND #647 Vdd pmos W=0.0975U L=0.91U
M296_ Vdd O1_at_51_6 #fb652# Vdd pmos W=0.1625U L=0.13U
M297_keeper Vdd GND #650 Vdd pmos W=0.0975U L=0.91U
M298_ Vdd O1_af_51_6 #fb655# Vdd pmos W=0.1625U L=0.13U
M299_keeper Vdd GND #653 Vdd pmos W=0.0975U L=0.26U
M300_ Vdd n__O0__t_52_6 #fb658# Vdd pmos W=0.1625U L=0.13U
M301_keeper Vdd GND #656 Vdd pmos W=0.0975U L=0.26U
M302_ Vdd n__O0__f_52_6 #fb661# Vdd pmos W=0.1625U L=0.13U
M303_keeper Vdd GND #659 Vdd pmos W=0.0975U L=0.91U
M304_ Vdd O1_at_52_6 #fb664# Vdd pmos W=0.1625U L=0.13U
M305_keeper Vdd GND #662 Vdd pmos W=0.0975U L=0.91U
M306_ Vdd O1_af_52_6 #fb667# Vdd pmos W=0.1625U L=0.13U
M307_keeper Vdd GND #665 Vdd pmos W=0.0975U L=0.26U
M308_ Vdd n__O0__t_53_6 #fb670# Vdd pmos W=0.1625U L=0.13U
M309_keeper Vdd GND #668 Vdd pmos W=0.0975U L=0.26U
M310_ Vdd n__O0__f_53_6 #fb673# Vdd pmos W=0.1625U L=0.13U
M311_keeper Vdd GND #671 Vdd pmos W=0.0975U L=0.91U
M312_ Vdd O1_at_53_6 #fb676# Vdd pmos W=0.1625U L=0.13U
M313_keeper Vdd GND #674 Vdd pmos W=0.0975U L=0.91U
M314_ Vdd O1_af_53_6 #fb679# Vdd pmos W=0.1625U L=0.13U
M315_keeper Vdd GND #677 Vdd pmos W=0.0975U L=0.26U
M316_ Vdd n__O0__t_54_6 #fb682# Vdd pmos W=0.1625U L=0.13U
M317_keeper Vdd GND #680 Vdd pmos W=0.0975U L=0.26U
M318_ Vdd n__O0__f_54_6 #fb685# Vdd pmos W=0.1625U L=0.13U
M319_keeper Vdd GND #683 Vdd pmos W=0.0975U L=0.91U
M320_ Vdd O1_at_54_6 #fb688# Vdd pmos W=0.1625U L=0.13U
M321_keeper Vdd GND #686 Vdd pmos W=0.0975U L=0.91U
M322_ Vdd O1_af_54_6 #fb691# Vdd pmos W=0.1625U L=0.13U
M323_keeper Vdd GND #689 Vdd pmos W=0.0975U L=0.26U
M324_ Vdd n__O0__t_55_6 #fb694# Vdd pmos W=0.1625U L=0.13U
M325_keeper Vdd GND #692 Vdd pmos W=0.0975U L=0.26U
M326_ Vdd n__O0__f_55_6 #fb697# Vdd pmos W=0.1625U L=0.13U
M327_keeper Vdd GND #695 Vdd pmos W=0.0975U L=0.91U
M328_ Vdd O1_at_55_6 #fb700# Vdd pmos W=0.1625U L=0.13U
M329_keeper Vdd GND #698 Vdd pmos W=0.0975U L=0.91U
M330_ Vdd O1_af_55_6 #fb703# Vdd pmos W=0.1625U L=0.13U
M331_keeper Vdd GND #701 Vdd pmos W=0.0975U L=0.26U
M332_ Vdd n__O0__t_56_6 #fb706# Vdd pmos W=0.1625U L=0.13U
M333_keeper Vdd GND #704 Vdd pmos W=0.0975U L=0.26U
M334_ Vdd n__O0__f_56_6 #fb709# Vdd pmos W=0.1625U L=0.13U
M335_keeper Vdd GND #707 Vdd pmos W=0.0975U L=0.91U
M336_ Vdd O1_at_56_6 #fb712# Vdd pmos W=0.1625U L=0.13U
M337_keeper Vdd GND #710 Vdd pmos W=0.0975U L=0.91U
M338_ Vdd O1_af_56_6 #fb715# Vdd pmos W=0.1625U L=0.13U
M339_keeper Vdd GND #713 Vdd pmos W=0.0975U L=0.26U
M340_ Vdd n__O0__t_57_6 #fb718# Vdd pmos W=0.1625U L=0.13U
M341_keeper Vdd GND #716 Vdd pmos W=0.0975U L=0.26U
M342_ Vdd n__O0__f_57_6 #fb721# Vdd pmos W=0.1625U L=0.13U
M343_keeper Vdd GND #719 Vdd pmos W=0.0975U L=0.91U
M344_ Vdd O1_at_57_6 #fb724# Vdd pmos W=0.1625U L=0.13U
M345_keeper Vdd GND #722 Vdd pmos W=0.0975U L=0.91U
M346_ Vdd O1_af_57_6 #fb727# Vdd pmos W=0.1625U L=0.13U
M347_keeper Vdd GND #725 Vdd pmos W=0.0975U L=0.26U
M348_ Vdd n__O0__t_58_6 #fb730# Vdd pmos W=0.1625U L=0.13U
M349_keeper Vdd GND #728 Vdd pmos W=0.0975U L=0.26U
M350_ Vdd n__O0__f_58_6 #fb733# Vdd pmos W=0.1625U L=0.13U
M351_keeper Vdd GND #731 Vdd pmos W=0.0975U L=0.91U
M352_ Vdd O1_at_58_6 #fb736# Vdd pmos W=0.1625U L=0.13U
M353_keeper Vdd GND #734 Vdd pmos W=0.0975U L=0.91U
M354_ Vdd O1_af_58_6 #fb739# Vdd pmos W=0.1625U L=0.13U
M355_keeper Vdd GND #737 Vdd pmos W=0.0975U L=0.26U
M356_ Vdd n__O0__t_59_6 #fb742# Vdd pmos W=0.1625U L=0.13U
M357_keeper Vdd GND #740 Vdd pmos W=0.0975U L=0.26U
M358_ Vdd n__O0__f_59_6 #fb745# Vdd pmos W=0.1625U L=0.13U
M359_keeper Vdd GND #743 Vdd pmos W=0.0975U L=0.91U
M360_ Vdd O1_at_59_6 #fb748# Vdd pmos W=0.1625U L=0.13U
M361_keeper Vdd GND #746 Vdd pmos W=0.0975U L=0.91U
M362_ Vdd O1_af_59_6 #fb751# Vdd pmos W=0.1625U L=0.13U
M363_keeper Vdd GND #749 Vdd pmos W=0.0975U L=0.26U
M364_ Vdd n__O0__t_510_6 #fb754# Vdd pmos W=0.1625U L=0.13U
M365_keeper Vdd GND #752 Vdd pmos W=0.0975U L=0.26U
M366_ Vdd n__O0__f_510_6 #fb757# Vdd pmos W=0.1625U L=0.13U
M367_keeper Vdd GND #755 Vdd pmos W=0.0975U L=0.91U
M368_ Vdd O1_at_510_6 #fb760# Vdd pmos W=0.1625U L=0.13U
M369_keeper Vdd GND #758 Vdd pmos W=0.0975U L=0.91U
M370_ Vdd O1_af_510_6 #fb763# Vdd pmos W=0.1625U L=0.13U
M371_keeper Vdd GND #761 Vdd pmos W=0.0975U L=0.26U
M372_ Vdd n__O0__t_511_6 #fb766# Vdd pmos W=0.1625U L=0.13U
M373_keeper Vdd GND #764 Vdd pmos W=0.0975U L=0.26U
M374_ Vdd n__O0__f_511_6 #fb769# Vdd pmos W=0.1625U L=0.13U
M375_keeper Vdd GND #767 Vdd pmos W=0.0975U L=0.91U
M376_ Vdd O1_at_511_6 #fb772# Vdd pmos W=0.1625U L=0.13U
M377_keeper Vdd GND #770 Vdd pmos W=0.0975U L=0.91U
M378_ Vdd O1_af_511_6 #fb775# Vdd pmos W=0.1625U L=0.13U
M379_keeper Vdd GND #773 Vdd pmos W=0.0975U L=0.26U
M380_ Vdd n__O0__t_512_6 #fb778# Vdd pmos W=0.1625U L=0.13U
M381_keeper Vdd GND #776 Vdd pmos W=0.0975U L=0.26U
M382_ Vdd n__O0__f_512_6 #fb781# Vdd pmos W=0.1625U L=0.13U
M383_keeper Vdd GND #779 Vdd pmos W=0.0975U L=0.91U
M384_ Vdd O1_at_512_6 #fb784# Vdd pmos W=0.1625U L=0.13U
M385_keeper Vdd GND #782 Vdd pmos W=0.0975U L=0.91U
M386_ Vdd O1_af_512_6 #fb787# Vdd pmos W=0.1625U L=0.13U
M387_keeper Vdd GND #785 Vdd pmos W=0.0975U L=0.26U
M388_ Vdd n__O0__t_513_6 #fb790# Vdd pmos W=0.1625U L=0.13U
M389_keeper Vdd GND #788 Vdd pmos W=0.0975U L=0.26U
M390_ Vdd n__O0__f_513_6 #fb793# Vdd pmos W=0.1625U L=0.13U
M391_keeper Vdd GND #791 Vdd pmos W=0.0975U L=0.91U
M392_ Vdd O1_at_513_6 #fb796# Vdd pmos W=0.1625U L=0.13U
M393_keeper Vdd GND #794 Vdd pmos W=0.0975U L=0.91U
M394_ Vdd O1_af_513_6 #fb799# Vdd pmos W=0.1625U L=0.13U
M395_keeper Vdd GND #797 Vdd pmos W=0.0975U L=0.26U
M396_ Vdd n__O0__t_514_6 #fb802# Vdd pmos W=0.1625U L=0.13U
M397_keeper Vdd GND #800 Vdd pmos W=0.0975U L=0.26U
M398_ Vdd n__O0__f_514_6 #fb805# Vdd pmos W=0.1625U L=0.13U
M399_keeper Vdd GND #803 Vdd pmos W=0.0975U L=0.91U
M400_ Vdd O1_at_514_6 #fb808# Vdd pmos W=0.1625U L=0.13U
M401_keeper Vdd GND #806 Vdd pmos W=0.0975U L=0.91U
M402_ Vdd O1_af_514_6 #fb811# Vdd pmos W=0.1625U L=0.13U
M403_keeper Vdd GND #809 Vdd pmos W=0.0975U L=0.26U
M404_ Vdd n__O0__t_515_6 #fb814# Vdd pmos W=0.1625U L=0.13U
M405_keeper Vdd GND #812 Vdd pmos W=0.0975U L=0.26U
M406_ Vdd n__O0__f_515_6 #fb817# Vdd pmos W=0.1625U L=0.13U
M407_keeper Vdd GND #815 Vdd pmos W=0.0975U L=0.91U
M408_ Vdd O1_at_515_6 #fb820# Vdd pmos W=0.1625U L=0.13U
M409_keeper Vdd GND #818 Vdd pmos W=0.0975U L=0.91U
M410_ Vdd O1_af_515_6 #fb823# Vdd pmos W=0.1625U L=0.13U
M411_keeper Vdd GND #821 Vdd pmos W=0.0975U L=0.26U
M412_ Vdd n__O0__t_516_6 #fb826# Vdd pmos W=0.1625U L=0.13U
M413_keeper Vdd GND #824 Vdd pmos W=0.0975U L=0.26U
M414_ Vdd n__O0__f_516_6 #fb829# Vdd pmos W=0.1625U L=0.13U
M415_keeper Vdd GND #827 Vdd pmos W=0.0975U L=0.91U
M416_ Vdd O1_at_516_6 #fb832# Vdd pmos W=0.1625U L=0.13U
M417_keeper Vdd GND #830 Vdd pmos W=0.0975U L=0.91U
M418_ Vdd O1_af_516_6 #fb835# Vdd pmos W=0.1625U L=0.13U
M419_keeper Vdd GND #833 Vdd pmos W=0.0975U L=0.26U
M420_ Vdd n__O0__t_517_6 #fb838# Vdd pmos W=0.1625U L=0.13U
M421_keeper Vdd GND #836 Vdd pmos W=0.0975U L=0.26U
M422_ Vdd n__O0__f_517_6 #fb841# Vdd pmos W=0.1625U L=0.13U
M423_keeper Vdd GND #839 Vdd pmos W=0.0975U L=0.91U
M424_ Vdd O1_at_517_6 #fb844# Vdd pmos W=0.1625U L=0.13U
M425_keeper Vdd GND #842 Vdd pmos W=0.0975U L=0.91U
M426_ Vdd O1_af_517_6 #fb847# Vdd pmos W=0.1625U L=0.13U
M427_keeper Vdd GND #845 Vdd pmos W=0.0975U L=0.26U
M428_ Vdd n__O0__t_518_6 #fb850# Vdd pmos W=0.1625U L=0.13U
M429_keeper Vdd GND #848 Vdd pmos W=0.0975U L=0.26U
M430_ Vdd n__O0__f_518_6 #fb853# Vdd pmos W=0.1625U L=0.13U
M431_keeper Vdd GND #851 Vdd pmos W=0.0975U L=0.91U
M432_ Vdd O1_at_518_6 #fb856# Vdd pmos W=0.1625U L=0.13U
M433_keeper Vdd GND #854 Vdd pmos W=0.0975U L=0.91U
M434_ Vdd O1_af_518_6 #fb859# Vdd pmos W=0.1625U L=0.13U
M435_keeper Vdd GND #857 Vdd pmos W=0.0975U L=0.26U
M436_ Vdd n__O0__t_519_6 #fb862# Vdd pmos W=0.1625U L=0.13U
M437_keeper Vdd GND #860 Vdd pmos W=0.0975U L=0.26U
M438_ Vdd n__O0__f_519_6 #fb865# Vdd pmos W=0.1625U L=0.13U
M439_keeper Vdd GND #863 Vdd pmos W=0.0975U L=0.91U
M440_ Vdd O1_at_519_6 #fb868# Vdd pmos W=0.1625U L=0.13U
M441_keeper Vdd GND #866 Vdd pmos W=0.0975U L=0.91U
M442_ Vdd O1_af_519_6 #fb871# Vdd pmos W=0.1625U L=0.13U
M443_keeper Vdd GND #869 Vdd pmos W=0.0975U L=0.26U
M444_ Vdd n__O0__t_520_6 #fb874# Vdd pmos W=0.1625U L=0.13U
M445_keeper Vdd GND #872 Vdd pmos W=0.0975U L=0.26U
M446_ Vdd n__O0__f_520_6 #fb877# Vdd pmos W=0.1625U L=0.13U
M447_keeper Vdd GND #875 Vdd pmos W=0.0975U L=0.91U
M448_ Vdd O1_at_520_6 #fb880# Vdd pmos W=0.1625U L=0.13U
M449_keeper Vdd GND #878 Vdd pmos W=0.0975U L=0.91U
M450_ Vdd O1_af_520_6 #fb883# Vdd pmos W=0.1625U L=0.13U
M451_keeper Vdd GND #881 Vdd pmos W=0.0975U L=0.26U
M452_ Vdd n__O0__t_521_6 #fb886# Vdd pmos W=0.1625U L=0.13U
M453_keeper Vdd GND #884 Vdd pmos W=0.0975U L=0.26U
M454_ Vdd n__O0__f_521_6 #fb889# Vdd pmos W=0.1625U L=0.13U
M455_keeper Vdd GND #887 Vdd pmos W=0.0975U L=0.91U
M456_ Vdd O1_at_521_6 #fb892# Vdd pmos W=0.1625U L=0.13U
M457_keeper Vdd GND #890 Vdd pmos W=0.0975U L=0.91U
M458_ Vdd O1_af_521_6 #fb895# Vdd pmos W=0.1625U L=0.13U
M459_keeper Vdd GND #893 Vdd pmos W=0.0975U L=0.26U
M460_ Vdd n__O0__t_522_6 #fb898# Vdd pmos W=0.1625U L=0.13U
M461_keeper Vdd GND #896 Vdd pmos W=0.0975U L=0.26U
M462_ Vdd n__O0__f_522_6 #fb901# Vdd pmos W=0.1625U L=0.13U
M463_keeper Vdd GND #899 Vdd pmos W=0.0975U L=0.91U
M464_ Vdd O1_at_522_6 #fb904# Vdd pmos W=0.1625U L=0.13U
M465_keeper Vdd GND #902 Vdd pmos W=0.0975U L=0.91U
M466_ Vdd O1_af_522_6 #fb907# Vdd pmos W=0.1625U L=0.13U
M467_keeper Vdd GND #905 Vdd pmos W=0.0975U L=0.26U
M468_ Vdd n__O0__t_523_6 #fb910# Vdd pmos W=0.1625U L=0.13U
M469_keeper Vdd GND #908 Vdd pmos W=0.0975U L=0.26U
M470_ Vdd n__O0__f_523_6 #fb913# Vdd pmos W=0.1625U L=0.13U
M471_keeper Vdd GND #911 Vdd pmos W=0.0975U L=0.91U
M472_ Vdd O1_at_523_6 #fb916# Vdd pmos W=0.1625U L=0.13U
M473_keeper Vdd GND #914 Vdd pmos W=0.0975U L=0.91U
M474_ Vdd O1_af_523_6 #fb919# Vdd pmos W=0.1625U L=0.13U
M475_keeper Vdd GND #917 Vdd pmos W=0.0975U L=0.26U
M476_ Vdd n__O0__t_524_6 #fb922# Vdd pmos W=0.1625U L=0.13U
M477_keeper Vdd GND #920 Vdd pmos W=0.0975U L=0.26U
M478_ Vdd n__O0__f_524_6 #fb925# Vdd pmos W=0.1625U L=0.13U
M479_keeper Vdd GND #923 Vdd pmos W=0.0975U L=0.91U
M480_ Vdd O1_at_524_6 #fb928# Vdd pmos W=0.1625U L=0.13U
M481_keeper Vdd GND #926 Vdd pmos W=0.0975U L=0.91U
M482_ Vdd O1_af_524_6 #fb931# Vdd pmos W=0.1625U L=0.13U
M483_keeper Vdd GND #929 Vdd pmos W=0.0975U L=0.26U
M484_ Vdd n__O0__t_525_6 #fb934# Vdd pmos W=0.1625U L=0.13U
M485_keeper Vdd GND #932 Vdd pmos W=0.0975U L=0.26U
M486_ Vdd n__O0__f_525_6 #fb937# Vdd pmos W=0.1625U L=0.13U
M487_keeper Vdd GND #935 Vdd pmos W=0.0975U L=0.91U
M488_ Vdd O1_at_525_6 #fb940# Vdd pmos W=0.1625U L=0.13U
M489_keeper Vdd GND #938 Vdd pmos W=0.0975U L=0.91U
M490_ Vdd O1_af_525_6 #fb943# Vdd pmos W=0.1625U L=0.13U
M491_keeper Vdd GND #941 Vdd pmos W=0.0975U L=0.26U
M492_ Vdd n__O0__t_526_6 #fb946# Vdd pmos W=0.1625U L=0.13U
M493_keeper Vdd GND #944 Vdd pmos W=0.0975U L=0.26U
M494_ Vdd n__O0__f_526_6 #fb949# Vdd pmos W=0.1625U L=0.13U
M495_keeper Vdd GND #947 Vdd pmos W=0.0975U L=0.91U
M496_ Vdd O1_at_526_6 #fb952# Vdd pmos W=0.1625U L=0.13U
M497_keeper Vdd GND #950 Vdd pmos W=0.0975U L=0.91U
M498_ Vdd O1_af_526_6 #fb955# Vdd pmos W=0.1625U L=0.13U
M499_keeper Vdd GND #953 Vdd pmos W=0.0975U L=0.26U
M500_ Vdd n__O0__t_527_6 #fb958# Vdd pmos W=0.1625U L=0.13U
M501_keeper Vdd GND #956 Vdd pmos W=0.0975U L=0.26U
M502_ Vdd n__O0__f_527_6 #fb961# Vdd pmos W=0.1625U L=0.13U
M503_keeper Vdd GND #959 Vdd pmos W=0.0975U L=0.91U
M504_ Vdd O1_at_527_6 #fb964# Vdd pmos W=0.1625U L=0.13U
M505_keeper Vdd GND #962 Vdd pmos W=0.0975U L=0.91U
M506_ Vdd O1_af_527_6 #fb967# Vdd pmos W=0.1625U L=0.13U
M507_keeper Vdd GND #965 Vdd pmos W=0.0975U L=0.26U
M508_ Vdd n__O0__t_528_6 #fb970# Vdd pmos W=0.1625U L=0.13U
M509_keeper Vdd GND #968 Vdd pmos W=0.0975U L=0.26U
M510_ Vdd n__O0__f_528_6 #fb973# Vdd pmos W=0.1625U L=0.13U
M511_keeper Vdd GND #971 Vdd pmos W=0.0975U L=0.91U
M512_ Vdd O1_at_528_6 #fb976# Vdd pmos W=0.1625U L=0.13U
M513_keeper Vdd GND #974 Vdd pmos W=0.0975U L=0.91U
M514_ Vdd O1_af_528_6 #fb979# Vdd pmos W=0.1625U L=0.13U
M515_keeper Vdd GND #977 Vdd pmos W=0.0975U L=0.26U
M516_ Vdd n__O0__t_529_6 #fb982# Vdd pmos W=0.1625U L=0.13U
M517_keeper Vdd GND #980 Vdd pmos W=0.0975U L=0.26U
M518_ Vdd n__O0__f_529_6 #fb985# Vdd pmos W=0.1625U L=0.13U
M519_keeper Vdd GND #983 Vdd pmos W=0.0975U L=0.91U
M520_ Vdd O1_at_529_6 #fb988# Vdd pmos W=0.1625U L=0.13U
M521_keeper Vdd GND #986 Vdd pmos W=0.0975U L=0.91U
M522_ Vdd O1_af_529_6 #fb991# Vdd pmos W=0.1625U L=0.13U
M523_keeper Vdd GND #989 Vdd pmos W=0.0975U L=0.26U
M524_ Vdd n__O0__t_530_6 #fb994# Vdd pmos W=0.1625U L=0.13U
M525_keeper Vdd GND #992 Vdd pmos W=0.0975U L=0.26U
M526_ Vdd n__O0__f_530_6 #fb997# Vdd pmos W=0.1625U L=0.13U
M527_keeper Vdd GND #995 Vdd pmos W=0.0975U L=0.91U
M528_ Vdd O1_at_530_6 #fb1000# Vdd pmos W=0.1625U L=0.13U
M529_keeper Vdd GND #998 Vdd pmos W=0.0975U L=0.91U
M530_ Vdd O1_af_530_6 #fb1003# Vdd pmos W=0.1625U L=0.13U
M531_keeper Vdd GND #1001 Vdd pmos W=0.0975U L=0.26U
M532_ Vdd n__O0__t_531_6 #fb1006# Vdd pmos W=0.1625U L=0.13U
M533_keeper Vdd GND #1004 Vdd pmos W=0.0975U L=0.26U
M534_ Vdd n__O0__f_531_6 #fb1009# Vdd pmos W=0.1625U L=0.13U
M535_keeper Vdd GND #1007 Vdd pmos W=0.0975U L=0.91U
M536_ Vdd O1_at_531_6 #fb1012# Vdd pmos W=0.1625U L=0.13U
M537_keeper Vdd GND #1010 Vdd pmos W=0.0975U L=0.91U
M538_ Vdd O1_af_531_6 #fb1015# Vdd pmos W=0.1625U L=0.13U
M539_keeper Vdd GND #1013 Vdd pmos W=0.0975U L=0.26U
M540_keeper Vdd GND #1016 Vdd pmos W=0.0975U L=0.26U
M541_ GND I_af_51_6 #7 GND nmos W=0.0975U L=0.065U
M542_ GND inv__s #16 GND nmos W=0.0975U L=0.065U
M543_ GND reset w__0i GND nmos W=0.0975U L=0.065U
M544_ GND inv__s #21 GND nmos W=0.0975U L=0.065U
M545_ GND inv__s #28 GND nmos W=0.0975U L=0.065U
M546_ GND w__0i s GND nmos W=0.0975U L=0.065U
M547_ GND O0_aa #37 GND nmos W=0.0975U L=0.065U
M548_ GND O1_aa #37 GND nmos W=0.0975U L=0.065U
M549_ GND p #46 GND nmos W=0.0975U L=0.065U
M550_ GND p #49 GND nmos W=0.0975U L=0.065U
M551_ GND inv__I__t_50_6 O1_at_50_6 GND nmos W=0.0975U L=0.065U
M552_ GND inv__I__f_50_6 O1_af_50_6 GND nmos W=0.0975U L=0.065U
M553_ GND p #60 GND nmos W=0.0975U L=0.065U
M554_ GND p #64 GND nmos W=0.0975U L=0.065U
M555_ GND inv__I__t_51_6 O1_at_51_6 GND nmos W=0.0975U L=0.065U
M556_ GND inv__I__f_51_6 O1_af_51_6 GND nmos W=0.0975U L=0.065U
M557_ GND p #73 GND nmos W=0.0975U L=0.065U
M558_ GND p #77 GND nmos W=0.0975U L=0.065U
M559_ GND inv__I__t_52_6 O1_at_52_6 GND nmos W=0.0975U L=0.065U
M560_ GND inv__I__f_52_6 O1_af_52_6 GND nmos W=0.0975U L=0.065U
M561_ GND p #89 GND nmos W=0.0975U L=0.065U
M562_ GND p #93 GND nmos W=0.0975U L=0.065U
M563_ GND inv__I__t_53_6 O1_at_53_6 GND nmos W=0.0975U L=0.065U
M564_ GND inv__I__f_53_6 O1_af_53_6 GND nmos W=0.0975U L=0.065U
M565_ GND p #105 GND nmos W=0.0975U L=0.065U
M566_ GND p #109 GND nmos W=0.0975U L=0.065U
M567_ GND inv__I__t_54_6 O1_at_54_6 GND nmos W=0.0975U L=0.065U
M568_ GND inv__I__f_54_6 O1_af_54_6 GND nmos W=0.0975U L=0.065U
M569_ GND p #121 GND nmos W=0.0975U L=0.065U
M570_ GND p #125 GND nmos W=0.0975U L=0.065U
M571_ GND inv__I__t_55_6 O1_at_55_6 GND nmos W=0.0975U L=0.065U
M572_ GND inv__I__f_55_6 O1_af_55_6 GND nmos W=0.0975U L=0.065U
M573_ GND p #137 GND nmos W=0.0975U L=0.065U
M574_ GND p #141 GND nmos W=0.0975U L=0.065U
M575_ GND inv__I__t_56_6 O1_at_56_6 GND nmos W=0.0975U L=0.065U
M576_ GND inv__I__f_56_6 O1_af_56_6 GND nmos W=0.0975U L=0.065U
M577_ GND p #153 GND nmos W=0.0975U L=0.065U
M578_ GND p #157 GND nmos W=0.0975U L=0.065U
M579_ GND inv__I__t_57_6 O1_at_57_6 GND nmos W=0.0975U L=0.065U
M580_ GND inv__I__f_57_6 O1_af_57_6 GND nmos W=0.0975U L=0.065U
M581_ GND p #169 GND nmos W=0.0975U L=0.065U
M582_ GND p #173 GND nmos W=0.0975U L=0.065U
M583_ GND inv__I__t_58_6 O1_at_58_6 GND nmos W=0.0975U L=0.065U
M584_ GND inv__I__f_58_6 O1_af_58_6 GND nmos W=0.0975U L=0.065U
M585_ GND p #185 GND nmos W=0.0975U L=0.065U
M586_ GND p #189 GND nmos W=0.0975U L=0.065U
M587_ GND inv__I__t_59_6 O1_at_59_6 GND nmos W=0.0975U L=0.065U
M588_ GND inv__I__f_59_6 O1_af_59_6 GND nmos W=0.0975U L=0.065U
M589_ GND p #201 GND nmos W=0.0975U L=0.065U
M590_ GND p #205 GND nmos W=0.0975U L=0.065U
M591_ GND inv__I__t_510_6 O1_at_510_6 GND nmos W=0.0975U L=0.065U
M592_ GND inv__I__f_510_6 O1_af_510_6 GND nmos W=0.0975U L=0.065U
M593_ GND p #217 GND nmos W=0.0975U L=0.065U
M594_ GND p #221 GND nmos W=0.0975U L=0.065U
M595_ GND inv__I__t_511_6 O1_at_511_6 GND nmos W=0.0975U L=0.065U
M596_ GND inv__I__f_511_6 O1_af_511_6 GND nmos W=0.0975U L=0.065U
M597_ GND p #233 GND nmos W=0.0975U L=0.065U
M598_ GND p #237 GND nmos W=0.0975U L=0.065U
M599_ GND inv__I__t_512_6 O1_at_512_6 GND nmos W=0.0975U L=0.065U
M600_ GND inv__I__f_512_6 O1_af_512_6 GND nmos W=0.0975U L=0.065U
M601_ GND p #249 GND nmos W=0.0975U L=0.065U
M602_ GND p #253 GND nmos W=0.0975U L=0.065U
M603_ GND inv__I__t_513_6 O1_at_513_6 GND nmos W=0.0975U L=0.065U
M604_ GND inv__I__f_513_6 O1_af_513_6 GND nmos W=0.0975U L=0.065U
M605_ GND p #265 GND nmos W=0.0975U L=0.065U
M606_ GND p #269 GND nmos W=0.0975U L=0.065U
M607_ GND inv__I__t_514_6 O1_at_514_6 GND nmos W=0.0975U L=0.065U
M608_ GND inv__I__f_514_6 O1_af_514_6 GND nmos W=0.0975U L=0.065U
M609_ GND p #281 GND nmos W=0.0975U L=0.065U
M610_ GND p #285 GND nmos W=0.0975U L=0.065U
M611_ GND inv__I__t_515_6 O1_at_515_6 GND nmos W=0.0975U L=0.065U
M612_ GND inv__I__f_515_6 O1_af_515_6 GND nmos W=0.0975U L=0.065U
M613_ GND p #297 GND nmos W=0.0975U L=0.065U
M614_ GND p #301 GND nmos W=0.0975U L=0.065U
M615_ GND inv__I__t_516_6 O1_at_516_6 GND nmos W=0.0975U L=0.065U
M616_ GND inv__I__f_516_6 O1_af_516_6 GND nmos W=0.0975U L=0.065U
M617_ GND p #313 GND nmos W=0.0975U L=0.065U
M618_ GND p #317 GND nmos W=0.0975U L=0.065U
M619_ GND inv__I__t_517_6 O1_at_517_6 GND nmos W=0.0975U L=0.065U
M620_ GND inv__I__f_517_6 O1_af_517_6 GND nmos W=0.0975U L=0.065U
M621_ GND p #329 GND nmos W=0.0975U L=0.065U
M622_ GND p #333 GND nmos W=0.0975U L=0.065U
M623_ GND inv__I__t_518_6 O1_at_518_6 GND nmos W=0.0975U L=0.065U
M624_ GND inv__I__f_518_6 O1_af_518_6 GND nmos W=0.0975U L=0.065U
M625_ GND p #345 GND nmos W=0.0975U L=0.065U
M626_ GND p #349 GND nmos W=0.0975U L=0.065U
M627_ GND inv__I__t_519_6 O1_at_519_6 GND nmos W=0.0975U L=0.065U
M628_ GND inv__I__f_519_6 O1_af_519_6 GND nmos W=0.0975U L=0.065U
M629_ GND p #361 GND nmos W=0.0975U L=0.065U
M630_ GND p #365 GND nmos W=0.0975U L=0.065U
M631_ GND inv__I__t_520_6 O1_at_520_6 GND nmos W=0.0975U L=0.065U
M632_ GND inv__I__f_520_6 O1_af_520_6 GND nmos W=0.0975U L=0.065U
M633_ GND p #377 GND nmos W=0.0975U L=0.065U
M634_ GND p #381 GND nmos W=0.0975U L=0.065U
M635_ GND inv__I__t_521_6 O1_at_521_6 GND nmos W=0.0975U L=0.065U
M636_ GND inv__I__f_521_6 O1_af_521_6 GND nmos W=0.0975U L=0.065U
M637_ GND p #393 GND nmos W=0.0975U L=0.065U
M638_ GND p #397 GND nmos W=0.0975U L=0.065U
M639_ GND inv__I__t_522_6 O1_at_522_6 GND nmos W=0.0975U L=0.065U
M640_ GND inv__I__f_522_6 O1_af_522_6 GND nmos W=0.0975U L=0.065U
M641_ GND p #409 GND nmos W=0.0975U L=0.065U
M642_ GND p #413 GND nmos W=0.0975U L=0.065U
M643_ GND inv__I__t_523_6 O1_at_523_6 GND nmos W=0.0975U L=0.065U
M644_ GND inv__I__f_523_6 O1_af_523_6 GND nmos W=0.0975U L=0.065U
M645_ GND p #425 GND nmos W=0.0975U L=0.065U
M646_ GND p #429 GND nmos W=0.0975U L=0.065U
M647_ GND inv__I__t_524_6 O1_at_524_6 GND nmos W=0.0975U L=0.065U
M648_ GND inv__I__f_524_6 O1_af_524_6 GND nmos W=0.0975U L=0.065U
M649_ GND p #441 GND nmos W=0.0975U L=0.065U
M650_ GND p #445 GND nmos W=0.0975U L=0.065U
M651_ GND inv__I__t_525_6 O1_at_525_6 GND nmos W=0.0975U L=0.065U
M652_ GND inv__I__f_525_6 O1_af_525_6 GND nmos W=0.0975U L=0.065U
M653_ GND p #457 GND nmos W=0.0975U L=0.065U
M654_ GND p #461 GND nmos W=0.0975U L=0.065U
M655_ GND inv__I__t_526_6 O1_at_526_6 GND nmos W=0.0975U L=0.065U
M656_ GND inv__I__f_526_6 O1_af_526_6 GND nmos W=0.0975U L=0.065U
M657_ GND p #473 GND nmos W=0.0975U L=0.065U
M658_ GND p #477 GND nmos W=0.0975U L=0.065U
M659_ GND inv__I__t_527_6 O1_at_527_6 GND nmos W=0.0975U L=0.065U
M660_ GND inv__I__f_527_6 O1_af_527_6 GND nmos W=0.0975U L=0.065U
M661_ GND p #489 GND nmos W=0.0975U L=0.065U
M662_ GND p #493 GND nmos W=0.0975U L=0.065U
M663_ GND inv__I__t_528_6 O1_at_528_6 GND nmos W=0.0975U L=0.065U
M664_ GND inv__I__f_528_6 O1_af_528_6 GND nmos W=0.0975U L=0.065U
M665_ GND p #505 GND nmos W=0.0975U L=0.065U
M666_ GND p #509 GND nmos W=0.0975U L=0.065U
M667_ GND inv__I__t_529_6 O1_at_529_6 GND nmos W=0.0975U L=0.065U
M668_ GND inv__I__f_529_6 O1_af_529_6 GND nmos W=0.0975U L=0.065U
M669_ GND p #521 GND nmos W=0.0975U L=0.065U
M670_ GND p #525 GND nmos W=0.0975U L=0.065U
M671_ GND inv__I__t_530_6 O1_at_530_6 GND nmos W=0.0975U L=0.065U
M672_ GND inv__I__f_530_6 O1_af_530_6 GND nmos W=0.0975U L=0.065U
M673_ GND p #537 GND nmos W=0.0975U L=0.065U
M674_ GND p #541 GND nmos W=0.0975U L=0.065U
M675_ GND inv__I__t_531_6 O1_at_531_6 GND nmos W=0.0975U L=0.065U
M676_ GND inv__I__f_531_6 O1_af_531_6 GND nmos W=0.0975U L=0.065U
M677_ GND s inv__s GND nmos W=0.0975U L=0.065U
M678_ GND reset inv__reset GND nmos W=0.0975U L=0.065U
M679_ GND p inv__p GND nmos W=0.0975U L=0.065U
M680_ GND w__0i inv__w__0i GND nmos W=0.0975U L=0.065U
M681_ GND n__w__0 w__0 GND nmos W=0.0975U L=0.065U
M682_ GND n__w__1 w__1 GND nmos W=0.0975U L=0.065U
M683_ GND I_at_50_6 inv__I__t_50_6 GND nmos W=0.0975U L=0.065U
M684_ GND I_af_50_6 inv__I__f_50_6 GND nmos W=0.0975U L=0.065U
M685_ GND I_at_51_6 inv__I__t_51_6 GND nmos W=0.0975U L=0.065U
M686_ GND I_af_51_6 inv__I__f_51_6 GND nmos W=0.0975U L=0.065U
M687_ GND I_at_52_6 inv__I__t_52_6 GND nmos W=0.0975U L=0.065U
M688_ GND I_af_52_6 inv__I__f_52_6 GND nmos W=0.0975U L=0.065U
M689_ GND I_at_53_6 inv__I__t_53_6 GND nmos W=0.0975U L=0.065U
M690_ GND I_af_53_6 inv__I__f_53_6 GND nmos W=0.0975U L=0.065U
M691_ GND I_at_54_6 inv__I__t_54_6 GND nmos W=0.0975U L=0.065U
M692_ GND I_af_54_6 inv__I__f_54_6 GND nmos W=0.0975U L=0.065U
M693_ GND I_at_55_6 inv__I__t_55_6 GND nmos W=0.0975U L=0.065U
M694_ GND I_af_55_6 inv__I__f_55_6 GND nmos W=0.0975U L=0.065U
M695_ GND I_at_56_6 inv__I__t_56_6 GND nmos W=0.0975U L=0.065U
M696_ GND I_af_56_6 inv__I__f_56_6 GND nmos W=0.0975U L=0.065U
M697_ GND I_at_57_6 inv__I__t_57_6 GND nmos W=0.0975U L=0.065U
M698_ GND I_af_57_6 inv__I__f_57_6 GND nmos W=0.0975U L=0.065U
M699_ GND I_at_58_6 inv__I__t_58_6 GND nmos W=0.0975U L=0.065U
M700_ GND I_af_58_6 inv__I__f_58_6 GND nmos W=0.0975U L=0.065U
M701_ GND I_at_59_6 inv__I__t_59_6 GND nmos W=0.0975U L=0.065U
M702_ GND I_af_59_6 inv__I__f_59_6 GND nmos W=0.0975U L=0.065U
M703_ GND I_at_510_6 inv__I__t_510_6 GND nmos W=0.0975U L=0.065U
M704_ GND I_af_510_6 inv__I__f_510_6 GND nmos W=0.0975U L=0.065U
M705_ GND I_at_511_6 inv__I__t_511_6 GND nmos W=0.0975U L=0.065U
M706_ GND I_af_511_6 inv__I__f_511_6 GND nmos W=0.0975U L=0.065U
M707_ GND I_at_512_6 inv__I__t_512_6 GND nmos W=0.0975U L=0.065U
M708_ GND I_af_512_6 inv__I__f_512_6 GND nmos W=0.0975U L=0.065U
M709_ GND I_at_513_6 inv__I__t_513_6 GND nmos W=0.0975U L=0.065U
M710_ GND I_af_513_6 inv__I__f_513_6 GND nmos W=0.0975U L=0.065U
M711_ GND I_at_514_6 inv__I__t_514_6 GND nmos W=0.0975U L=0.065U
M712_ GND I_af_514_6 inv__I__f_514_6 GND nmos W=0.0975U L=0.065U
M713_ GND I_at_515_6 inv__I__t_515_6 GND nmos W=0.0975U L=0.065U
M714_ GND I_af_515_6 inv__I__f_515_6 GND nmos W=0.0975U L=0.065U
M715_ GND I_at_516_6 inv__I__t_516_6 GND nmos W=0.0975U L=0.065U
M716_ GND I_af_516_6 inv__I__f_516_6 GND nmos W=0.0975U L=0.065U
M717_ GND I_at_517_6 inv__I__t_517_6 GND nmos W=0.0975U L=0.065U
M718_ GND I_af_517_6 inv__I__f_517_6 GND nmos W=0.0975U L=0.065U
M719_ GND I_at_518_6 inv__I__t_518_6 GND nmos W=0.0975U L=0.065U
M720_ GND I_af_518_6 inv__I__f_518_6 GND nmos W=0.0975U L=0.065U
M721_ GND I_at_519_6 inv__I__t_519_6 GND nmos W=0.0975U L=0.065U
M722_ GND I_af_519_6 inv__I__f_519_6 GND nmos W=0.0975U L=0.065U
M723_ GND I_at_520_6 inv__I__t_520_6 GND nmos W=0.0975U L=0.065U
M724_ GND I_af_520_6 inv__I__f_520_6 GND nmos W=0.0975U L=0.065U
M725_ GND I_at_521_6 inv__I__t_521_6 GND nmos W=0.0975U L=0.065U
M726_ GND I_af_521_6 inv__I__f_521_6 GND nmos W=0.0975U L=0.065U
M727_ GND I_at_522_6 inv__I__t_522_6 GND nmos W=0.0975U L=0.065U
M728_ GND I_af_522_6 inv__I__f_522_6 GND nmos W=0.0975U L=0.065U
M729_ GND I_at_523_6 inv__I__t_523_6 GND nmos W=0.0975U L=0.065U
M730_ GND I_af_523_6 inv__I__f_523_6 GND nmos W=0.0975U L=0.065U
M731_ GND I_at_524_6 inv__I__t_524_6 GND nmos W=0.0975U L=0.065U
M732_ GND I_af_524_6 inv__I__f_524_6 GND nmos W=0.0975U L=0.065U
M733_ GND I_at_525_6 inv__I__t_525_6 GND nmos W=0.0975U L=0.065U
M734_ GND I_af_525_6 inv__I__f_525_6 GND nmos W=0.0975U L=0.065U
M735_ GND I_at_526_6 inv__I__t_526_6 GND nmos W=0.0975U L=0.065U
M736_ GND I_af_526_6 inv__I__f_526_6 GND nmos W=0.0975U L=0.065U
M737_ GND I_at_527_6 inv__I__t_527_6 GND nmos W=0.0975U L=0.065U
M738_ GND I_af_527_6 inv__I__f_527_6 GND nmos W=0.0975U L=0.065U
M739_ GND I_at_528_6 inv__I__t_528_6 GND nmos W=0.0975U L=0.065U
M740_ GND I_af_528_6 inv__I__f_528_6 GND nmos W=0.0975U L=0.065U
M741_ GND I_at_529_6 inv__I__t_529_6 GND nmos W=0.0975U L=0.065U
M742_ GND I_af_529_6 inv__I__f_529_6 GND nmos W=0.0975U L=0.065U
M743_ GND I_at_530_6 inv__I__t_530_6 GND nmos W=0.0975U L=0.065U
M744_ GND I_af_530_6 inv__I__f_530_6 GND nmos W=0.0975U L=0.065U
M745_ GND I_at_531_6 inv__I__t_531_6 GND nmos W=0.0975U L=0.065U
M746_ GND I_af_531_6 inv__I__f_531_6 GND nmos W=0.0975U L=0.065U
M747_ GND n__I__a I_aa GND nmos W=0.0975U L=0.065U
M748_ GND n__O0__t_50_6 O0_at_50_6 GND nmos W=0.0975U L=0.065U
M749_ GND n__O0__f_50_6 O0_af_50_6 GND nmos W=0.0975U L=0.065U
M750_ GND n__O0__t_51_6 O0_at_51_6 GND nmos W=0.0975U L=0.065U
M751_ GND n__O0__f_51_6 O0_af_51_6 GND nmos W=0.0975U L=0.065U
M752_ GND n__O0__t_52_6 O0_at_52_6 GND nmos W=0.0975U L=0.065U
M753_ GND n__O0__f_52_6 O0_af_52_6 GND nmos W=0.0975U L=0.065U
M754_ GND n__O0__t_53_6 O0_at_53_6 GND nmos W=0.0975U L=0.065U
M755_ GND n__O0__f_53_6 O0_af_53_6 GND nmos W=0.0975U L=0.065U
M756_ GND n__O0__t_54_6 O0_at_54_6 GND nmos W=0.0975U L=0.065U
M757_ GND n__O0__f_54_6 O0_af_54_6 GND nmos W=0.0975U L=0.065U
M758_ GND n__O0__t_55_6 O0_at_55_6 GND nmos W=0.0975U L=0.065U
M759_ GND n__O0__f_55_6 O0_af_55_6 GND nmos W=0.0975U L=0.065U
M760_ GND n__O0__t_56_6 O0_at_56_6 GND nmos W=0.0975U L=0.065U
M761_ GND n__O0__f_56_6 O0_af_56_6 GND nmos W=0.0975U L=0.065U
M762_ GND n__O0__t_57_6 O0_at_57_6 GND nmos W=0.0975U L=0.065U
M763_ GND n__O0__f_57_6 O0_af_57_6 GND nmos W=0.0975U L=0.065U
M764_ GND n__O0__t_58_6 O0_at_58_6 GND nmos W=0.0975U L=0.065U
M765_ GND n__O0__f_58_6 O0_af_58_6 GND nmos W=0.0975U L=0.065U
M766_ GND n__O0__t_59_6 O0_at_59_6 GND nmos W=0.0975U L=0.065U
M767_ GND n__O0__f_59_6 O0_af_59_6 GND nmos W=0.0975U L=0.065U
M768_ GND n__O0__t_510_6 O0_at_510_6 GND nmos W=0.0975U L=0.065U
M769_ GND n__O0__f_510_6 O0_af_510_6 GND nmos W=0.0975U L=0.065U
M770_ GND n__O0__t_511_6 O0_at_511_6 GND nmos W=0.0975U L=0.065U
M771_ GND n__O0__f_511_6 O0_af_511_6 GND nmos W=0.0975U L=0.065U
M772_ GND n__O0__t_512_6 O0_at_512_6 GND nmos W=0.0975U L=0.065U
M773_ GND n__O0__f_512_6 O0_af_512_6 GND nmos W=0.0975U L=0.065U
M774_ GND n__O0__t_513_6 O0_at_513_6 GND nmos W=0.0975U L=0.065U
M775_ GND n__O0__f_513_6 O0_af_513_6 GND nmos W=0.0975U L=0.065U
M776_ GND n__O0__t_514_6 O0_at_514_6 GND nmos W=0.0975U L=0.065U
M777_ GND n__O0__f_514_6 O0_af_514_6 GND nmos W=0.0975U L=0.065U
M778_ GND n__O0__t_515_6 O0_at_515_6 GND nmos W=0.0975U L=0.065U
M779_ GND n__O0__f_515_6 O0_af_515_6 GND nmos W=0.0975U L=0.065U
M780_ GND n__O0__t_516_6 O0_at_516_6 GND nmos W=0.0975U L=0.065U
M781_ GND n__O0__f_516_6 O0_af_516_6 GND nmos W=0.0975U L=0.065U
M782_ GND n__O0__t_517_6 O0_at_517_6 GND nmos W=0.0975U L=0.065U
M783_ GND n__O0__f_517_6 O0_af_517_6 GND nmos W=0.0975U L=0.065U
M784_ GND n__O0__t_518_6 O0_at_518_6 GND nmos W=0.0975U L=0.065U
M785_ GND n__O0__f_518_6 O0_af_518_6 GND nmos W=0.0975U L=0.065U
M786_ GND n__O0__t_519_6 O0_at_519_6 GND nmos W=0.0975U L=0.065U
M787_ GND n__O0__f_519_6 O0_af_519_6 GND nmos W=0.0975U L=0.065U
M788_ GND n__O0__t_520_6 O0_at_520_6 GND nmos W=0.0975U L=0.065U
M789_ GND n__O0__f_520_6 O0_af_520_6 GND nmos W=0.0975U L=0.065U
M790_ GND n__O0__t_521_6 O0_at_521_6 GND nmos W=0.0975U L=0.065U
M791_ GND n__O0__f_521_6 O0_af_521_6 GND nmos W=0.0975U L=0.065U
M792_ GND n__O0__t_522_6 O0_at_522_6 GND nmos W=0.0975U L=0.065U
M793_ GND n__O0__f_522_6 O0_af_522_6 GND nmos W=0.0975U L=0.065U
M794_ GND n__O0__t_523_6 O0_at_523_6 GND nmos W=0.0975U L=0.065U
M795_ GND n__O0__f_523_6 O0_af_523_6 GND nmos W=0.0975U L=0.065U
M796_ GND n__O0__t_524_6 O0_at_524_6 GND nmos W=0.0975U L=0.065U
M797_ GND n__O0__f_524_6 O0_af_524_6 GND nmos W=0.0975U L=0.065U
M798_ GND n__O0__t_525_6 O0_at_525_6 GND nmos W=0.0975U L=0.065U
M799_ GND n__O0__f_525_6 O0_af_525_6 GND nmos W=0.0975U L=0.065U
M800_ GND n__O0__t_526_6 O0_at_526_6 GND nmos W=0.0975U L=0.065U
M801_ GND n__O0__f_526_6 O0_af_526_6 GND nmos W=0.0975U L=0.065U
M802_ GND n__O0__t_527_6 O0_at_527_6 GND nmos W=0.0975U L=0.065U
M803_ GND n__O0__f_527_6 O0_af_527_6 GND nmos W=0.0975U L=0.065U
M804_ GND n__O0__t_528_6 O0_at_528_6 GND nmos W=0.0975U L=0.065U
M805_ GND n__O0__f_528_6 O0_af_528_6 GND nmos W=0.0975U L=0.065U
M806_ GND n__O0__t_529_6 O0_at_529_6 GND nmos W=0.0975U L=0.065U
M807_ GND n__O0__f_529_6 O0_af_529_6 GND nmos W=0.0975U L=0.065U
M808_ GND n__O0__t_530_6 O0_at_530_6 GND nmos W=0.0975U L=0.065U
M809_ GND n__O0__f_530_6 O0_af_530_6 GND nmos W=0.0975U L=0.065U
M810_ GND n__O0__t_531_6 O0_at_531_6 GND nmos W=0.0975U L=0.065U
M811_ GND n__O0__f_531_6 O0_af_531_6 GND nmos W=0.0975U L=0.065U
M812_ GND p #fb616# GND nmos W=0.0975U L=0.13U
M813_ GND s #fb619# GND nmos W=0.0975U L=0.13U
M814_keeper GND Vdd #618 GND nmos W=0.0975U L=1.495U
M815_ GND w__0i #fb622# GND nmos W=0.0975U L=0.13U
M816_keeper GND Vdd #621 GND nmos W=0.0975U L=3.055U
M817_ GND n__w__0 #fb625# GND nmos W=0.0975U L=0.13U
M818_keeper GND Vdd #624 GND nmos W=0.0975U L=2.275U
M819_ GND n__I__a #fb628# GND nmos W=0.0975U L=0.13U
M820_keeper GND Vdd #627 GND nmos W=0.0975U L=3.055U
M821_ GND n__w__1 #fb631# GND nmos W=0.0975U L=0.13U
M822_keeper GND Vdd #630 GND nmos W=0.0975U L=3.055U
M823_ GND n__O0__t_50_6 #fb634# GND nmos W=0.0975U L=0.13U
M824_keeper GND Vdd #633 GND nmos W=0.0975U L=3.055U
M825_ GND n__O0__f_50_6 #fb637# GND nmos W=0.0975U L=0.13U
M826_keeper GND Vdd #636 GND nmos W=0.0975U L=0.715U
M827_ GND O1_at_50_6 #fb640# GND nmos W=0.0975U L=0.13U
M828_keeper GND Vdd #639 GND nmos W=0.0975U L=0.715U
M829_ GND O1_af_50_6 #fb643# GND nmos W=0.0975U L=0.13U
M830_keeper GND Vdd #642 GND nmos W=0.0975U L=2.275U
M831_ GND n__O0__t_51_6 #fb646# GND nmos W=0.0975U L=0.13U
M832_keeper GND Vdd #645 GND nmos W=0.0975U L=2.275U
M833_ GND n__O0__f_51_6 #fb649# GND nmos W=0.0975U L=0.13U
M834_keeper GND Vdd #648 GND nmos W=0.0975U L=0.715U
M835_ GND O1_at_51_6 #fb652# GND nmos W=0.0975U L=0.13U
M836_keeper GND Vdd #651 GND nmos W=0.0975U L=0.715U
M837_ GND O1_af_51_6 #fb655# GND nmos W=0.0975U L=0.13U
M838_keeper GND Vdd #654 GND nmos W=0.0975U L=2.275U
M839_ GND n__O0__t_52_6 #fb658# GND nmos W=0.0975U L=0.13U
M840_keeper GND Vdd #657 GND nmos W=0.0975U L=2.275U
M841_ GND n__O0__f_52_6 #fb661# GND nmos W=0.0975U L=0.13U
M842_keeper GND Vdd #660 GND nmos W=0.0975U L=0.715U
M843_ GND O1_at_52_6 #fb664# GND nmos W=0.0975U L=0.13U
M844_keeper GND Vdd #663 GND nmos W=0.0975U L=0.715U
M845_ GND O1_af_52_6 #fb667# GND nmos W=0.0975U L=0.13U
M846_keeper GND Vdd #666 GND nmos W=0.0975U L=2.275U
M847_ GND n__O0__t_53_6 #fb670# GND nmos W=0.0975U L=0.13U
M848_keeper GND Vdd #669 GND nmos W=0.0975U L=2.275U
M849_ GND n__O0__f_53_6 #fb673# GND nmos W=0.0975U L=0.13U
M850_keeper GND Vdd #672 GND nmos W=0.0975U L=0.715U
M851_ GND O1_at_53_6 #fb676# GND nmos W=0.0975U L=0.13U
M852_keeper GND Vdd #675 GND nmos W=0.0975U L=0.715U
M853_ GND O1_af_53_6 #fb679# GND nmos W=0.0975U L=0.13U
M854_keeper GND Vdd #678 GND nmos W=0.0975U L=2.275U
M855_ GND n__O0__t_54_6 #fb682# GND nmos W=0.0975U L=0.13U
M856_keeper GND Vdd #681 GND nmos W=0.0975U L=2.275U
M857_ GND n__O0__f_54_6 #fb685# GND nmos W=0.0975U L=0.13U
M858_keeper GND Vdd #684 GND nmos W=0.0975U L=0.715U
M859_ GND O1_at_54_6 #fb688# GND nmos W=0.0975U L=0.13U
M860_keeper GND Vdd #687 GND nmos W=0.0975U L=0.715U
M861_ GND O1_af_54_6 #fb691# GND nmos W=0.0975U L=0.13U
M862_keeper GND Vdd #690 GND nmos W=0.0975U L=2.275U
M863_ GND n__O0__t_55_6 #fb694# GND nmos W=0.0975U L=0.13U
M864_keeper GND Vdd #693 GND nmos W=0.0975U L=2.275U
M865_ GND n__O0__f_55_6 #fb697# GND nmos W=0.0975U L=0.13U
M866_keeper GND Vdd #696 GND nmos W=0.0975U L=0.715U
M867_ GND O1_at_55_6 #fb700# GND nmos W=0.0975U L=0.13U
M868_keeper GND Vdd #699 GND nmos W=0.0975U L=0.715U
M869_ GND O1_af_55_6 #fb703# GND nmos W=0.0975U L=0.13U
M870_keeper GND Vdd #702 GND nmos W=0.0975U L=2.275U
M871_ GND n__O0__t_56_6 #fb706# GND nmos W=0.0975U L=0.13U
M872_keeper GND Vdd #705 GND nmos W=0.0975U L=2.275U
M873_ GND n__O0__f_56_6 #fb709# GND nmos W=0.0975U L=0.13U
M874_keeper GND Vdd #708 GND nmos W=0.0975U L=0.715U
M875_ GND O1_at_56_6 #fb712# GND nmos W=0.0975U L=0.13U
M876_keeper GND Vdd #711 GND nmos W=0.0975U L=0.715U
M877_ GND O1_af_56_6 #fb715# GND nmos W=0.0975U L=0.13U
M878_keeper GND Vdd #714 GND nmos W=0.0975U L=2.275U
M879_ GND n__O0__t_57_6 #fb718# GND nmos W=0.0975U L=0.13U
M880_keeper GND Vdd #717 GND nmos W=0.0975U L=2.275U
M881_ GND n__O0__f_57_6 #fb721# GND nmos W=0.0975U L=0.13U
M882_keeper GND Vdd #720 GND nmos W=0.0975U L=0.715U
M883_ GND O1_at_57_6 #fb724# GND nmos W=0.0975U L=0.13U
M884_keeper GND Vdd #723 GND nmos W=0.0975U L=0.715U
M885_ GND O1_af_57_6 #fb727# GND nmos W=0.0975U L=0.13U
M886_keeper GND Vdd #726 GND nmos W=0.0975U L=2.275U
M887_ GND n__O0__t_58_6 #fb730# GND nmos W=0.0975U L=0.13U
M888_keeper GND Vdd #729 GND nmos W=0.0975U L=2.275U
M889_ GND n__O0__f_58_6 #fb733# GND nmos W=0.0975U L=0.13U
M890_keeper GND Vdd #732 GND nmos W=0.0975U L=0.715U
M891_ GND O1_at_58_6 #fb736# GND nmos W=0.0975U L=0.13U
M892_keeper GND Vdd #735 GND nmos W=0.0975U L=0.715U
M893_ GND O1_af_58_6 #fb739# GND nmos W=0.0975U L=0.13U
M894_keeper GND Vdd #738 GND nmos W=0.0975U L=2.275U
M895_ GND n__O0__t_59_6 #fb742# GND nmos W=0.0975U L=0.13U
M896_keeper GND Vdd #741 GND nmos W=0.0975U L=2.275U
M897_ GND n__O0__f_59_6 #fb745# GND nmos W=0.0975U L=0.13U
M898_keeper GND Vdd #744 GND nmos W=0.0975U L=0.715U
M899_ GND O1_at_59_6 #fb748# GND nmos W=0.0975U L=0.13U
M900_keeper GND Vdd #747 GND nmos W=0.0975U L=0.715U
M901_ GND O1_af_59_6 #fb751# GND nmos W=0.0975U L=0.13U
M902_keeper GND Vdd #750 GND nmos W=0.0975U L=2.275U
M903_ GND n__O0__t_510_6 #fb754# GND nmos W=0.0975U L=0.13U
M904_keeper GND Vdd #753 GND nmos W=0.0975U L=2.275U
M905_ GND n__O0__f_510_6 #fb757# GND nmos W=0.0975U L=0.13U
M906_keeper GND Vdd #756 GND nmos W=0.0975U L=0.715U
M907_ GND O1_at_510_6 #fb760# GND nmos W=0.0975U L=0.13U
M908_keeper GND Vdd #759 GND nmos W=0.0975U L=0.715U
M909_ GND O1_af_510_6 #fb763# GND nmos W=0.0975U L=0.13U
M910_keeper GND Vdd #762 GND nmos W=0.0975U L=2.275U
M911_ GND n__O0__t_511_6 #fb766# GND nmos W=0.0975U L=0.13U
M912_keeper GND Vdd #765 GND nmos W=0.0975U L=2.275U
M913_ GND n__O0__f_511_6 #fb769# GND nmos W=0.0975U L=0.13U
M914_keeper GND Vdd #768 GND nmos W=0.0975U L=0.715U
M915_ GND O1_at_511_6 #fb772# GND nmos W=0.0975U L=0.13U
M916_keeper GND Vdd #771 GND nmos W=0.0975U L=0.715U
M917_ GND O1_af_511_6 #fb775# GND nmos W=0.0975U L=0.13U
M918_keeper GND Vdd #774 GND nmos W=0.0975U L=2.275U
M919_ GND n__O0__t_512_6 #fb778# GND nmos W=0.0975U L=0.13U
M920_keeper GND Vdd #777 GND nmos W=0.0975U L=2.275U
M921_ GND n__O0__f_512_6 #fb781# GND nmos W=0.0975U L=0.13U
M922_keeper GND Vdd #780 GND nmos W=0.0975U L=0.715U
M923_ GND O1_at_512_6 #fb784# GND nmos W=0.0975U L=0.13U
M924_keeper GND Vdd #783 GND nmos W=0.0975U L=0.715U
M925_ GND O1_af_512_6 #fb787# GND nmos W=0.0975U L=0.13U
M926_keeper GND Vdd #786 GND nmos W=0.0975U L=2.275U
M927_ GND n__O0__t_513_6 #fb790# GND nmos W=0.0975U L=0.13U
M928_keeper GND Vdd #789 GND nmos W=0.0975U L=2.275U
M929_ GND n__O0__f_513_6 #fb793# GND nmos W=0.0975U L=0.13U
M930_keeper GND Vdd #792 GND nmos W=0.0975U L=0.715U
M931_ GND O1_at_513_6 #fb796# GND nmos W=0.0975U L=0.13U
M932_keeper GND Vdd #795 GND nmos W=0.0975U L=0.715U
M933_ GND O1_af_513_6 #fb799# GND nmos W=0.0975U L=0.13U
M934_keeper GND Vdd #798 GND nmos W=0.0975U L=2.275U
M935_ GND n__O0__t_514_6 #fb802# GND nmos W=0.0975U L=0.13U
M936_keeper GND Vdd #801 GND nmos W=0.0975U L=2.275U
M937_ GND n__O0__f_514_6 #fb805# GND nmos W=0.0975U L=0.13U
M938_keeper GND Vdd #804 GND nmos W=0.0975U L=0.715U
M939_ GND O1_at_514_6 #fb808# GND nmos W=0.0975U L=0.13U
M940_keeper GND Vdd #807 GND nmos W=0.0975U L=0.715U
M941_ GND O1_af_514_6 #fb811# GND nmos W=0.0975U L=0.13U
M942_keeper GND Vdd #810 GND nmos W=0.0975U L=2.275U
M943_ GND n__O0__t_515_6 #fb814# GND nmos W=0.0975U L=0.13U
M944_keeper GND Vdd #813 GND nmos W=0.0975U L=2.275U
M945_ GND n__O0__f_515_6 #fb817# GND nmos W=0.0975U L=0.13U
M946_keeper GND Vdd #816 GND nmos W=0.0975U L=0.715U
M947_ GND O1_at_515_6 #fb820# GND nmos W=0.0975U L=0.13U
M948_keeper GND Vdd #819 GND nmos W=0.0975U L=0.715U
M949_ GND O1_af_515_6 #fb823# GND nmos W=0.0975U L=0.13U
M950_keeper GND Vdd #822 GND nmos W=0.0975U L=2.275U
M951_ GND n__O0__t_516_6 #fb826# GND nmos W=0.0975U L=0.13U
M952_keeper GND Vdd #825 GND nmos W=0.0975U L=2.275U
M953_ GND n__O0__f_516_6 #fb829# GND nmos W=0.0975U L=0.13U
M954_keeper GND Vdd #828 GND nmos W=0.0975U L=0.715U
M955_ GND O1_at_516_6 #fb832# GND nmos W=0.0975U L=0.13U
M956_keeper GND Vdd #831 GND nmos W=0.0975U L=0.715U
M957_ GND O1_af_516_6 #fb835# GND nmos W=0.0975U L=0.13U
M958_keeper GND Vdd #834 GND nmos W=0.0975U L=2.275U
M959_ GND n__O0__t_517_6 #fb838# GND nmos W=0.0975U L=0.13U
M960_keeper GND Vdd #837 GND nmos W=0.0975U L=2.275U
M961_ GND n__O0__f_517_6 #fb841# GND nmos W=0.0975U L=0.13U
M962_keeper GND Vdd #840 GND nmos W=0.0975U L=0.715U
M963_ GND O1_at_517_6 #fb844# GND nmos W=0.0975U L=0.13U
M964_keeper GND Vdd #843 GND nmos W=0.0975U L=0.715U
M965_ GND O1_af_517_6 #fb847# GND nmos W=0.0975U L=0.13U
M966_keeper GND Vdd #846 GND nmos W=0.0975U L=2.275U
M967_ GND n__O0__t_518_6 #fb850# GND nmos W=0.0975U L=0.13U
M968_keeper GND Vdd #849 GND nmos W=0.0975U L=2.275U
M969_ GND n__O0__f_518_6 #fb853# GND nmos W=0.0975U L=0.13U
M970_keeper GND Vdd #852 GND nmos W=0.0975U L=0.715U
M971_ GND O1_at_518_6 #fb856# GND nmos W=0.0975U L=0.13U
M972_keeper GND Vdd #855 GND nmos W=0.0975U L=0.715U
M973_ GND O1_af_518_6 #fb859# GND nmos W=0.0975U L=0.13U
M974_keeper GND Vdd #858 GND nmos W=0.0975U L=2.275U
M975_ GND n__O0__t_519_6 #fb862# GND nmos W=0.0975U L=0.13U
M976_keeper GND Vdd #861 GND nmos W=0.0975U L=2.275U
M977_ GND n__O0__f_519_6 #fb865# GND nmos W=0.0975U L=0.13U
M978_keeper GND Vdd #864 GND nmos W=0.0975U L=0.715U
M979_ GND O1_at_519_6 #fb868# GND nmos W=0.0975U L=0.13U
M980_keeper GND Vdd #867 GND nmos W=0.0975U L=0.715U
M981_ GND O1_af_519_6 #fb871# GND nmos W=0.0975U L=0.13U
M982_keeper GND Vdd #870 GND nmos W=0.0975U L=2.275U
M983_ GND n__O0__t_520_6 #fb874# GND nmos W=0.0975U L=0.13U
M984_keeper GND Vdd #873 GND nmos W=0.0975U L=2.275U
M985_ GND n__O0__f_520_6 #fb877# GND nmos W=0.0975U L=0.13U
M986_keeper GND Vdd #876 GND nmos W=0.0975U L=0.715U
M987_ GND O1_at_520_6 #fb880# GND nmos W=0.0975U L=0.13U
M988_keeper GND Vdd #879 GND nmos W=0.0975U L=0.715U
M989_ GND O1_af_520_6 #fb883# GND nmos W=0.0975U L=0.13U
M990_keeper GND Vdd #882 GND nmos W=0.0975U L=2.275U
M991_ GND n__O0__t_521_6 #fb886# GND nmos W=0.0975U L=0.13U
M992_keeper GND Vdd #885 GND nmos W=0.0975U L=2.275U
M993_ GND n__O0__f_521_6 #fb889# GND nmos W=0.0975U L=0.13U
M994_keeper GND Vdd #888 GND nmos W=0.0975U L=0.715U
M995_ GND O1_at_521_6 #fb892# GND nmos W=0.0975U L=0.13U
M996_keeper GND Vdd #891 GND nmos W=0.0975U L=0.715U
M997_ GND O1_af_521_6 #fb895# GND nmos W=0.0975U L=0.13U
M998_keeper GND Vdd #894 GND nmos W=0.0975U L=2.275U
M999_ GND n__O0__t_522_6 #fb898# GND nmos W=0.0975U L=0.13U
M1000_keeper GND Vdd #897 GND nmos W=0.0975U L=2.275U
M1001_ GND n__O0__f_522_6 #fb901# GND nmos W=0.0975U L=0.13U
M1002_keeper GND Vdd #900 GND nmos W=0.0975U L=0.715U
M1003_ GND O1_at_522_6 #fb904# GND nmos W=0.0975U L=0.13U
M1004_keeper GND Vdd #903 GND nmos W=0.0975U L=0.715U
M1005_ GND O1_af_522_6 #fb907# GND nmos W=0.0975U L=0.13U
M1006_keeper GND Vdd #906 GND nmos W=0.0975U L=2.275U
M1007_ GND n__O0__t_523_6 #fb910# GND nmos W=0.0975U L=0.13U
M1008_keeper GND Vdd #909 GND nmos W=0.0975U L=2.275U
M1009_ GND n__O0__f_523_6 #fb913# GND nmos W=0.0975U L=0.13U
M1010_keeper GND Vdd #912 GND nmos W=0.0975U L=0.715U
M1011_ GND O1_at_523_6 #fb916# GND nmos W=0.0975U L=0.13U
M1012_keeper GND Vdd #915 GND nmos W=0.0975U L=0.715U
M1013_ GND O1_af_523_6 #fb919# GND nmos W=0.0975U L=0.13U
M1014_keeper GND Vdd #918 GND nmos W=0.0975U L=2.275U
M1015_ GND n__O0__t_524_6 #fb922# GND nmos W=0.0975U L=0.13U
M1016_keeper GND Vdd #921 GND nmos W=0.0975U L=2.275U
M1017_ GND n__O0__f_524_6 #fb925# GND nmos W=0.0975U L=0.13U
M1018_keeper GND Vdd #924 GND nmos W=0.0975U L=0.715U
M1019_ GND O1_at_524_6 #fb928# GND nmos W=0.0975U L=0.13U
M1020_keeper GND Vdd #927 GND nmos W=0.0975U L=0.715U
M1021_ GND O1_af_524_6 #fb931# GND nmos W=0.0975U L=0.13U
M1022_keeper GND Vdd #930 GND nmos W=0.0975U L=2.275U
M1023_ GND n__O0__t_525_6 #fb934# GND nmos W=0.0975U L=0.13U
M1024_keeper GND Vdd #933 GND nmos W=0.0975U L=2.275U
M1025_ GND n__O0__f_525_6 #fb937# GND nmos W=0.0975U L=0.13U
M1026_keeper GND Vdd #936 GND nmos W=0.0975U L=0.715U
M1027_ GND O1_at_525_6 #fb940# GND nmos W=0.0975U L=0.13U
M1028_keeper GND Vdd #939 GND nmos W=0.0975U L=0.715U
M1029_ GND O1_af_525_6 #fb943# GND nmos W=0.0975U L=0.13U
M1030_keeper GND Vdd #942 GND nmos W=0.0975U L=2.275U
M1031_ GND n__O0__t_526_6 #fb946# GND nmos W=0.0975U L=0.13U
M1032_keeper GND Vdd #945 GND nmos W=0.0975U L=2.275U
M1033_ GND n__O0__f_526_6 #fb949# GND nmos W=0.0975U L=0.13U
M1034_keeper GND Vdd #948 GND nmos W=0.0975U L=0.715U
M1035_ GND O1_at_526_6 #fb952# GND nmos W=0.0975U L=0.13U
M1036_keeper GND Vdd #951 GND nmos W=0.0975U L=0.715U
M1037_ GND O1_af_526_6 #fb955# GND nmos W=0.0975U L=0.13U
M1038_keeper GND Vdd #954 GND nmos W=0.0975U L=2.275U
M1039_ GND n__O0__t_527_6 #fb958# GND nmos W=0.0975U L=0.13U
M1040_keeper GND Vdd #957 GND nmos W=0.0975U L=2.275U
M1041_ GND n__O0__f_527_6 #fb961# GND nmos W=0.0975U L=0.13U
M1042_keeper GND Vdd #960 GND nmos W=0.0975U L=0.715U
M1043_ GND O1_at_527_6 #fb964# GND nmos W=0.0975U L=0.13U
M1044_keeper GND Vdd #963 GND nmos W=0.0975U L=0.715U
M1045_ GND O1_af_527_6 #fb967# GND nmos W=0.0975U L=0.13U
M1046_keeper GND Vdd #966 GND nmos W=0.0975U L=2.275U
M1047_ GND n__O0__t_528_6 #fb970# GND nmos W=0.0975U L=0.13U
M1048_keeper GND Vdd #969 GND nmos W=0.0975U L=2.275U
M1049_ GND n__O0__f_528_6 #fb973# GND nmos W=0.0975U L=0.13U
M1050_keeper GND Vdd #972 GND nmos W=0.0975U L=0.715U
M1051_ GND O1_at_528_6 #fb976# GND nmos W=0.0975U L=0.13U
M1052_keeper GND Vdd #975 GND nmos W=0.0975U L=0.715U
M1053_ GND O1_af_528_6 #fb979# GND nmos W=0.0975U L=0.13U
M1054_keeper GND Vdd #978 GND nmos W=0.0975U L=2.275U
M1055_ GND n__O0__t_529_6 #fb982# GND nmos W=0.0975U L=0.13U
M1056_keeper GND Vdd #981 GND nmos W=0.0975U L=2.275U
M1057_ GND n__O0__f_529_6 #fb985# GND nmos W=0.0975U L=0.13U
M1058_keeper GND Vdd #984 GND nmos W=0.0975U L=0.715U
M1059_ GND O1_at_529_6 #fb988# GND nmos W=0.0975U L=0.13U
M1060_keeper GND Vdd #987 GND nmos W=0.0975U L=0.715U
M1061_ GND O1_af_529_6 #fb991# GND nmos W=0.0975U L=0.13U
M1062_keeper GND Vdd #990 GND nmos W=0.0975U L=2.275U
M1063_ GND n__O0__t_530_6 #fb994# GND nmos W=0.0975U L=0.13U
M1064_keeper GND Vdd #993 GND nmos W=0.0975U L=2.275U
M1065_ GND n__O0__f_530_6 #fb997# GND nmos W=0.0975U L=0.13U
M1066_keeper GND Vdd #996 GND nmos W=0.0975U L=0.715U
M1067_ GND O1_at_530_6 #fb1000# GND nmos W=0.0975U L=0.13U
M1068_keeper GND Vdd #999 GND nmos W=0.0975U L=0.715U
M1069_ GND O1_af_530_6 #fb1003# GND nmos W=0.0975U L=0.13U
M1070_keeper GND Vdd #1002 GND nmos W=0.0975U L=2.275U
M1071_ GND n__O0__t_531_6 #fb1006# GND nmos W=0.0975U L=0.13U
M1072_keeper GND Vdd #1005 GND nmos W=0.0975U L=2.275U
M1073_ GND n__O0__f_531_6 #fb1009# GND nmos W=0.0975U L=0.13U
M1074_keeper GND Vdd #1008 GND nmos W=0.0975U L=0.715U
M1075_ GND O1_at_531_6 #fb1012# GND nmos W=0.0975U L=0.13U
M1076_keeper GND Vdd #1011 GND nmos W=0.0975U L=0.715U
M1077_ GND O1_af_531_6 #fb1015# GND nmos W=0.0975U L=0.13U
M1078_keeper GND Vdd #1014 GND nmos W=0.0975U L=2.275U
M1079_keeper GND Vdd #1017 GND nmos W=0.0975U L=2.275U
M1080_ #3 inv__s p Vdd pmos W=0.1625U L=0.065U
M1081_ #7 s p GND nmos W=0.0975U L=0.065U
M1082_keeper #617 #fb616# p Vdd pmos W=0.0975U L=0.065U
M1083_keeper #618 #fb616# p GND nmos W=0.0975U L=0.065U
M1084_ #35 O1_aa s Vdd pmos W=0.1625U L=0.065U
M1085_keeper #620 #fb619# s Vdd pmos W=0.0975U L=0.065U
M1086_keeper #621 #fb619# s GND nmos W=0.0975U L=0.065U
M1087_ #12 inv__p w__0i Vdd pmos W=0.1625U L=0.065U
M1088_ #14 p w__0i Vdd pmos W=0.1625U L=0.065U
M1089_ #16 O0_aa w__0i GND nmos W=0.0975U L=0.065U
M1090_ #16 O1_aa w__0i GND nmos W=0.0975U L=0.065U
M1091_keeper #623 #fb622# w__0i Vdd pmos W=0.0975U L=0.065U
M1092_keeper #624 #fb622# w__0i GND nmos W=0.0975U L=0.065U
M1093_ #11 inv__I__t_51_6 #12 Vdd pmos W=0.1625U L=0.065U
M1094_ #11 inv__I__f_51_6 #14 Vdd pmos W=0.1625U L=0.065U
M1095_ #21 I_af_50_6 n__w__0 GND nmos W=0.0975U L=0.065U
M1096_ #26 O1_aa n__w__0 Vdd pmos W=0.1625U L=0.065U
M1097_keeper #626 #fb625# n__w__0 Vdd pmos W=0.0975U L=0.065U
M1098_keeper #627 #fb625# n__w__0 GND nmos W=0.0975U L=0.065U
M1099_ #24 n__I__a #23 Vdd pmos W=0.1625U L=0.065U
M1100_ #23 O0_aa #26 Vdd pmos W=0.1625U L=0.065U
M1101_ #36 inv__w__0i n__I__a GND nmos W=0.0975U L=0.065U
M1102_ #43 w__0 n__I__a Vdd pmos W=0.1625U L=0.065U
M1103_keeper #629 #fb628# n__I__a Vdd pmos W=0.0975U L=0.065U
M1104_keeper #630 #fb628# n__I__a GND nmos W=0.0975U L=0.065U
M1105_ #28 I_at_50_6 n__w__1 GND nmos W=0.0975U L=0.065U
M1106_ #32 O1_aa n__w__1 Vdd pmos W=0.1625U L=0.065U
M1107_keeper #632 #fb631# n__w__1 Vdd pmos W=0.0975U L=0.065U
M1108_keeper #633 #fb631# n__w__1 GND nmos W=0.0975U L=0.065U
M1109_ #31 n__I__a #30 Vdd pmos W=0.1625U L=0.065U
M1110_ #30 O0_aa #32 Vdd pmos W=0.1625U L=0.065U
M1111_ #34 n__I__a #33 Vdd pmos W=0.1625U L=0.065U
M1112_ #33 O0_aa #35 Vdd pmos W=0.1625U L=0.065U
M1113_ #37 w__1 #36 GND nmos W=0.0975U L=0.065U
M1114_ #37 w__0 #36 GND nmos W=0.0975U L=0.065U
M1115_ #42 O1_aa #41 Vdd pmos W=0.1625U L=0.065U
M1116_ #41 w__1 #43 Vdd pmos W=0.1625U L=0.065U
M1117_ #45 I_at_50_6 n__O0__t_50_6 GND nmos W=0.0975U L=0.065U
M1118_keeper #635 #fb634# n__O0__t_50_6 Vdd pmos W=0.0975U L=0.065U
M1119_keeper #636 #fb634# n__O0__t_50_6 GND nmos W=0.0975U L=0.065U
M1120_ #46 inv__s #45 GND nmos W=0.0975U L=0.065U
M1121_ #48 I_af_50_6 n__O0__f_50_6 GND nmos W=0.0975U L=0.065U
M1122_keeper #638 #fb637# n__O0__f_50_6 Vdd pmos W=0.0975U L=0.065U
M1123_keeper #639 #fb637# n__O0__f_50_6 GND nmos W=0.0975U L=0.065U
M1124_ #49 inv__s #48 GND nmos W=0.0975U L=0.065U
M1125_ #51 inv__I__t_50_6 O1_at_50_6 Vdd pmos W=0.1625U L=0.065U
M1126_keeper #641 #fb640# O1_at_50_6 Vdd pmos W=0.0975U L=0.065U
M1127_keeper #642 #fb640# O1_at_50_6 GND nmos W=0.0975U L=0.065U
M1128_ #52 s #51 Vdd pmos W=0.1625U L=0.065U
M1129_ #55 inv__I__f_50_6 O1_af_50_6 Vdd pmos W=0.1625U L=0.065U
M1130_keeper #644 #fb643# O1_af_50_6 Vdd pmos W=0.0975U L=0.065U
M1131_keeper #645 #fb643# O1_af_50_6 GND nmos W=0.0975U L=0.065U
M1132_ #56 s #55 Vdd pmos W=0.1625U L=0.065U
M1133_ #59 I_at_51_6 n__O0__t_51_6 GND nmos W=0.0975U L=0.065U
M1134_keeper #647 #fb646# n__O0__t_51_6 Vdd pmos W=0.0975U L=0.065U
M1135_keeper #648 #fb646# n__O0__t_51_6 GND nmos W=0.0975U L=0.065U
M1136_ #60 inv__s #59 GND nmos W=0.0975U L=0.065U
M1137_ #63 I_af_51_6 n__O0__f_51_6 GND nmos W=0.0975U L=0.065U
M1138_keeper #650 #fb649# n__O0__f_51_6 Vdd pmos W=0.0975U L=0.065U
M1139_keeper #651 #fb649# n__O0__f_51_6 GND nmos W=0.0975U L=0.065U
M1140_ #64 inv__s #63 GND nmos W=0.0975U L=0.065U
M1141_ #66 inv__I__t_51_6 O1_at_51_6 Vdd pmos W=0.1625U L=0.065U
M1142_keeper #653 #fb652# O1_at_51_6 Vdd pmos W=0.0975U L=0.065U
M1143_keeper #654 #fb652# O1_at_51_6 GND nmos W=0.0975U L=0.065U
M1144_ #67 s #66 Vdd pmos W=0.1625U L=0.065U
M1145_ #69 inv__I__f_51_6 O1_af_51_6 Vdd pmos W=0.1625U L=0.065U
M1146_keeper #656 #fb655# O1_af_51_6 Vdd pmos W=0.0975U L=0.065U
M1147_keeper #657 #fb655# O1_af_51_6 GND nmos W=0.0975U L=0.065U
M1148_ #70 s #69 Vdd pmos W=0.1625U L=0.065U
M1149_ #72 I_at_52_6 n__O0__t_52_6 GND nmos W=0.0975U L=0.065U
M1150_keeper #659 #fb658# n__O0__t_52_6 Vdd pmos W=0.0975U L=0.065U
M1151_keeper #660 #fb658# n__O0__t_52_6 GND nmos W=0.0975U L=0.065U
M1152_ #73 inv__s #72 GND nmos W=0.0975U L=0.065U
M1153_ #76 I_af_52_6 n__O0__f_52_6 GND nmos W=0.0975U L=0.065U
M1154_keeper #662 #fb661# n__O0__f_52_6 Vdd pmos W=0.0975U L=0.065U
M1155_keeper #663 #fb661# n__O0__f_52_6 GND nmos W=0.0975U L=0.065U
M1156_ #77 inv__s #76 GND nmos W=0.0975U L=0.065U
M1157_ #80 inv__I__t_52_6 O1_at_52_6 Vdd pmos W=0.1625U L=0.065U
M1158_keeper #665 #fb664# O1_at_52_6 Vdd pmos W=0.0975U L=0.065U
M1159_keeper #666 #fb664# O1_at_52_6 GND nmos W=0.0975U L=0.065U
M1160_ #81 s #80 Vdd pmos W=0.1625U L=0.065U
M1161_ #84 inv__I__f_52_6 O1_af_52_6 Vdd pmos W=0.1625U L=0.065U
M1162_keeper #668 #fb667# O1_af_52_6 Vdd pmos W=0.0975U L=0.065U
M1163_keeper #669 #fb667# O1_af_52_6 GND nmos W=0.0975U L=0.065U
M1164_ #85 s #84 Vdd pmos W=0.1625U L=0.065U
M1165_ #88 I_at_53_6 n__O0__t_53_6 GND nmos W=0.0975U L=0.065U
M1166_keeper #671 #fb670# n__O0__t_53_6 Vdd pmos W=0.0975U L=0.065U
M1167_keeper #672 #fb670# n__O0__t_53_6 GND nmos W=0.0975U L=0.065U
M1168_ #89 inv__s #88 GND nmos W=0.0975U L=0.065U
M1169_ #92 I_af_53_6 n__O0__f_53_6 GND nmos W=0.0975U L=0.065U
M1170_keeper #674 #fb673# n__O0__f_53_6 Vdd pmos W=0.0975U L=0.065U
M1171_keeper #675 #fb673# n__O0__f_53_6 GND nmos W=0.0975U L=0.065U
M1172_ #93 inv__s #92 GND nmos W=0.0975U L=0.065U
M1173_ #96 inv__I__t_53_6 O1_at_53_6 Vdd pmos W=0.1625U L=0.065U
M1174_keeper #677 #fb676# O1_at_53_6 Vdd pmos W=0.0975U L=0.065U
M1175_keeper #678 #fb676# O1_at_53_6 GND nmos W=0.0975U L=0.065U
M1176_ #97 s #96 Vdd pmos W=0.1625U L=0.065U
M1177_ #100 inv__I__f_53_6 O1_af_53_6 Vdd pmos W=0.1625U L=0.065U
M1178_keeper #680 #fb679# O1_af_53_6 Vdd pmos W=0.0975U L=0.065U
M1179_keeper #681 #fb679# O1_af_53_6 GND nmos W=0.0975U L=0.065U
M1180_ #101 s #100 Vdd pmos W=0.1625U L=0.065U
M1181_ #104 I_at_54_6 n__O0__t_54_6 GND nmos W=0.0975U L=0.065U
M1182_keeper #683 #fb682# n__O0__t_54_6 Vdd pmos W=0.0975U L=0.065U
M1183_keeper #684 #fb682# n__O0__t_54_6 GND nmos W=0.0975U L=0.065U
M1184_ #105 inv__s #104 GND nmos W=0.0975U L=0.065U
M1185_ #108 I_af_54_6 n__O0__f_54_6 GND nmos W=0.0975U L=0.065U
M1186_keeper #686 #fb685# n__O0__f_54_6 Vdd pmos W=0.0975U L=0.065U
M1187_keeper #687 #fb685# n__O0__f_54_6 GND nmos W=0.0975U L=0.065U
M1188_ #109 inv__s #108 GND nmos W=0.0975U L=0.065U
M1189_ #112 inv__I__t_54_6 O1_at_54_6 Vdd pmos W=0.1625U L=0.065U
M1190_keeper #689 #fb688# O1_at_54_6 Vdd pmos W=0.0975U L=0.065U
M1191_keeper #690 #fb688# O1_at_54_6 GND nmos W=0.0975U L=0.065U
M1192_ #113 s #112 Vdd pmos W=0.1625U L=0.065U
M1193_ #116 inv__I__f_54_6 O1_af_54_6 Vdd pmos W=0.1625U L=0.065U
M1194_keeper #692 #fb691# O1_af_54_6 Vdd pmos W=0.0975U L=0.065U
M1195_keeper #693 #fb691# O1_af_54_6 GND nmos W=0.0975U L=0.065U
M1196_ #117 s #116 Vdd pmos W=0.1625U L=0.065U
M1197_ #120 I_at_55_6 n__O0__t_55_6 GND nmos W=0.0975U L=0.065U
M1198_keeper #695 #fb694# n__O0__t_55_6 Vdd pmos W=0.0975U L=0.065U
M1199_keeper #696 #fb694# n__O0__t_55_6 GND nmos W=0.0975U L=0.065U
M1200_ #121 inv__s #120 GND nmos W=0.0975U L=0.065U
M1201_ #124 I_af_55_6 n__O0__f_55_6 GND nmos W=0.0975U L=0.065U
M1202_keeper #698 #fb697# n__O0__f_55_6 Vdd pmos W=0.0975U L=0.065U
M1203_keeper #699 #fb697# n__O0__f_55_6 GND nmos W=0.0975U L=0.065U
M1204_ #125 inv__s #124 GND nmos W=0.0975U L=0.065U
M1205_ #128 inv__I__t_55_6 O1_at_55_6 Vdd pmos W=0.1625U L=0.065U
M1206_keeper #701 #fb700# O1_at_55_6 Vdd pmos W=0.0975U L=0.065U
M1207_keeper #702 #fb700# O1_at_55_6 GND nmos W=0.0975U L=0.065U
M1208_ #129 s #128 Vdd pmos W=0.1625U L=0.065U
M1209_ #132 inv__I__f_55_6 O1_af_55_6 Vdd pmos W=0.1625U L=0.065U
M1210_keeper #704 #fb703# O1_af_55_6 Vdd pmos W=0.0975U L=0.065U
M1211_keeper #705 #fb703# O1_af_55_6 GND nmos W=0.0975U L=0.065U
M1212_ #133 s #132 Vdd pmos W=0.1625U L=0.065U
M1213_ #136 I_at_56_6 n__O0__t_56_6 GND nmos W=0.0975U L=0.065U
M1214_keeper #707 #fb706# n__O0__t_56_6 Vdd pmos W=0.0975U L=0.065U
M1215_keeper #708 #fb706# n__O0__t_56_6 GND nmos W=0.0975U L=0.065U
M1216_ #137 inv__s #136 GND nmos W=0.0975U L=0.065U
M1217_ #140 I_af_56_6 n__O0__f_56_6 GND nmos W=0.0975U L=0.065U
M1218_keeper #710 #fb709# n__O0__f_56_6 Vdd pmos W=0.0975U L=0.065U
M1219_keeper #711 #fb709# n__O0__f_56_6 GND nmos W=0.0975U L=0.065U
M1220_ #141 inv__s #140 GND nmos W=0.0975U L=0.065U
M1221_ #144 inv__I__t_56_6 O1_at_56_6 Vdd pmos W=0.1625U L=0.065U
M1222_keeper #713 #fb712# O1_at_56_6 Vdd pmos W=0.0975U L=0.065U
M1223_keeper #714 #fb712# O1_at_56_6 GND nmos W=0.0975U L=0.065U
M1224_ #145 s #144 Vdd pmos W=0.1625U L=0.065U
M1225_ #148 inv__I__f_56_6 O1_af_56_6 Vdd pmos W=0.1625U L=0.065U
M1226_keeper #716 #fb715# O1_af_56_6 Vdd pmos W=0.0975U L=0.065U
M1227_keeper #717 #fb715# O1_af_56_6 GND nmos W=0.0975U L=0.065U
M1228_ #149 s #148 Vdd pmos W=0.1625U L=0.065U
M1229_ #152 I_at_57_6 n__O0__t_57_6 GND nmos W=0.0975U L=0.065U
M1230_keeper #719 #fb718# n__O0__t_57_6 Vdd pmos W=0.0975U L=0.065U
M1231_keeper #720 #fb718# n__O0__t_57_6 GND nmos W=0.0975U L=0.065U
M1232_ #153 inv__s #152 GND nmos W=0.0975U L=0.065U
M1233_ #156 I_af_57_6 n__O0__f_57_6 GND nmos W=0.0975U L=0.065U
M1234_keeper #722 #fb721# n__O0__f_57_6 Vdd pmos W=0.0975U L=0.065U
M1235_keeper #723 #fb721# n__O0__f_57_6 GND nmos W=0.0975U L=0.065U
M1236_ #157 inv__s #156 GND nmos W=0.0975U L=0.065U
M1237_ #160 inv__I__t_57_6 O1_at_57_6 Vdd pmos W=0.1625U L=0.065U
M1238_keeper #725 #fb724# O1_at_57_6 Vdd pmos W=0.0975U L=0.065U
M1239_keeper #726 #fb724# O1_at_57_6 GND nmos W=0.0975U L=0.065U
M1240_ #161 s #160 Vdd pmos W=0.1625U L=0.065U
M1241_ #164 inv__I__f_57_6 O1_af_57_6 Vdd pmos W=0.1625U L=0.065U
M1242_keeper #728 #fb727# O1_af_57_6 Vdd pmos W=0.0975U L=0.065U
M1243_keeper #729 #fb727# O1_af_57_6 GND nmos W=0.0975U L=0.065U
M1244_ #165 s #164 Vdd pmos W=0.1625U L=0.065U
M1245_ #168 I_at_58_6 n__O0__t_58_6 GND nmos W=0.0975U L=0.065U
M1246_keeper #731 #fb730# n__O0__t_58_6 Vdd pmos W=0.0975U L=0.065U
M1247_keeper #732 #fb730# n__O0__t_58_6 GND nmos W=0.0975U L=0.065U
M1248_ #169 inv__s #168 GND nmos W=0.0975U L=0.065U
M1249_ #172 I_af_58_6 n__O0__f_58_6 GND nmos W=0.0975U L=0.065U
M1250_keeper #734 #fb733# n__O0__f_58_6 Vdd pmos W=0.0975U L=0.065U
M1251_keeper #735 #fb733# n__O0__f_58_6 GND nmos W=0.0975U L=0.065U
M1252_ #173 inv__s #172 GND nmos W=0.0975U L=0.065U
M1253_ #176 inv__I__t_58_6 O1_at_58_6 Vdd pmos W=0.1625U L=0.065U
M1254_keeper #737 #fb736# O1_at_58_6 Vdd pmos W=0.0975U L=0.065U
M1255_keeper #738 #fb736# O1_at_58_6 GND nmos W=0.0975U L=0.065U
M1256_ #177 s #176 Vdd pmos W=0.1625U L=0.065U
M1257_ #180 inv__I__f_58_6 O1_af_58_6 Vdd pmos W=0.1625U L=0.065U
M1258_keeper #740 #fb739# O1_af_58_6 Vdd pmos W=0.0975U L=0.065U
M1259_keeper #741 #fb739# O1_af_58_6 GND nmos W=0.0975U L=0.065U
M1260_ #181 s #180 Vdd pmos W=0.1625U L=0.065U
M1261_ #184 I_at_59_6 n__O0__t_59_6 GND nmos W=0.0975U L=0.065U
M1262_keeper #743 #fb742# n__O0__t_59_6 Vdd pmos W=0.0975U L=0.065U
M1263_keeper #744 #fb742# n__O0__t_59_6 GND nmos W=0.0975U L=0.065U
M1264_ #185 inv__s #184 GND nmos W=0.0975U L=0.065U
M1265_ #188 I_af_59_6 n__O0__f_59_6 GND nmos W=0.0975U L=0.065U
M1266_keeper #746 #fb745# n__O0__f_59_6 Vdd pmos W=0.0975U L=0.065U
M1267_keeper #747 #fb745# n__O0__f_59_6 GND nmos W=0.0975U L=0.065U
M1268_ #189 inv__s #188 GND nmos W=0.0975U L=0.065U
M1269_ #192 inv__I__t_59_6 O1_at_59_6 Vdd pmos W=0.1625U L=0.065U
M1270_keeper #749 #fb748# O1_at_59_6 Vdd pmos W=0.0975U L=0.065U
M1271_keeper #750 #fb748# O1_at_59_6 GND nmos W=0.0975U L=0.065U
M1272_ #193 s #192 Vdd pmos W=0.1625U L=0.065U
M1273_ #196 inv__I__f_59_6 O1_af_59_6 Vdd pmos W=0.1625U L=0.065U
M1274_keeper #752 #fb751# O1_af_59_6 Vdd pmos W=0.0975U L=0.065U
M1275_keeper #753 #fb751# O1_af_59_6 GND nmos W=0.0975U L=0.065U
M1276_ #197 s #196 Vdd pmos W=0.1625U L=0.065U
M1277_ #200 I_at_510_6 n__O0__t_510_6 GND nmos W=0.0975U L=0.065U
M1278_keeper #755 #fb754# n__O0__t_510_6 Vdd pmos W=0.0975U L=0.065U
M1279_keeper #756 #fb754# n__O0__t_510_6 GND nmos W=0.0975U L=0.065U
M1280_ #201 inv__s #200 GND nmos W=0.0975U L=0.065U
M1281_ #204 I_af_510_6 n__O0__f_510_6 GND nmos W=0.0975U L=0.065U
M1282_keeper #758 #fb757# n__O0__f_510_6 Vdd pmos W=0.0975U L=0.065U
M1283_keeper #759 #fb757# n__O0__f_510_6 GND nmos W=0.0975U L=0.065U
M1284_ #205 inv__s #204 GND nmos W=0.0975U L=0.065U
M1285_ #208 inv__I__t_510_6 O1_at_510_6 Vdd pmos W=0.1625U L=0.065U
M1286_keeper #761 #fb760# O1_at_510_6 Vdd pmos W=0.0975U L=0.065U
M1287_keeper #762 #fb760# O1_at_510_6 GND nmos W=0.0975U L=0.065U
M1288_ #209 s #208 Vdd pmos W=0.1625U L=0.065U
M1289_ #212 inv__I__f_510_6 O1_af_510_6 Vdd pmos W=0.1625U L=0.065U
M1290_keeper #764 #fb763# O1_af_510_6 Vdd pmos W=0.0975U L=0.065U
M1291_keeper #765 #fb763# O1_af_510_6 GND nmos W=0.0975U L=0.065U
M1292_ #213 s #212 Vdd pmos W=0.1625U L=0.065U
M1293_ #216 I_at_511_6 n__O0__t_511_6 GND nmos W=0.0975U L=0.065U
M1294_keeper #767 #fb766# n__O0__t_511_6 Vdd pmos W=0.0975U L=0.065U
M1295_keeper #768 #fb766# n__O0__t_511_6 GND nmos W=0.0975U L=0.065U
M1296_ #217 inv__s #216 GND nmos W=0.0975U L=0.065U
M1297_ #220 I_af_511_6 n__O0__f_511_6 GND nmos W=0.0975U L=0.065U
M1298_keeper #770 #fb769# n__O0__f_511_6 Vdd pmos W=0.0975U L=0.065U
M1299_keeper #771 #fb769# n__O0__f_511_6 GND nmos W=0.0975U L=0.065U
M1300_ #221 inv__s #220 GND nmos W=0.0975U L=0.065U
M1301_ #224 inv__I__t_511_6 O1_at_511_6 Vdd pmos W=0.1625U L=0.065U
M1302_keeper #773 #fb772# O1_at_511_6 Vdd pmos W=0.0975U L=0.065U
M1303_keeper #774 #fb772# O1_at_511_6 GND nmos W=0.0975U L=0.065U
M1304_ #225 s #224 Vdd pmos W=0.1625U L=0.065U
M1305_ #228 inv__I__f_511_6 O1_af_511_6 Vdd pmos W=0.1625U L=0.065U
M1306_keeper #776 #fb775# O1_af_511_6 Vdd pmos W=0.0975U L=0.065U
M1307_keeper #777 #fb775# O1_af_511_6 GND nmos W=0.0975U L=0.065U
M1308_ #229 s #228 Vdd pmos W=0.1625U L=0.065U
M1309_ #232 I_at_512_6 n__O0__t_512_6 GND nmos W=0.0975U L=0.065U
M1310_keeper #779 #fb778# n__O0__t_512_6 Vdd pmos W=0.0975U L=0.065U
M1311_keeper #780 #fb778# n__O0__t_512_6 GND nmos W=0.0975U L=0.065U
M1312_ #233 inv__s #232 GND nmos W=0.0975U L=0.065U
M1313_ #236 I_af_512_6 n__O0__f_512_6 GND nmos W=0.0975U L=0.065U
M1314_keeper #782 #fb781# n__O0__f_512_6 Vdd pmos W=0.0975U L=0.065U
M1315_keeper #783 #fb781# n__O0__f_512_6 GND nmos W=0.0975U L=0.065U
M1316_ #237 inv__s #236 GND nmos W=0.0975U L=0.065U
M1317_ #240 inv__I__t_512_6 O1_at_512_6 Vdd pmos W=0.1625U L=0.065U
M1318_keeper #785 #fb784# O1_at_512_6 Vdd pmos W=0.0975U L=0.065U
M1319_keeper #786 #fb784# O1_at_512_6 GND nmos W=0.0975U L=0.065U
M1320_ #241 s #240 Vdd pmos W=0.1625U L=0.065U
M1321_ #244 inv__I__f_512_6 O1_af_512_6 Vdd pmos W=0.1625U L=0.065U
M1322_keeper #788 #fb787# O1_af_512_6 Vdd pmos W=0.0975U L=0.065U
M1323_keeper #789 #fb787# O1_af_512_6 GND nmos W=0.0975U L=0.065U
M1324_ #245 s #244 Vdd pmos W=0.1625U L=0.065U
M1325_ #248 I_at_513_6 n__O0__t_513_6 GND nmos W=0.0975U L=0.065U
M1326_keeper #791 #fb790# n__O0__t_513_6 Vdd pmos W=0.0975U L=0.065U
M1327_keeper #792 #fb790# n__O0__t_513_6 GND nmos W=0.0975U L=0.065U
M1328_ #249 inv__s #248 GND nmos W=0.0975U L=0.065U
M1329_ #252 I_af_513_6 n__O0__f_513_6 GND nmos W=0.0975U L=0.065U
M1330_keeper #794 #fb793# n__O0__f_513_6 Vdd pmos W=0.0975U L=0.065U
M1331_keeper #795 #fb793# n__O0__f_513_6 GND nmos W=0.0975U L=0.065U
M1332_ #253 inv__s #252 GND nmos W=0.0975U L=0.065U
M1333_ #256 inv__I__t_513_6 O1_at_513_6 Vdd pmos W=0.1625U L=0.065U
M1334_keeper #797 #fb796# O1_at_513_6 Vdd pmos W=0.0975U L=0.065U
M1335_keeper #798 #fb796# O1_at_513_6 GND nmos W=0.0975U L=0.065U
M1336_ #257 s #256 Vdd pmos W=0.1625U L=0.065U
M1337_ #260 inv__I__f_513_6 O1_af_513_6 Vdd pmos W=0.1625U L=0.065U
M1338_keeper #800 #fb799# O1_af_513_6 Vdd pmos W=0.0975U L=0.065U
M1339_keeper #801 #fb799# O1_af_513_6 GND nmos W=0.0975U L=0.065U
M1340_ #261 s #260 Vdd pmos W=0.1625U L=0.065U
M1341_ #264 I_at_514_6 n__O0__t_514_6 GND nmos W=0.0975U L=0.065U
M1342_keeper #803 #fb802# n__O0__t_514_6 Vdd pmos W=0.0975U L=0.065U
M1343_keeper #804 #fb802# n__O0__t_514_6 GND nmos W=0.0975U L=0.065U
M1344_ #265 inv__s #264 GND nmos W=0.0975U L=0.065U
M1345_ #268 I_af_514_6 n__O0__f_514_6 GND nmos W=0.0975U L=0.065U
M1346_keeper #806 #fb805# n__O0__f_514_6 Vdd pmos W=0.0975U L=0.065U
M1347_keeper #807 #fb805# n__O0__f_514_6 GND nmos W=0.0975U L=0.065U
M1348_ #269 inv__s #268 GND nmos W=0.0975U L=0.065U
M1349_ #272 inv__I__t_514_6 O1_at_514_6 Vdd pmos W=0.1625U L=0.065U
M1350_keeper #809 #fb808# O1_at_514_6 Vdd pmos W=0.0975U L=0.065U
M1351_keeper #810 #fb808# O1_at_514_6 GND nmos W=0.0975U L=0.065U
M1352_ #273 s #272 Vdd pmos W=0.1625U L=0.065U
M1353_ #276 inv__I__f_514_6 O1_af_514_6 Vdd pmos W=0.1625U L=0.065U
M1354_keeper #812 #fb811# O1_af_514_6 Vdd pmos W=0.0975U L=0.065U
M1355_keeper #813 #fb811# O1_af_514_6 GND nmos W=0.0975U L=0.065U
M1356_ #277 s #276 Vdd pmos W=0.1625U L=0.065U
M1357_ #280 I_at_515_6 n__O0__t_515_6 GND nmos W=0.0975U L=0.065U
M1358_keeper #815 #fb814# n__O0__t_515_6 Vdd pmos W=0.0975U L=0.065U
M1359_keeper #816 #fb814# n__O0__t_515_6 GND nmos W=0.0975U L=0.065U
M1360_ #281 inv__s #280 GND nmos W=0.0975U L=0.065U
M1361_ #284 I_af_515_6 n__O0__f_515_6 GND nmos W=0.0975U L=0.065U
M1362_keeper #818 #fb817# n__O0__f_515_6 Vdd pmos W=0.0975U L=0.065U
M1363_keeper #819 #fb817# n__O0__f_515_6 GND nmos W=0.0975U L=0.065U
M1364_ #285 inv__s #284 GND nmos W=0.0975U L=0.065U
M1365_ #288 inv__I__t_515_6 O1_at_515_6 Vdd pmos W=0.1625U L=0.065U
M1366_keeper #821 #fb820# O1_at_515_6 Vdd pmos W=0.0975U L=0.065U
M1367_keeper #822 #fb820# O1_at_515_6 GND nmos W=0.0975U L=0.065U
M1368_ #289 s #288 Vdd pmos W=0.1625U L=0.065U
M1369_ #292 inv__I__f_515_6 O1_af_515_6 Vdd pmos W=0.1625U L=0.065U
M1370_keeper #824 #fb823# O1_af_515_6 Vdd pmos W=0.0975U L=0.065U
M1371_keeper #825 #fb823# O1_af_515_6 GND nmos W=0.0975U L=0.065U
M1372_ #293 s #292 Vdd pmos W=0.1625U L=0.065U
M1373_ #296 I_at_516_6 n__O0__t_516_6 GND nmos W=0.0975U L=0.065U
M1374_keeper #827 #fb826# n__O0__t_516_6 Vdd pmos W=0.0975U L=0.065U
M1375_keeper #828 #fb826# n__O0__t_516_6 GND nmos W=0.0975U L=0.065U
M1376_ #297 inv__s #296 GND nmos W=0.0975U L=0.065U
M1377_ #300 I_af_516_6 n__O0__f_516_6 GND nmos W=0.0975U L=0.065U
M1378_keeper #830 #fb829# n__O0__f_516_6 Vdd pmos W=0.0975U L=0.065U
M1379_keeper #831 #fb829# n__O0__f_516_6 GND nmos W=0.0975U L=0.065U
M1380_ #301 inv__s #300 GND nmos W=0.0975U L=0.065U
M1381_ #304 inv__I__t_516_6 O1_at_516_6 Vdd pmos W=0.1625U L=0.065U
M1382_keeper #833 #fb832# O1_at_516_6 Vdd pmos W=0.0975U L=0.065U
M1383_keeper #834 #fb832# O1_at_516_6 GND nmos W=0.0975U L=0.065U
M1384_ #305 s #304 Vdd pmos W=0.1625U L=0.065U
M1385_ #308 inv__I__f_516_6 O1_af_516_6 Vdd pmos W=0.1625U L=0.065U
M1386_keeper #836 #fb835# O1_af_516_6 Vdd pmos W=0.0975U L=0.065U
M1387_keeper #837 #fb835# O1_af_516_6 GND nmos W=0.0975U L=0.065U
M1388_ #309 s #308 Vdd pmos W=0.1625U L=0.065U
M1389_ #312 I_at_517_6 n__O0__t_517_6 GND nmos W=0.0975U L=0.065U
M1390_keeper #839 #fb838# n__O0__t_517_6 Vdd pmos W=0.0975U L=0.065U
M1391_keeper #840 #fb838# n__O0__t_517_6 GND nmos W=0.0975U L=0.065U
M1392_ #313 inv__s #312 GND nmos W=0.0975U L=0.065U
M1393_ #316 I_af_517_6 n__O0__f_517_6 GND nmos W=0.0975U L=0.065U
M1394_keeper #842 #fb841# n__O0__f_517_6 Vdd pmos W=0.0975U L=0.065U
M1395_keeper #843 #fb841# n__O0__f_517_6 GND nmos W=0.0975U L=0.065U
M1396_ #317 inv__s #316 GND nmos W=0.0975U L=0.065U
M1397_ #320 inv__I__t_517_6 O1_at_517_6 Vdd pmos W=0.1625U L=0.065U
M1398_keeper #845 #fb844# O1_at_517_6 Vdd pmos W=0.0975U L=0.065U
M1399_keeper #846 #fb844# O1_at_517_6 GND nmos W=0.0975U L=0.065U
M1400_ #321 s #320 Vdd pmos W=0.1625U L=0.065U
M1401_ #324 inv__I__f_517_6 O1_af_517_6 Vdd pmos W=0.1625U L=0.065U
M1402_keeper #848 #fb847# O1_af_517_6 Vdd pmos W=0.0975U L=0.065U
M1403_keeper #849 #fb847# O1_af_517_6 GND nmos W=0.0975U L=0.065U
M1404_ #325 s #324 Vdd pmos W=0.1625U L=0.065U
M1405_ #328 I_at_518_6 n__O0__t_518_6 GND nmos W=0.0975U L=0.065U
M1406_keeper #851 #fb850# n__O0__t_518_6 Vdd pmos W=0.0975U L=0.065U
M1407_keeper #852 #fb850# n__O0__t_518_6 GND nmos W=0.0975U L=0.065U
M1408_ #329 inv__s #328 GND nmos W=0.0975U L=0.065U
M1409_ #332 I_af_518_6 n__O0__f_518_6 GND nmos W=0.0975U L=0.065U
M1410_keeper #854 #fb853# n__O0__f_518_6 Vdd pmos W=0.0975U L=0.065U
M1411_keeper #855 #fb853# n__O0__f_518_6 GND nmos W=0.0975U L=0.065U
M1412_ #333 inv__s #332 GND nmos W=0.0975U L=0.065U
M1413_ #336 inv__I__t_518_6 O1_at_518_6 Vdd pmos W=0.1625U L=0.065U
M1414_keeper #857 #fb856# O1_at_518_6 Vdd pmos W=0.0975U L=0.065U
M1415_keeper #858 #fb856# O1_at_518_6 GND nmos W=0.0975U L=0.065U
M1416_ #337 s #336 Vdd pmos W=0.1625U L=0.065U
M1417_ #340 inv__I__f_518_6 O1_af_518_6 Vdd pmos W=0.1625U L=0.065U
M1418_keeper #860 #fb859# O1_af_518_6 Vdd pmos W=0.0975U L=0.065U
M1419_keeper #861 #fb859# O1_af_518_6 GND nmos W=0.0975U L=0.065U
M1420_ #341 s #340 Vdd pmos W=0.1625U L=0.065U
M1421_ #344 I_at_519_6 n__O0__t_519_6 GND nmos W=0.0975U L=0.065U
M1422_keeper #863 #fb862# n__O0__t_519_6 Vdd pmos W=0.0975U L=0.065U
M1423_keeper #864 #fb862# n__O0__t_519_6 GND nmos W=0.0975U L=0.065U
M1424_ #345 inv__s #344 GND nmos W=0.0975U L=0.065U
M1425_ #348 I_af_519_6 n__O0__f_519_6 GND nmos W=0.0975U L=0.065U
M1426_keeper #866 #fb865# n__O0__f_519_6 Vdd pmos W=0.0975U L=0.065U
M1427_keeper #867 #fb865# n__O0__f_519_6 GND nmos W=0.0975U L=0.065U
M1428_ #349 inv__s #348 GND nmos W=0.0975U L=0.065U
M1429_ #352 inv__I__t_519_6 O1_at_519_6 Vdd pmos W=0.1625U L=0.065U
M1430_keeper #869 #fb868# O1_at_519_6 Vdd pmos W=0.0975U L=0.065U
M1431_keeper #870 #fb868# O1_at_519_6 GND nmos W=0.0975U L=0.065U
M1432_ #353 s #352 Vdd pmos W=0.1625U L=0.065U
M1433_ #356 inv__I__f_519_6 O1_af_519_6 Vdd pmos W=0.1625U L=0.065U
M1434_keeper #872 #fb871# O1_af_519_6 Vdd pmos W=0.0975U L=0.065U
M1435_keeper #873 #fb871# O1_af_519_6 GND nmos W=0.0975U L=0.065U
M1436_ #357 s #356 Vdd pmos W=0.1625U L=0.065U
M1437_ #360 I_at_520_6 n__O0__t_520_6 GND nmos W=0.0975U L=0.065U
M1438_keeper #875 #fb874# n__O0__t_520_6 Vdd pmos W=0.0975U L=0.065U
M1439_keeper #876 #fb874# n__O0__t_520_6 GND nmos W=0.0975U L=0.065U
M1440_ #361 inv__s #360 GND nmos W=0.0975U L=0.065U
M1441_ #364 I_af_520_6 n__O0__f_520_6 GND nmos W=0.0975U L=0.065U
M1442_keeper #878 #fb877# n__O0__f_520_6 Vdd pmos W=0.0975U L=0.065U
M1443_keeper #879 #fb877# n__O0__f_520_6 GND nmos W=0.0975U L=0.065U
M1444_ #365 inv__s #364 GND nmos W=0.0975U L=0.065U
M1445_ #368 inv__I__t_520_6 O1_at_520_6 Vdd pmos W=0.1625U L=0.065U
M1446_keeper #881 #fb880# O1_at_520_6 Vdd pmos W=0.0975U L=0.065U
M1447_keeper #882 #fb880# O1_at_520_6 GND nmos W=0.0975U L=0.065U
M1448_ #369 s #368 Vdd pmos W=0.1625U L=0.065U
M1449_ #372 inv__I__f_520_6 O1_af_520_6 Vdd pmos W=0.1625U L=0.065U
M1450_keeper #884 #fb883# O1_af_520_6 Vdd pmos W=0.0975U L=0.065U
M1451_keeper #885 #fb883# O1_af_520_6 GND nmos W=0.0975U L=0.065U
M1452_ #373 s #372 Vdd pmos W=0.1625U L=0.065U
M1453_ #376 I_at_521_6 n__O0__t_521_6 GND nmos W=0.0975U L=0.065U
M1454_keeper #887 #fb886# n__O0__t_521_6 Vdd pmos W=0.0975U L=0.065U
M1455_keeper #888 #fb886# n__O0__t_521_6 GND nmos W=0.0975U L=0.065U
M1456_ #377 inv__s #376 GND nmos W=0.0975U L=0.065U
M1457_ #380 I_af_521_6 n__O0__f_521_6 GND nmos W=0.0975U L=0.065U
M1458_keeper #890 #fb889# n__O0__f_521_6 Vdd pmos W=0.0975U L=0.065U
M1459_keeper #891 #fb889# n__O0__f_521_6 GND nmos W=0.0975U L=0.065U
M1460_ #381 inv__s #380 GND nmos W=0.0975U L=0.065U
M1461_ #384 inv__I__t_521_6 O1_at_521_6 Vdd pmos W=0.1625U L=0.065U
M1462_keeper #893 #fb892# O1_at_521_6 Vdd pmos W=0.0975U L=0.065U
M1463_keeper #894 #fb892# O1_at_521_6 GND nmos W=0.0975U L=0.065U
M1464_ #385 s #384 Vdd pmos W=0.1625U L=0.065U
M1465_ #388 inv__I__f_521_6 O1_af_521_6 Vdd pmos W=0.1625U L=0.065U
M1466_keeper #896 #fb895# O1_af_521_6 Vdd pmos W=0.0975U L=0.065U
M1467_keeper #897 #fb895# O1_af_521_6 GND nmos W=0.0975U L=0.065U
M1468_ #389 s #388 Vdd pmos W=0.1625U L=0.065U
M1469_ #392 I_at_522_6 n__O0__t_522_6 GND nmos W=0.0975U L=0.065U
M1470_keeper #899 #fb898# n__O0__t_522_6 Vdd pmos W=0.0975U L=0.065U
M1471_keeper #900 #fb898# n__O0__t_522_6 GND nmos W=0.0975U L=0.065U
M1472_ #393 inv__s #392 GND nmos W=0.0975U L=0.065U
M1473_ #396 I_af_522_6 n__O0__f_522_6 GND nmos W=0.0975U L=0.065U
M1474_keeper #902 #fb901# n__O0__f_522_6 Vdd pmos W=0.0975U L=0.065U
M1475_keeper #903 #fb901# n__O0__f_522_6 GND nmos W=0.0975U L=0.065U
M1476_ #397 inv__s #396 GND nmos W=0.0975U L=0.065U
M1477_ #400 inv__I__t_522_6 O1_at_522_6 Vdd pmos W=0.1625U L=0.065U
M1478_keeper #905 #fb904# O1_at_522_6 Vdd pmos W=0.0975U L=0.065U
M1479_keeper #906 #fb904# O1_at_522_6 GND nmos W=0.0975U L=0.065U
M1480_ #401 s #400 Vdd pmos W=0.1625U L=0.065U
M1481_ #404 inv__I__f_522_6 O1_af_522_6 Vdd pmos W=0.1625U L=0.065U
M1482_keeper #908 #fb907# O1_af_522_6 Vdd pmos W=0.0975U L=0.065U
M1483_keeper #909 #fb907# O1_af_522_6 GND nmos W=0.0975U L=0.065U
M1484_ #405 s #404 Vdd pmos W=0.1625U L=0.065U
M1485_ #408 I_at_523_6 n__O0__t_523_6 GND nmos W=0.0975U L=0.065U
M1486_keeper #911 #fb910# n__O0__t_523_6 Vdd pmos W=0.0975U L=0.065U
M1487_keeper #912 #fb910# n__O0__t_523_6 GND nmos W=0.0975U L=0.065U
M1488_ #409 inv__s #408 GND nmos W=0.0975U L=0.065U
M1489_ #412 I_af_523_6 n__O0__f_523_6 GND nmos W=0.0975U L=0.065U
M1490_keeper #914 #fb913# n__O0__f_523_6 Vdd pmos W=0.0975U L=0.065U
M1491_keeper #915 #fb913# n__O0__f_523_6 GND nmos W=0.0975U L=0.065U
M1492_ #413 inv__s #412 GND nmos W=0.0975U L=0.065U
M1493_ #416 inv__I__t_523_6 O1_at_523_6 Vdd pmos W=0.1625U L=0.065U
M1494_keeper #917 #fb916# O1_at_523_6 Vdd pmos W=0.0975U L=0.065U
M1495_keeper #918 #fb916# O1_at_523_6 GND nmos W=0.0975U L=0.065U
M1496_ #417 s #416 Vdd pmos W=0.1625U L=0.065U
M1497_ #420 inv__I__f_523_6 O1_af_523_6 Vdd pmos W=0.1625U L=0.065U
M1498_keeper #920 #fb919# O1_af_523_6 Vdd pmos W=0.0975U L=0.065U
M1499_keeper #921 #fb919# O1_af_523_6 GND nmos W=0.0975U L=0.065U
M1500_ #421 s #420 Vdd pmos W=0.1625U L=0.065U
M1501_ #424 I_at_524_6 n__O0__t_524_6 GND nmos W=0.0975U L=0.065U
M1502_keeper #923 #fb922# n__O0__t_524_6 Vdd pmos W=0.0975U L=0.065U
M1503_keeper #924 #fb922# n__O0__t_524_6 GND nmos W=0.0975U L=0.065U
M1504_ #425 inv__s #424 GND nmos W=0.0975U L=0.065U
M1505_ #428 I_af_524_6 n__O0__f_524_6 GND nmos W=0.0975U L=0.065U
M1506_keeper #926 #fb925# n__O0__f_524_6 Vdd pmos W=0.0975U L=0.065U
M1507_keeper #927 #fb925# n__O0__f_524_6 GND nmos W=0.0975U L=0.065U
M1508_ #429 inv__s #428 GND nmos W=0.0975U L=0.065U
M1509_ #432 inv__I__t_524_6 O1_at_524_6 Vdd pmos W=0.1625U L=0.065U
M1510_keeper #929 #fb928# O1_at_524_6 Vdd pmos W=0.0975U L=0.065U
M1511_keeper #930 #fb928# O1_at_524_6 GND nmos W=0.0975U L=0.065U
M1512_ #433 s #432 Vdd pmos W=0.1625U L=0.065U
M1513_ #436 inv__I__f_524_6 O1_af_524_6 Vdd pmos W=0.1625U L=0.065U
M1514_keeper #932 #fb931# O1_af_524_6 Vdd pmos W=0.0975U L=0.065U
M1515_keeper #933 #fb931# O1_af_524_6 GND nmos W=0.0975U L=0.065U
M1516_ #437 s #436 Vdd pmos W=0.1625U L=0.065U
M1517_ #440 I_at_525_6 n__O0__t_525_6 GND nmos W=0.0975U L=0.065U
M1518_keeper #935 #fb934# n__O0__t_525_6 Vdd pmos W=0.0975U L=0.065U
M1519_keeper #936 #fb934# n__O0__t_525_6 GND nmos W=0.0975U L=0.065U
M1520_ #441 inv__s #440 GND nmos W=0.0975U L=0.065U
M1521_ #444 I_af_525_6 n__O0__f_525_6 GND nmos W=0.0975U L=0.065U
M1522_keeper #938 #fb937# n__O0__f_525_6 Vdd pmos W=0.0975U L=0.065U
M1523_keeper #939 #fb937# n__O0__f_525_6 GND nmos W=0.0975U L=0.065U
M1524_ #445 inv__s #444 GND nmos W=0.0975U L=0.065U
M1525_ #448 inv__I__t_525_6 O1_at_525_6 Vdd pmos W=0.1625U L=0.065U
M1526_keeper #941 #fb940# O1_at_525_6 Vdd pmos W=0.0975U L=0.065U
M1527_keeper #942 #fb940# O1_at_525_6 GND nmos W=0.0975U L=0.065U
M1528_ #449 s #448 Vdd pmos W=0.1625U L=0.065U
M1529_ #452 inv__I__f_525_6 O1_af_525_6 Vdd pmos W=0.1625U L=0.065U
M1530_keeper #944 #fb943# O1_af_525_6 Vdd pmos W=0.0975U L=0.065U
M1531_keeper #945 #fb943# O1_af_525_6 GND nmos W=0.0975U L=0.065U
M1532_ #453 s #452 Vdd pmos W=0.1625U L=0.065U
M1533_ #456 I_at_526_6 n__O0__t_526_6 GND nmos W=0.0975U L=0.065U
M1534_keeper #947 #fb946# n__O0__t_526_6 Vdd pmos W=0.0975U L=0.065U
M1535_keeper #948 #fb946# n__O0__t_526_6 GND nmos W=0.0975U L=0.065U
M1536_ #457 inv__s #456 GND nmos W=0.0975U L=0.065U
M1537_ #460 I_af_526_6 n__O0__f_526_6 GND nmos W=0.0975U L=0.065U
M1538_keeper #950 #fb949# n__O0__f_526_6 Vdd pmos W=0.0975U L=0.065U
M1539_keeper #951 #fb949# n__O0__f_526_6 GND nmos W=0.0975U L=0.065U
M1540_ #461 inv__s #460 GND nmos W=0.0975U L=0.065U
M1541_ #464 inv__I__t_526_6 O1_at_526_6 Vdd pmos W=0.1625U L=0.065U
M1542_keeper #953 #fb952# O1_at_526_6 Vdd pmos W=0.0975U L=0.065U
M1543_keeper #954 #fb952# O1_at_526_6 GND nmos W=0.0975U L=0.065U
M1544_ #465 s #464 Vdd pmos W=0.1625U L=0.065U
M1545_ #468 inv__I__f_526_6 O1_af_526_6 Vdd pmos W=0.1625U L=0.065U
M1546_keeper #956 #fb955# O1_af_526_6 Vdd pmos W=0.0975U L=0.065U
M1547_keeper #957 #fb955# O1_af_526_6 GND nmos W=0.0975U L=0.065U
M1548_ #469 s #468 Vdd pmos W=0.1625U L=0.065U
M1549_ #472 I_at_527_6 n__O0__t_527_6 GND nmos W=0.0975U L=0.065U
M1550_keeper #959 #fb958# n__O0__t_527_6 Vdd pmos W=0.0975U L=0.065U
M1551_keeper #960 #fb958# n__O0__t_527_6 GND nmos W=0.0975U L=0.065U
M1552_ #473 inv__s #472 GND nmos W=0.0975U L=0.065U
M1553_ #476 I_af_527_6 n__O0__f_527_6 GND nmos W=0.0975U L=0.065U
M1554_keeper #962 #fb961# n__O0__f_527_6 Vdd pmos W=0.0975U L=0.065U
M1555_keeper #963 #fb961# n__O0__f_527_6 GND nmos W=0.0975U L=0.065U
M1556_ #477 inv__s #476 GND nmos W=0.0975U L=0.065U
M1557_ #480 inv__I__t_527_6 O1_at_527_6 Vdd pmos W=0.1625U L=0.065U
M1558_keeper #965 #fb964# O1_at_527_6 Vdd pmos W=0.0975U L=0.065U
M1559_keeper #966 #fb964# O1_at_527_6 GND nmos W=0.0975U L=0.065U
M1560_ #481 s #480 Vdd pmos W=0.1625U L=0.065U
M1561_ #484 inv__I__f_527_6 O1_af_527_6 Vdd pmos W=0.1625U L=0.065U
M1562_keeper #968 #fb967# O1_af_527_6 Vdd pmos W=0.0975U L=0.065U
M1563_keeper #969 #fb967# O1_af_527_6 GND nmos W=0.0975U L=0.065U
M1564_ #485 s #484 Vdd pmos W=0.1625U L=0.065U
M1565_ #488 I_at_528_6 n__O0__t_528_6 GND nmos W=0.0975U L=0.065U
M1566_keeper #971 #fb970# n__O0__t_528_6 Vdd pmos W=0.0975U L=0.065U
M1567_keeper #972 #fb970# n__O0__t_528_6 GND nmos W=0.0975U L=0.065U
M1568_ #489 inv__s #488 GND nmos W=0.0975U L=0.065U
M1569_ #492 I_af_528_6 n__O0__f_528_6 GND nmos W=0.0975U L=0.065U
M1570_keeper #974 #fb973# n__O0__f_528_6 Vdd pmos W=0.0975U L=0.065U
M1571_keeper #975 #fb973# n__O0__f_528_6 GND nmos W=0.0975U L=0.065U
M1572_ #493 inv__s #492 GND nmos W=0.0975U L=0.065U
M1573_ #496 inv__I__t_528_6 O1_at_528_6 Vdd pmos W=0.1625U L=0.065U
M1574_keeper #977 #fb976# O1_at_528_6 Vdd pmos W=0.0975U L=0.065U
M1575_keeper #978 #fb976# O1_at_528_6 GND nmos W=0.0975U L=0.065U
M1576_ #497 s #496 Vdd pmos W=0.1625U L=0.065U
M1577_ #500 inv__I__f_528_6 O1_af_528_6 Vdd pmos W=0.1625U L=0.065U
M1578_keeper #980 #fb979# O1_af_528_6 Vdd pmos W=0.0975U L=0.065U
M1579_keeper #981 #fb979# O1_af_528_6 GND nmos W=0.0975U L=0.065U
M1580_ #501 s #500 Vdd pmos W=0.1625U L=0.065U
M1581_ #504 I_at_529_6 n__O0__t_529_6 GND nmos W=0.0975U L=0.065U
M1582_keeper #983 #fb982# n__O0__t_529_6 Vdd pmos W=0.0975U L=0.065U
M1583_keeper #984 #fb982# n__O0__t_529_6 GND nmos W=0.0975U L=0.065U
M1584_ #505 inv__s #504 GND nmos W=0.0975U L=0.065U
M1585_ #508 I_af_529_6 n__O0__f_529_6 GND nmos W=0.0975U L=0.065U
M1586_keeper #986 #fb985# n__O0__f_529_6 Vdd pmos W=0.0975U L=0.065U
M1587_keeper #987 #fb985# n__O0__f_529_6 GND nmos W=0.0975U L=0.065U
M1588_ #509 inv__s #508 GND nmos W=0.0975U L=0.065U
M1589_ #512 inv__I__t_529_6 O1_at_529_6 Vdd pmos W=0.1625U L=0.065U
M1590_keeper #989 #fb988# O1_at_529_6 Vdd pmos W=0.0975U L=0.065U
M1591_keeper #990 #fb988# O1_at_529_6 GND nmos W=0.0975U L=0.065U
M1592_ #513 s #512 Vdd pmos W=0.1625U L=0.065U
M1593_ #516 inv__I__f_529_6 O1_af_529_6 Vdd pmos W=0.1625U L=0.065U
M1594_keeper #992 #fb991# O1_af_529_6 Vdd pmos W=0.0975U L=0.065U
M1595_keeper #993 #fb991# O1_af_529_6 GND nmos W=0.0975U L=0.065U
M1596_ #517 s #516 Vdd pmos W=0.1625U L=0.065U
M1597_ #520 I_at_530_6 n__O0__t_530_6 GND nmos W=0.0975U L=0.065U
M1598_keeper #995 #fb994# n__O0__t_530_6 Vdd pmos W=0.0975U L=0.065U
M1599_keeper #996 #fb994# n__O0__t_530_6 GND nmos W=0.0975U L=0.065U
M1600_ #521 inv__s #520 GND nmos W=0.0975U L=0.065U
M1601_ #524 I_af_530_6 n__O0__f_530_6 GND nmos W=0.0975U L=0.065U
M1602_keeper #998 #fb997# n__O0__f_530_6 Vdd pmos W=0.0975U L=0.065U
M1603_keeper #999 #fb997# n__O0__f_530_6 GND nmos W=0.0975U L=0.065U
M1604_ #525 inv__s #524 GND nmos W=0.0975U L=0.065U
M1605_ #528 inv__I__t_530_6 O1_at_530_6 Vdd pmos W=0.1625U L=0.065U
M1606_keeper #1001 #fb1000# O1_at_530_6 Vdd pmos W=0.0975U L=0.065U
M1607_keeper #1002 #fb1000# O1_at_530_6 GND nmos W=0.0975U L=0.065U
M1608_ #529 s #528 Vdd pmos W=0.1625U L=0.065U
M1609_ #532 inv__I__f_530_6 O1_af_530_6 Vdd pmos W=0.1625U L=0.065U
M1610_keeper #1004 #fb1003# O1_af_530_6 Vdd pmos W=0.0975U L=0.065U
M1611_keeper #1005 #fb1003# O1_af_530_6 GND nmos W=0.0975U L=0.065U
M1612_ #533 s #532 Vdd pmos W=0.1625U L=0.065U
M1613_ #536 I_at_531_6 n__O0__t_531_6 GND nmos W=0.0975U L=0.065U
M1614_keeper #1007 #fb1006# n__O0__t_531_6 Vdd pmos W=0.0975U L=0.065U
M1615_keeper #1008 #fb1006# n__O0__t_531_6 GND nmos W=0.0975U L=0.065U
M1616_ #537 inv__s #536 GND nmos W=0.0975U L=0.065U
M1617_ #540 I_af_531_6 n__O0__f_531_6 GND nmos W=0.0975U L=0.065U
M1618_keeper #1010 #fb1009# n__O0__f_531_6 Vdd pmos W=0.0975U L=0.065U
M1619_keeper #1011 #fb1009# n__O0__f_531_6 GND nmos W=0.0975U L=0.065U
M1620_ #541 inv__s #540 GND nmos W=0.0975U L=0.065U
M1621_ #544 inv__I__t_531_6 O1_at_531_6 Vdd pmos W=0.1625U L=0.065U
M1622_keeper #1013 #fb1012# O1_at_531_6 Vdd pmos W=0.0975U L=0.065U
M1623_keeper #1014 #fb1012# O1_at_531_6 GND nmos W=0.0975U L=0.065U
M1624_ #545 s #544 Vdd pmos W=0.1625U L=0.065U
M1625_ #548 inv__I__f_531_6 O1_af_531_6 Vdd pmos W=0.1625U L=0.065U
M1626_keeper #1016 #fb1015# O1_af_531_6 Vdd pmos W=0.0975U L=0.065U
M1627_keeper #1017 #fb1015# O1_af_531_6 GND nmos W=0.0975U L=0.065U
M1628_ #549 s #548 Vdd pmos W=0.1625U L=0.065U
.ends
*---- end of process: MltcSel<> -----
*
*---- act defproc: Merge<32,t> -----
* raw ports:  I0.t[0] I0.t[1] I0.t[2] I0.t[3] I0.t[4] I0.t[5] I0.t[6] I0.t[7] I0.t[8] I0.t[9] I0.t[10] I0.t[11] I0.t[12] I0.t[13] I0.t[14] I0.t[15] I0.t[16] I0.t[17] I0.t[18] I0.t[19] I0.t[20] I0.t[21] I0.t[22] I0.t[23] I0.t[24] I0.t[25] I0.t[26] I0.t[27] I0.t[28] I0.t[29] I0.t[30] I0.t[31] I0.f[0] I0.f[1] I0.f[2] I0.f[3] I0.f[4] I0.f[5] I0.f[6] I0.f[7] I0.f[8] I0.f[9] I0.f[10] I0.f[11] I0.f[12] I0.f[13] I0.f[14] I0.f[15] I0.f[16] I0.f[17] I0.f[18] I0.f[19] I0.f[20] I0.f[21] I0.f[22] I0.f[23] I0.f[24] I0.f[25] I0.f[26] I0.f[27] I0.f[28] I0.f[29] I0.f[30] I0.f[31] I0.a I1.t[0] I1.t[1] I1.t[2] I1.t[3] I1.t[4] I1.t[5] I1.t[6] I1.t[7] I1.t[8] I1.t[9] I1.t[10] I1.t[11] I1.t[12] I1.t[13] I1.t[14] I1.t[15] I1.t[16] I1.t[17] I1.t[18] I1.t[19] I1.t[20] I1.t[21] I1.t[22] I1.t[23] I1.t[24] I1.t[25] I1.t[26] I1.t[27] I1.t[28] I1.t[29] I1.t[30] I1.t[31] I1.f[0] I1.f[1] I1.f[2] I1.f[3] I1.f[4] I1.f[5] I1.f[6] I1.f[7] I1.f[8] I1.f[9] I1.f[10] I1.f[11] I1.f[12] I1.f[13] I1.f[14] I1.f[15] I1.f[16] I1.f[17] I1.f[18] I1.f[19] I1.f[20] I1.f[21] I1.f[22] I1.f[23] I1.f[24] I1.f[25] I1.f[26] I1.f[27] I1.f[28] I1.f[29] I1.f[30] I1.f[31] I1.a O.t[0] O.t[1] O.t[2] O.t[3] O.t[4] O.t[5] O.t[6] O.t[7] O.t[8] O.t[9] O.t[10] O.t[11] O.t[12] O.t[13] O.t[14] O.t[15] O.t[16] O.t[17] O.t[18] O.t[19] O.t[20] O.t[21] O.t[22] O.t[23] O.t[24] O.t[25] O.t[26] O.t[27] O.t[28] O.t[29] O.t[30] O.t[31] O.f[0] O.f[1] O.f[2] O.f[3] O.f[4] O.f[5] O.f[6] O.f[7] O.f[8] O.f[9] O.f[10] O.f[11] O.f[12] O.f[13] O.f[14] O.f[15] O.f[16] O.f[17] O.f[18] O.f[19] O.f[20] O.f[21] O.f[22] O.f[23] O.f[24] O.f[25] O.f[26] O.f[27] O.f[28] O.f[29] O.f[30] O.f[31] O.a
*
.subckt Merge_332_7t_4 I0_at_50_6 I0_at_51_6 I0_at_52_6 I0_at_53_6 I0_at_54_6 I0_at_55_6 I0_at_56_6 I0_at_57_6 I0_at_58_6 I0_at_59_6 I0_at_510_6 I0_at_511_6 I0_at_512_6 I0_at_513_6 I0_at_514_6 I0_at_515_6 I0_at_516_6 I0_at_517_6 I0_at_518_6 I0_at_519_6 I0_at_520_6 I0_at_521_6 I0_at_522_6 I0_at_523_6 I0_at_524_6 I0_at_525_6 I0_at_526_6 I0_at_527_6 I0_at_528_6 I0_at_529_6 I0_at_530_6 I0_at_531_6 I0_af_50_6 I0_af_51_6 I0_af_52_6 I0_af_53_6 I0_af_54_6 I0_af_55_6 I0_af_56_6 I0_af_57_6 I0_af_58_6 I0_af_59_6 I0_af_510_6 I0_af_511_6 I0_af_512_6 I0_af_513_6 I0_af_514_6 I0_af_515_6 I0_af_516_6 I0_af_517_6 I0_af_518_6 I0_af_519_6 I0_af_520_6 I0_af_521_6 I0_af_522_6 I0_af_523_6 I0_af_524_6 I0_af_525_6 I0_af_526_6 I0_af_527_6 I0_af_528_6 I0_af_529_6 I0_af_530_6 I0_af_531_6 I0_aa I1_at_50_6 I1_at_51_6 I1_at_52_6 I1_at_53_6 I1_at_54_6 I1_at_55_6 I1_at_56_6 I1_at_57_6 I1_at_58_6 I1_at_59_6 I1_at_510_6 I1_at_511_6 I1_at_512_6 I1_at_513_6 I1_at_514_6 I1_at_515_6 I1_at_516_6 I1_at_517_6 I1_at_518_6 I1_at_519_6 I1_at_520_6 I1_at_521_6 I1_at_522_6 I1_at_523_6 I1_at_524_6 I1_at_525_6 I1_at_526_6 I1_at_527_6 I1_at_528_6 I1_at_529_6 I1_at_530_6 I1_at_531_6 I1_af_50_6 I1_af_51_6 I1_af_52_6 I1_af_53_6 I1_af_54_6 I1_af_55_6 I1_af_56_6 I1_af_57_6 I1_af_58_6 I1_af_59_6 I1_af_510_6 I1_af_511_6 I1_af_512_6 I1_af_513_6 I1_af_514_6 I1_af_515_6 I1_af_516_6 I1_af_517_6 I1_af_518_6 I1_af_519_6 I1_af_520_6 I1_af_521_6 I1_af_522_6 I1_af_523_6 I1_af_524_6 I1_af_525_6 I1_af_526_6 I1_af_527_6 I1_af_528_6 I1_af_529_6 I1_af_530_6 I1_af_531_6 I1_aa O_at_50_6 O_at_51_6 O_at_52_6 O_at_53_6 O_at_54_6 O_at_55_6 O_at_56_6 O_at_57_6 O_at_58_6 O_at_59_6 O_at_510_6 O_at_511_6 O_at_512_6 O_at_513_6 O_at_514_6 O_at_515_6 O_at_516_6 O_at_517_6 O_at_518_6 O_at_519_6 O_at_520_6 O_at_521_6 O_at_522_6 O_at_523_6 O_at_524_6 O_at_525_6 O_at_526_6 O_at_527_6 O_at_528_6 O_at_529_6 O_at_530_6 O_at_531_6 O_af_50_6 O_af_51_6 O_af_52_6 O_af_53_6 O_af_54_6 O_af_55_6 O_af_56_6 O_af_57_6 O_af_58_6 O_af_59_6 O_af_510_6 O_af_511_6 O_af_512_6 O_af_513_6 O_af_514_6 O_af_515_6 O_af_516_6 O_af_517_6 O_af_518_6 O_af_519_6 O_af_520_6 O_af_521_6 O_af_522_6 O_af_523_6 O_af_524_6 O_af_525_6 O_af_526_6 O_af_527_6 O_af_528_6 O_af_529_6 O_af_530_6 O_af_531_6 O_aa
*.PININFO I0_at_50_6:I I0_at_51_6:I I0_at_52_6:I I0_at_53_6:I I0_at_54_6:I I0_at_55_6:I I0_at_56_6:I I0_at_57_6:I I0_at_58_6:I I0_at_59_6:I I0_at_510_6:I I0_at_511_6:I I0_at_512_6:I I0_at_513_6:I I0_at_514_6:I I0_at_515_6:I I0_at_516_6:I I0_at_517_6:I I0_at_518_6:I I0_at_519_6:I I0_at_520_6:I I0_at_521_6:I I0_at_522_6:I I0_at_523_6:I I0_at_524_6:I I0_at_525_6:I I0_at_526_6:I I0_at_527_6:I I0_at_528_6:I I0_at_529_6:I I0_at_530_6:I I0_at_531_6:I I0_af_50_6:I I0_af_51_6:I I0_af_52_6:I I0_af_53_6:I I0_af_54_6:I I0_af_55_6:I I0_af_56_6:I I0_af_57_6:I I0_af_58_6:I I0_af_59_6:I I0_af_510_6:I I0_af_511_6:I I0_af_512_6:I I0_af_513_6:I I0_af_514_6:I I0_af_515_6:I I0_af_516_6:I I0_af_517_6:I I0_af_518_6:I I0_af_519_6:I I0_af_520_6:I I0_af_521_6:I I0_af_522_6:I I0_af_523_6:I I0_af_524_6:I I0_af_525_6:I I0_af_526_6:I I0_af_527_6:I I0_af_528_6:I I0_af_529_6:I I0_af_530_6:I I0_af_531_6:I I0_aa:O I1_at_50_6:I I1_at_51_6:I I1_at_52_6:I I1_at_53_6:I I1_at_54_6:I I1_at_55_6:I I1_at_56_6:I I1_at_57_6:I I1_at_58_6:I I1_at_59_6:I I1_at_510_6:I I1_at_511_6:I I1_at_512_6:I I1_at_513_6:I I1_at_514_6:I I1_at_515_6:I I1_at_516_6:I I1_at_517_6:I I1_at_518_6:I I1_at_519_6:I I1_at_520_6:I I1_at_521_6:I I1_at_522_6:I I1_at_523_6:I I1_at_524_6:I I1_at_525_6:I I1_at_526_6:I I1_at_527_6:I I1_at_528_6:I I1_at_529_6:I I1_at_530_6:I I1_at_531_6:I I1_af_50_6:I I1_af_51_6:I I1_af_52_6:I I1_af_53_6:I I1_af_54_6:I I1_af_55_6:I I1_af_56_6:I I1_af_57_6:I I1_af_58_6:I I1_af_59_6:I I1_af_510_6:I I1_af_511_6:I I1_af_512_6:I I1_af_513_6:I I1_af_514_6:I I1_af_515_6:I I1_af_516_6:I I1_af_517_6:I I1_af_518_6:I I1_af_519_6:I I1_af_520_6:I I1_af_521_6:I I1_af_522_6:I I1_af_523_6:I I1_af_524_6:I I1_af_525_6:I I1_af_526_6:I I1_af_527_6:I I1_af_528_6:I I1_af_529_6:I I1_af_530_6:I I1_af_531_6:I I1_aa:O O_at_50_6:O O_at_51_6:O O_at_52_6:O O_at_53_6:O O_at_54_6:O O_at_55_6:O O_at_56_6:O O_at_57_6:O O_at_58_6:O O_at_59_6:O O_at_510_6:O O_at_511_6:O O_at_512_6:O O_at_513_6:O O_at_514_6:O O_at_515_6:O O_at_516_6:O O_at_517_6:O O_at_518_6:O O_at_519_6:O O_at_520_6:O O_at_521_6:O O_at_522_6:O O_at_523_6:O O_at_524_6:O O_at_525_6:O O_at_526_6:O O_at_527_6:O O_at_528_6:O O_at_529_6:O O_at_530_6:O O_at_531_6:O O_af_50_6:O O_af_51_6:O O_af_52_6:O O_af_53_6:O O_af_54_6:O O_af_55_6:O O_af_56_6:O O_af_57_6:O O_af_58_6:O O_af_59_6:O O_af_510_6:O O_af_511_6:O O_af_512_6:O O_af_513_6:O O_af_514_6:O O_af_515_6:O O_af_516_6:O O_af_517_6:O O_af_518_6:O O_af_519_6:O O_af_520_6:O O_af_521_6:O O_af_522_6:O O_af_523_6:O O_af_524_6:O O_af_525_6:O O_af_526_6:O O_af_527_6:O O_af_528_6:O O_af_529_6:O O_af_530_6:O O_af_531_6:O O_aa:I
*.POWER VDD Vdd
*.POWER GND GND
*.POWER NSUB GND
*.POWER PSUB Vdd
*
* --- node flags ---
*
* n__I0__a (state-holding): pup_reff=0.4; pdn_reff=1.33333
* n__I1__a (state-holding): pup_reff=0.4; pdn_reff=1.33333
* n__O__t_50_6 (combinational)
* n__O__f_50_6 (combinational)
* n__O__t_51_6 (combinational)
* n__O__f_51_6 (combinational)
* n__O__t_52_6 (combinational)
* n__O__f_52_6 (combinational)
* n__O__t_53_6 (combinational)
* n__O__f_53_6 (combinational)
* n__O__t_54_6 (combinational)
* n__O__f_54_6 (combinational)
* n__O__t_55_6 (combinational)
* n__O__f_55_6 (combinational)
* n__O__t_56_6 (combinational)
* n__O__f_56_6 (combinational)
* n__O__t_57_6 (combinational)
* n__O__f_57_6 (combinational)
* n__O__t_58_6 (combinational)
* n__O__f_58_6 (combinational)
* n__O__t_59_6 (combinational)
* n__O__f_59_6 (combinational)
* n__O__t_510_6 (combinational)
* n__O__f_510_6 (combinational)
* n__O__t_511_6 (combinational)
* n__O__f_511_6 (combinational)
* n__O__t_512_6 (combinational)
* n__O__f_512_6 (combinational)
* n__O__t_513_6 (combinational)
* n__O__f_513_6 (combinational)
* n__O__t_514_6 (combinational)
* n__O__f_514_6 (combinational)
* n__O__t_515_6 (combinational)
* n__O__f_515_6 (combinational)
* n__O__t_516_6 (combinational)
* n__O__f_516_6 (combinational)
* n__O__t_517_6 (combinational)
* n__O__f_517_6 (combinational)
* n__O__t_518_6 (combinational)
* n__O__f_518_6 (combinational)
* n__O__t_519_6 (combinational)
* n__O__f_519_6 (combinational)
* n__O__t_520_6 (combinational)
* n__O__f_520_6 (combinational)
* n__O__t_521_6 (combinational)
* n__O__f_521_6 (combinational)
* n__O__t_522_6 (combinational)
* n__O__f_522_6 (combinational)
* n__O__t_523_6 (combinational)
* n__O__f_523_6 (combinational)
* n__O__t_524_6 (combinational)
* n__O__f_524_6 (combinational)
* n__O__t_525_6 (combinational)
* n__O__f_525_6 (combinational)
* n__O__t_526_6 (combinational)
* n__O__f_526_6 (combinational)
* n__O__t_527_6 (combinational)
* n__O__f_527_6 (combinational)
* n__O__t_528_6 (combinational)
* n__O__f_528_6 (combinational)
* n__O__t_529_6 (combinational)
* n__O__f_529_6 (combinational)
* n__O__t_530_6 (combinational)
* n__O__f_530_6 (combinational)
* n__O__t_531_6 (combinational)
* n__O__f_531_6 (combinational)
* I0_aa (combinational)
* I1_aa (combinational)
* O_at_50_6 (combinational)
* O_af_50_6 (combinational)
* O_at_51_6 (combinational)
* O_af_51_6 (combinational)
* O_at_52_6 (combinational)
* O_af_52_6 (combinational)
* O_at_53_6 (combinational)
* O_af_53_6 (combinational)
* O_at_54_6 (combinational)
* O_af_54_6 (combinational)
* O_at_55_6 (combinational)
* O_af_55_6 (combinational)
* O_at_56_6 (combinational)
* O_af_56_6 (combinational)
* O_at_57_6 (combinational)
* O_af_57_6 (combinational)
* O_at_58_6 (combinational)
* O_af_58_6 (combinational)
* O_at_59_6 (combinational)
* O_af_59_6 (combinational)
* O_at_510_6 (combinational)
* O_af_510_6 (combinational)
* O_at_511_6 (combinational)
* O_af_511_6 (combinational)
* O_at_512_6 (combinational)
* O_af_512_6 (combinational)
* O_at_513_6 (combinational)
* O_af_513_6 (combinational)
* O_at_514_6 (combinational)
* O_af_514_6 (combinational)
* O_at_515_6 (combinational)
* O_af_515_6 (combinational)
* O_at_516_6 (combinational)
* O_af_516_6 (combinational)
* O_at_517_6 (combinational)
* O_af_517_6 (combinational)
* O_at_518_6 (combinational)
* O_af_518_6 (combinational)
* O_at_519_6 (combinational)
* O_af_519_6 (combinational)
* O_at_520_6 (combinational)
* O_af_520_6 (combinational)
* O_at_521_6 (combinational)
* O_af_521_6 (combinational)
* O_at_522_6 (combinational)
* O_af_522_6 (combinational)
* O_at_523_6 (combinational)
* O_af_523_6 (combinational)
* O_at_524_6 (combinational)
* O_af_524_6 (combinational)
* O_at_525_6 (combinational)
* O_af_525_6 (combinational)
* O_at_526_6 (combinational)
* O_af_526_6 (combinational)
* O_at_527_6 (combinational)
* O_af_527_6 (combinational)
* O_at_528_6 (combinational)
* O_af_528_6 (combinational)
* O_at_529_6 (combinational)
* O_af_529_6 (combinational)
* O_at_530_6 (combinational)
* O_af_530_6 (combinational)
* O_at_531_6 (combinational)
* O_af_531_6 (combinational)
*
* --- end node flags ---
*
M0_ Vdd O_aa n__I0__a Vdd pmos W=0.1625U L=0.065U
M1_ Vdd O_aa n__I1__a Vdd pmos W=0.1625U L=0.065U
M2_ Vdd I0_at_50_6 #14 Vdd pmos W=0.1625U L=0.065U
M3_ Vdd I0_af_50_6 #18 Vdd pmos W=0.1625U L=0.065U
M4_ Vdd I0_at_51_6 #22 Vdd pmos W=0.1625U L=0.065U
M5_ Vdd I0_af_51_6 #26 Vdd pmos W=0.1625U L=0.065U
M6_ Vdd I0_at_52_6 #30 Vdd pmos W=0.1625U L=0.065U
M7_ Vdd I0_af_52_6 #34 Vdd pmos W=0.1625U L=0.065U
M8_ Vdd I0_at_53_6 #38 Vdd pmos W=0.1625U L=0.065U
M9_ Vdd I0_af_53_6 #42 Vdd pmos W=0.1625U L=0.065U
M10_ Vdd I0_at_54_6 #46 Vdd pmos W=0.1625U L=0.065U
M11_ Vdd I0_af_54_6 #50 Vdd pmos W=0.1625U L=0.065U
M12_ Vdd I0_at_55_6 #54 Vdd pmos W=0.1625U L=0.065U
M13_ Vdd I0_af_55_6 #58 Vdd pmos W=0.1625U L=0.065U
M14_ Vdd I0_at_56_6 #62 Vdd pmos W=0.1625U L=0.065U
M15_ Vdd I0_af_56_6 #66 Vdd pmos W=0.1625U L=0.065U
M16_ Vdd I0_at_57_6 #70 Vdd pmos W=0.1625U L=0.065U
M17_ Vdd I0_af_57_6 #74 Vdd pmos W=0.1625U L=0.065U
M18_ Vdd I0_at_58_6 #78 Vdd pmos W=0.1625U L=0.065U
M19_ Vdd I0_af_58_6 #82 Vdd pmos W=0.1625U L=0.065U
M20_ Vdd I0_at_59_6 #86 Vdd pmos W=0.1625U L=0.065U
M21_ Vdd I0_af_59_6 #90 Vdd pmos W=0.1625U L=0.065U
M22_ Vdd I0_at_510_6 #94 Vdd pmos W=0.1625U L=0.065U
M23_ Vdd I0_af_510_6 #98 Vdd pmos W=0.1625U L=0.065U
M24_ Vdd I0_at_511_6 #102 Vdd pmos W=0.1625U L=0.065U
M25_ Vdd I0_af_511_6 #106 Vdd pmos W=0.1625U L=0.065U
M26_ Vdd I0_at_512_6 #110 Vdd pmos W=0.1625U L=0.065U
M27_ Vdd I0_af_512_6 #114 Vdd pmos W=0.1625U L=0.065U
M28_ Vdd I0_at_513_6 #118 Vdd pmos W=0.1625U L=0.065U
M29_ Vdd I0_af_513_6 #122 Vdd pmos W=0.1625U L=0.065U
M30_ Vdd I0_at_514_6 #126 Vdd pmos W=0.1625U L=0.065U
M31_ Vdd I0_af_514_6 #130 Vdd pmos W=0.1625U L=0.065U
M32_ Vdd I0_at_515_6 #134 Vdd pmos W=0.1625U L=0.065U
M33_ Vdd I0_af_515_6 #138 Vdd pmos W=0.1625U L=0.065U
M34_ Vdd I0_at_516_6 #142 Vdd pmos W=0.1625U L=0.065U
M35_ Vdd I0_af_516_6 #146 Vdd pmos W=0.1625U L=0.065U
M36_ Vdd I0_at_517_6 #150 Vdd pmos W=0.1625U L=0.065U
M37_ Vdd I0_af_517_6 #154 Vdd pmos W=0.1625U L=0.065U
M38_ Vdd I0_at_518_6 #158 Vdd pmos W=0.1625U L=0.065U
M39_ Vdd I0_af_518_6 #162 Vdd pmos W=0.1625U L=0.065U
M40_ Vdd I0_at_519_6 #166 Vdd pmos W=0.1625U L=0.065U
M41_ Vdd I0_af_519_6 #170 Vdd pmos W=0.1625U L=0.065U
M42_ Vdd I0_at_520_6 #174 Vdd pmos W=0.1625U L=0.065U
M43_ Vdd I0_af_520_6 #178 Vdd pmos W=0.1625U L=0.065U
M44_ Vdd I0_at_521_6 #182 Vdd pmos W=0.1625U L=0.065U
M45_ Vdd I0_af_521_6 #186 Vdd pmos W=0.1625U L=0.065U
M46_ Vdd I0_at_522_6 #190 Vdd pmos W=0.1625U L=0.065U
M47_ Vdd I0_af_522_6 #194 Vdd pmos W=0.1625U L=0.065U
M48_ Vdd I0_at_523_6 #198 Vdd pmos W=0.1625U L=0.065U
M49_ Vdd I0_af_523_6 #202 Vdd pmos W=0.1625U L=0.065U
M50_ Vdd I0_at_524_6 #206 Vdd pmos W=0.1625U L=0.065U
M51_ Vdd I0_af_524_6 #210 Vdd pmos W=0.1625U L=0.065U
M52_ Vdd I0_at_525_6 #214 Vdd pmos W=0.1625U L=0.065U
M53_ Vdd I0_af_525_6 #218 Vdd pmos W=0.1625U L=0.065U
M54_ Vdd I0_at_526_6 #222 Vdd pmos W=0.1625U L=0.065U
M55_ Vdd I0_af_526_6 #226 Vdd pmos W=0.1625U L=0.065U
M56_ Vdd I0_at_527_6 #230 Vdd pmos W=0.1625U L=0.065U
M57_ Vdd I0_af_527_6 #234 Vdd pmos W=0.1625U L=0.065U
M58_ Vdd I0_at_528_6 #238 Vdd pmos W=0.1625U L=0.065U
M59_ Vdd I0_af_528_6 #242 Vdd pmos W=0.1625U L=0.065U
M60_ Vdd I0_at_529_6 #246 Vdd pmos W=0.1625U L=0.065U
M61_ Vdd I0_af_529_6 #250 Vdd pmos W=0.1625U L=0.065U
M62_ Vdd I0_at_530_6 #254 Vdd pmos W=0.1625U L=0.065U
M63_ Vdd I0_af_530_6 #258 Vdd pmos W=0.1625U L=0.065U
M64_ Vdd I0_at_531_6 #260 Vdd pmos W=0.1625U L=0.065U
M65_ Vdd I0_af_531_6 #262 Vdd pmos W=0.1625U L=0.065U
M66_ Vdd n__I0__a I0_aa Vdd pmos W=0.1625U L=0.065U
M67_ Vdd n__I1__a I1_aa Vdd pmos W=0.1625U L=0.065U
M68_ Vdd n__O__t_50_6 O_at_50_6 Vdd pmos W=0.1625U L=0.065U
M69_ Vdd n__O__f_50_6 O_af_50_6 Vdd pmos W=0.1625U L=0.065U
M70_ Vdd n__O__t_51_6 O_at_51_6 Vdd pmos W=0.1625U L=0.065U
M71_ Vdd n__O__f_51_6 O_af_51_6 Vdd pmos W=0.1625U L=0.065U
M72_ Vdd n__O__t_52_6 O_at_52_6 Vdd pmos W=0.1625U L=0.065U
M73_ Vdd n__O__f_52_6 O_af_52_6 Vdd pmos W=0.1625U L=0.065U
M74_ Vdd n__O__t_53_6 O_at_53_6 Vdd pmos W=0.1625U L=0.065U
M75_ Vdd n__O__f_53_6 O_af_53_6 Vdd pmos W=0.1625U L=0.065U
M76_ Vdd n__O__t_54_6 O_at_54_6 Vdd pmos W=0.1625U L=0.065U
M77_ Vdd n__O__f_54_6 O_af_54_6 Vdd pmos W=0.1625U L=0.065U
M78_ Vdd n__O__t_55_6 O_at_55_6 Vdd pmos W=0.1625U L=0.065U
M79_ Vdd n__O__f_55_6 O_af_55_6 Vdd pmos W=0.1625U L=0.065U
M80_ Vdd n__O__t_56_6 O_at_56_6 Vdd pmos W=0.1625U L=0.065U
M81_ Vdd n__O__f_56_6 O_af_56_6 Vdd pmos W=0.1625U L=0.065U
M82_ Vdd n__O__t_57_6 O_at_57_6 Vdd pmos W=0.1625U L=0.065U
M83_ Vdd n__O__f_57_6 O_af_57_6 Vdd pmos W=0.1625U L=0.065U
M84_ Vdd n__O__t_58_6 O_at_58_6 Vdd pmos W=0.1625U L=0.065U
M85_ Vdd n__O__f_58_6 O_af_58_6 Vdd pmos W=0.1625U L=0.065U
M86_ Vdd n__O__t_59_6 O_at_59_6 Vdd pmos W=0.1625U L=0.065U
M87_ Vdd n__O__f_59_6 O_af_59_6 Vdd pmos W=0.1625U L=0.065U
M88_ Vdd n__O__t_510_6 O_at_510_6 Vdd pmos W=0.1625U L=0.065U
M89_ Vdd n__O__f_510_6 O_af_510_6 Vdd pmos W=0.1625U L=0.065U
M90_ Vdd n__O__t_511_6 O_at_511_6 Vdd pmos W=0.1625U L=0.065U
M91_ Vdd n__O__f_511_6 O_af_511_6 Vdd pmos W=0.1625U L=0.065U
M92_ Vdd n__O__t_512_6 O_at_512_6 Vdd pmos W=0.1625U L=0.065U
M93_ Vdd n__O__f_512_6 O_af_512_6 Vdd pmos W=0.1625U L=0.065U
M94_ Vdd n__O__t_513_6 O_at_513_6 Vdd pmos W=0.1625U L=0.065U
M95_ Vdd n__O__f_513_6 O_af_513_6 Vdd pmos W=0.1625U L=0.065U
M96_ Vdd n__O__t_514_6 O_at_514_6 Vdd pmos W=0.1625U L=0.065U
M97_ Vdd n__O__f_514_6 O_af_514_6 Vdd pmos W=0.1625U L=0.065U
M98_ Vdd n__O__t_515_6 O_at_515_6 Vdd pmos W=0.1625U L=0.065U
M99_ Vdd n__O__f_515_6 O_af_515_6 Vdd pmos W=0.1625U L=0.065U
M100_ Vdd n__O__t_516_6 O_at_516_6 Vdd pmos W=0.1625U L=0.065U
M101_ Vdd n__O__f_516_6 O_af_516_6 Vdd pmos W=0.1625U L=0.065U
M102_ Vdd n__O__t_517_6 O_at_517_6 Vdd pmos W=0.1625U L=0.065U
M103_ Vdd n__O__f_517_6 O_af_517_6 Vdd pmos W=0.1625U L=0.065U
M104_ Vdd n__O__t_518_6 O_at_518_6 Vdd pmos W=0.1625U L=0.065U
M105_ Vdd n__O__f_518_6 O_af_518_6 Vdd pmos W=0.1625U L=0.065U
M106_ Vdd n__O__t_519_6 O_at_519_6 Vdd pmos W=0.1625U L=0.065U
M107_ Vdd n__O__f_519_6 O_af_519_6 Vdd pmos W=0.1625U L=0.065U
M108_ Vdd n__O__t_520_6 O_at_520_6 Vdd pmos W=0.1625U L=0.065U
M109_ Vdd n__O__f_520_6 O_af_520_6 Vdd pmos W=0.1625U L=0.065U
M110_ Vdd n__O__t_521_6 O_at_521_6 Vdd pmos W=0.1625U L=0.065U
M111_ Vdd n__O__f_521_6 O_af_521_6 Vdd pmos W=0.1625U L=0.065U
M112_ Vdd n__O__t_522_6 O_at_522_6 Vdd pmos W=0.1625U L=0.065U
M113_ Vdd n__O__f_522_6 O_af_522_6 Vdd pmos W=0.1625U L=0.065U
M114_ Vdd n__O__t_523_6 O_at_523_6 Vdd pmos W=0.1625U L=0.065U
M115_ Vdd n__O__f_523_6 O_af_523_6 Vdd pmos W=0.1625U L=0.065U
M116_ Vdd n__O__t_524_6 O_at_524_6 Vdd pmos W=0.1625U L=0.065U
M117_ Vdd n__O__f_524_6 O_af_524_6 Vdd pmos W=0.1625U L=0.065U
M118_ Vdd n__O__t_525_6 O_at_525_6 Vdd pmos W=0.1625U L=0.065U
M119_ Vdd n__O__f_525_6 O_af_525_6 Vdd pmos W=0.1625U L=0.065U
M120_ Vdd n__O__t_526_6 O_at_526_6 Vdd pmos W=0.1625U L=0.065U
M121_ Vdd n__O__f_526_6 O_af_526_6 Vdd pmos W=0.1625U L=0.065U
M122_ Vdd n__O__t_527_6 O_at_527_6 Vdd pmos W=0.1625U L=0.065U
M123_ Vdd n__O__f_527_6 O_af_527_6 Vdd pmos W=0.1625U L=0.065U
M124_ Vdd n__O__t_528_6 O_at_528_6 Vdd pmos W=0.1625U L=0.065U
M125_ Vdd n__O__f_528_6 O_af_528_6 Vdd pmos W=0.1625U L=0.065U
M126_ Vdd n__O__t_529_6 O_at_529_6 Vdd pmos W=0.1625U L=0.065U
M127_ Vdd n__O__f_529_6 O_af_529_6 Vdd pmos W=0.1625U L=0.065U
M128_ Vdd n__O__t_530_6 O_at_530_6 Vdd pmos W=0.1625U L=0.065U
M129_ Vdd n__O__f_530_6 O_af_530_6 Vdd pmos W=0.1625U L=0.065U
M130_ Vdd n__O__t_531_6 O_at_531_6 Vdd pmos W=0.1625U L=0.065U
M131_ Vdd n__O__f_531_6 O_af_531_6 Vdd pmos W=0.1625U L=0.065U
M132_ Vdd n__I0__a #fb329# Vdd pmos W=0.1625U L=0.13U
M133_ Vdd n__I1__a #fb332# Vdd pmos W=0.1625U L=0.13U
M134_keeper Vdd GND #330 Vdd pmos W=0.0975U L=0.585U
M135_keeper Vdd GND #333 Vdd pmos W=0.0975U L=0.585U
M136_ GND O_aa #3 GND nmos W=0.0975U L=0.065U
M137_ GND O_aa #8 GND nmos W=0.0975U L=0.065U
M138_ GND I0_at_50_6 n__O__t_50_6 GND nmos W=0.0975U L=0.065U
M139_ GND I1_at_50_6 n__O__t_50_6 GND nmos W=0.0975U L=0.065U
M140_ GND I0_af_50_6 n__O__f_50_6 GND nmos W=0.0975U L=0.065U
M141_ GND I1_af_50_6 n__O__f_50_6 GND nmos W=0.0975U L=0.065U
M142_ GND I0_at_51_6 n__O__t_51_6 GND nmos W=0.0975U L=0.065U
M143_ GND I1_at_51_6 n__O__t_51_6 GND nmos W=0.0975U L=0.065U
M144_ GND I0_af_51_6 n__O__f_51_6 GND nmos W=0.0975U L=0.065U
M145_ GND I1_af_51_6 n__O__f_51_6 GND nmos W=0.0975U L=0.065U
M146_ GND I0_at_52_6 n__O__t_52_6 GND nmos W=0.0975U L=0.065U
M147_ GND I1_at_52_6 n__O__t_52_6 GND nmos W=0.0975U L=0.065U
M148_ GND I0_af_52_6 n__O__f_52_6 GND nmos W=0.0975U L=0.065U
M149_ GND I1_af_52_6 n__O__f_52_6 GND nmos W=0.0975U L=0.065U
M150_ GND I0_at_53_6 n__O__t_53_6 GND nmos W=0.0975U L=0.065U
M151_ GND I1_at_53_6 n__O__t_53_6 GND nmos W=0.0975U L=0.065U
M152_ GND I0_af_53_6 n__O__f_53_6 GND nmos W=0.0975U L=0.065U
M153_ GND I1_af_53_6 n__O__f_53_6 GND nmos W=0.0975U L=0.065U
M154_ GND I0_at_54_6 n__O__t_54_6 GND nmos W=0.0975U L=0.065U
M155_ GND I1_at_54_6 n__O__t_54_6 GND nmos W=0.0975U L=0.065U
M156_ GND I0_af_54_6 n__O__f_54_6 GND nmos W=0.0975U L=0.065U
M157_ GND I1_af_54_6 n__O__f_54_6 GND nmos W=0.0975U L=0.065U
M158_ GND I0_at_55_6 n__O__t_55_6 GND nmos W=0.0975U L=0.065U
M159_ GND I1_at_55_6 n__O__t_55_6 GND nmos W=0.0975U L=0.065U
M160_ GND I0_af_55_6 n__O__f_55_6 GND nmos W=0.0975U L=0.065U
M161_ GND I1_af_55_6 n__O__f_55_6 GND nmos W=0.0975U L=0.065U
M162_ GND I0_at_56_6 n__O__t_56_6 GND nmos W=0.0975U L=0.065U
M163_ GND I1_at_56_6 n__O__t_56_6 GND nmos W=0.0975U L=0.065U
M164_ GND I0_af_56_6 n__O__f_56_6 GND nmos W=0.0975U L=0.065U
M165_ GND I1_af_56_6 n__O__f_56_6 GND nmos W=0.0975U L=0.065U
M166_ GND I0_at_57_6 n__O__t_57_6 GND nmos W=0.0975U L=0.065U
M167_ GND I1_at_57_6 n__O__t_57_6 GND nmos W=0.0975U L=0.065U
M168_ GND I0_af_57_6 n__O__f_57_6 GND nmos W=0.0975U L=0.065U
M169_ GND I1_af_57_6 n__O__f_57_6 GND nmos W=0.0975U L=0.065U
M170_ GND I0_at_58_6 n__O__t_58_6 GND nmos W=0.0975U L=0.065U
M171_ GND I1_at_58_6 n__O__t_58_6 GND nmos W=0.0975U L=0.065U
M172_ GND I0_af_58_6 n__O__f_58_6 GND nmos W=0.0975U L=0.065U
M173_ GND I1_af_58_6 n__O__f_58_6 GND nmos W=0.0975U L=0.065U
M174_ GND I0_at_59_6 n__O__t_59_6 GND nmos W=0.0975U L=0.065U
M175_ GND I1_at_59_6 n__O__t_59_6 GND nmos W=0.0975U L=0.065U
M176_ GND I0_af_59_6 n__O__f_59_6 GND nmos W=0.0975U L=0.065U
M177_ GND I1_af_59_6 n__O__f_59_6 GND nmos W=0.0975U L=0.065U
M178_ GND I0_at_510_6 n__O__t_510_6 GND nmos W=0.0975U L=0.065U
M179_ GND I1_at_510_6 n__O__t_510_6 GND nmos W=0.0975U L=0.065U
M180_ GND I0_af_510_6 n__O__f_510_6 GND nmos W=0.0975U L=0.065U
M181_ GND I1_af_510_6 n__O__f_510_6 GND nmos W=0.0975U L=0.065U
M182_ GND I0_at_511_6 n__O__t_511_6 GND nmos W=0.0975U L=0.065U
M183_ GND I1_at_511_6 n__O__t_511_6 GND nmos W=0.0975U L=0.065U
M184_ GND I0_af_511_6 n__O__f_511_6 GND nmos W=0.0975U L=0.065U
M185_ GND I1_af_511_6 n__O__f_511_6 GND nmos W=0.0975U L=0.065U
M186_ GND I0_at_512_6 n__O__t_512_6 GND nmos W=0.0975U L=0.065U
M187_ GND I1_at_512_6 n__O__t_512_6 GND nmos W=0.0975U L=0.065U
M188_ GND I0_af_512_6 n__O__f_512_6 GND nmos W=0.0975U L=0.065U
M189_ GND I1_af_512_6 n__O__f_512_6 GND nmos W=0.0975U L=0.065U
M190_ GND I0_at_513_6 n__O__t_513_6 GND nmos W=0.0975U L=0.065U
M191_ GND I1_at_513_6 n__O__t_513_6 GND nmos W=0.0975U L=0.065U
M192_ GND I0_af_513_6 n__O__f_513_6 GND nmos W=0.0975U L=0.065U
M193_ GND I1_af_513_6 n__O__f_513_6 GND nmos W=0.0975U L=0.065U
M194_ GND I0_at_514_6 n__O__t_514_6 GND nmos W=0.0975U L=0.065U
M195_ GND I1_at_514_6 n__O__t_514_6 GND nmos W=0.0975U L=0.065U
M196_ GND I0_af_514_6 n__O__f_514_6 GND nmos W=0.0975U L=0.065U
M197_ GND I1_af_514_6 n__O__f_514_6 GND nmos W=0.0975U L=0.065U
M198_ GND I0_at_515_6 n__O__t_515_6 GND nmos W=0.0975U L=0.065U
M199_ GND I1_at_515_6 n__O__t_515_6 GND nmos W=0.0975U L=0.065U
M200_ GND I0_af_515_6 n__O__f_515_6 GND nmos W=0.0975U L=0.065U
M201_ GND I1_af_515_6 n__O__f_515_6 GND nmos W=0.0975U L=0.065U
M202_ GND I0_at_516_6 n__O__t_516_6 GND nmos W=0.0975U L=0.065U
M203_ GND I1_at_516_6 n__O__t_516_6 GND nmos W=0.0975U L=0.065U
M204_ GND I0_af_516_6 n__O__f_516_6 GND nmos W=0.0975U L=0.065U
M205_ GND I1_af_516_6 n__O__f_516_6 GND nmos W=0.0975U L=0.065U
M206_ GND I0_at_517_6 n__O__t_517_6 GND nmos W=0.0975U L=0.065U
M207_ GND I1_at_517_6 n__O__t_517_6 GND nmos W=0.0975U L=0.065U
M208_ GND I0_af_517_6 n__O__f_517_6 GND nmos W=0.0975U L=0.065U
M209_ GND I1_af_517_6 n__O__f_517_6 GND nmos W=0.0975U L=0.065U
M210_ GND I0_at_518_6 n__O__t_518_6 GND nmos W=0.0975U L=0.065U
M211_ GND I1_at_518_6 n__O__t_518_6 GND nmos W=0.0975U L=0.065U
M212_ GND I0_af_518_6 n__O__f_518_6 GND nmos W=0.0975U L=0.065U
M213_ GND I1_af_518_6 n__O__f_518_6 GND nmos W=0.0975U L=0.065U
M214_ GND I0_at_519_6 n__O__t_519_6 GND nmos W=0.0975U L=0.065U
M215_ GND I1_at_519_6 n__O__t_519_6 GND nmos W=0.0975U L=0.065U
M216_ GND I0_af_519_6 n__O__f_519_6 GND nmos W=0.0975U L=0.065U
M217_ GND I1_af_519_6 n__O__f_519_6 GND nmos W=0.0975U L=0.065U
M218_ GND I0_at_520_6 n__O__t_520_6 GND nmos W=0.0975U L=0.065U
M219_ GND I1_at_520_6 n__O__t_520_6 GND nmos W=0.0975U L=0.065U
M220_ GND I0_af_520_6 n__O__f_520_6 GND nmos W=0.0975U L=0.065U
M221_ GND I1_af_520_6 n__O__f_520_6 GND nmos W=0.0975U L=0.065U
M222_ GND I0_at_521_6 n__O__t_521_6 GND nmos W=0.0975U L=0.065U
M223_ GND I1_at_521_6 n__O__t_521_6 GND nmos W=0.0975U L=0.065U
M224_ GND I0_af_521_6 n__O__f_521_6 GND nmos W=0.0975U L=0.065U
M225_ GND I1_af_521_6 n__O__f_521_6 GND nmos W=0.0975U L=0.065U
M226_ GND I0_at_522_6 n__O__t_522_6 GND nmos W=0.0975U L=0.065U
M227_ GND I1_at_522_6 n__O__t_522_6 GND nmos W=0.0975U L=0.065U
M228_ GND I0_af_522_6 n__O__f_522_6 GND nmos W=0.0975U L=0.065U
M229_ GND I1_af_522_6 n__O__f_522_6 GND nmos W=0.0975U L=0.065U
M230_ GND I0_at_523_6 n__O__t_523_6 GND nmos W=0.0975U L=0.065U
M231_ GND I1_at_523_6 n__O__t_523_6 GND nmos W=0.0975U L=0.065U
M232_ GND I0_af_523_6 n__O__f_523_6 GND nmos W=0.0975U L=0.065U
M233_ GND I1_af_523_6 n__O__f_523_6 GND nmos W=0.0975U L=0.065U
M234_ GND I0_at_524_6 n__O__t_524_6 GND nmos W=0.0975U L=0.065U
M235_ GND I1_at_524_6 n__O__t_524_6 GND nmos W=0.0975U L=0.065U
M236_ GND I0_af_524_6 n__O__f_524_6 GND nmos W=0.0975U L=0.065U
M237_ GND I1_af_524_6 n__O__f_524_6 GND nmos W=0.0975U L=0.065U
M238_ GND I0_at_525_6 n__O__t_525_6 GND nmos W=0.0975U L=0.065U
M239_ GND I1_at_525_6 n__O__t_525_6 GND nmos W=0.0975U L=0.065U
M240_ GND I0_af_525_6 n__O__f_525_6 GND nmos W=0.0975U L=0.065U
M241_ GND I1_af_525_6 n__O__f_525_6 GND nmos W=0.0975U L=0.065U
M242_ GND I0_at_526_6 n__O__t_526_6 GND nmos W=0.0975U L=0.065U
M243_ GND I1_at_526_6 n__O__t_526_6 GND nmos W=0.0975U L=0.065U
M244_ GND I0_af_526_6 n__O__f_526_6 GND nmos W=0.0975U L=0.065U
M245_ GND I1_af_526_6 n__O__f_526_6 GND nmos W=0.0975U L=0.065U
M246_ GND I0_at_527_6 n__O__t_527_6 GND nmos W=0.0975U L=0.065U
M247_ GND I1_at_527_6 n__O__t_527_6 GND nmos W=0.0975U L=0.065U
M248_ GND I0_af_527_6 n__O__f_527_6 GND nmos W=0.0975U L=0.065U
M249_ GND I1_af_527_6 n__O__f_527_6 GND nmos W=0.0975U L=0.065U
M250_ GND I0_at_528_6 n__O__t_528_6 GND nmos W=0.0975U L=0.065U
M251_ GND I1_at_528_6 n__O__t_528_6 GND nmos W=0.0975U L=0.065U
M252_ GND I0_af_528_6 n__O__f_528_6 GND nmos W=0.0975U L=0.065U
M253_ GND I1_af_528_6 n__O__f_528_6 GND nmos W=0.0975U L=0.065U
M254_ GND I0_at_529_6 n__O__t_529_6 GND nmos W=0.0975U L=0.065U
M255_ GND I1_at_529_6 n__O__t_529_6 GND nmos W=0.0975U L=0.065U
M256_ GND I0_af_529_6 n__O__f_529_6 GND nmos W=0.0975U L=0.065U
M257_ GND I1_af_529_6 n__O__f_529_6 GND nmos W=0.0975U L=0.065U
M258_ GND I0_at_530_6 n__O__t_530_6 GND nmos W=0.0975U L=0.065U
M259_ GND I1_at_530_6 n__O__t_530_6 GND nmos W=0.0975U L=0.065U
M260_ GND I0_af_530_6 n__O__f_530_6 GND nmos W=0.0975U L=0.065U
M261_ GND I1_af_530_6 n__O__f_530_6 GND nmos W=0.0975U L=0.065U
M262_ GND I0_at_531_6 n__O__t_531_6 GND nmos W=0.0975U L=0.065U
M263_ GND I1_at_531_6 n__O__t_531_6 GND nmos W=0.0975U L=0.065U
M264_ GND I0_af_531_6 n__O__f_531_6 GND nmos W=0.0975U L=0.065U
M265_ GND I1_af_531_6 n__O__f_531_6 GND nmos W=0.0975U L=0.065U
M266_ GND n__I0__a I0_aa GND nmos W=0.0975U L=0.065U
M267_ GND n__I1__a I1_aa GND nmos W=0.0975U L=0.065U
M268_ GND n__O__t_50_6 O_at_50_6 GND nmos W=0.0975U L=0.065U
M269_ GND n__O__f_50_6 O_af_50_6 GND nmos W=0.0975U L=0.065U
M270_ GND n__O__t_51_6 O_at_51_6 GND nmos W=0.0975U L=0.065U
M271_ GND n__O__f_51_6 O_af_51_6 GND nmos W=0.0975U L=0.065U
M272_ GND n__O__t_52_6 O_at_52_6 GND nmos W=0.0975U L=0.065U
M273_ GND n__O__f_52_6 O_af_52_6 GND nmos W=0.0975U L=0.065U
M274_ GND n__O__t_53_6 O_at_53_6 GND nmos W=0.0975U L=0.065U
M275_ GND n__O__f_53_6 O_af_53_6 GND nmos W=0.0975U L=0.065U
M276_ GND n__O__t_54_6 O_at_54_6 GND nmos W=0.0975U L=0.065U
M277_ GND n__O__f_54_6 O_af_54_6 GND nmos W=0.0975U L=0.065U
M278_ GND n__O__t_55_6 O_at_55_6 GND nmos W=0.0975U L=0.065U
M279_ GND n__O__f_55_6 O_af_55_6 GND nmos W=0.0975U L=0.065U
M280_ GND n__O__t_56_6 O_at_56_6 GND nmos W=0.0975U L=0.065U
M281_ GND n__O__f_56_6 O_af_56_6 GND nmos W=0.0975U L=0.065U
M282_ GND n__O__t_57_6 O_at_57_6 GND nmos W=0.0975U L=0.065U
M283_ GND n__O__f_57_6 O_af_57_6 GND nmos W=0.0975U L=0.065U
M284_ GND n__O__t_58_6 O_at_58_6 GND nmos W=0.0975U L=0.065U
M285_ GND n__O__f_58_6 O_af_58_6 GND nmos W=0.0975U L=0.065U
M286_ GND n__O__t_59_6 O_at_59_6 GND nmos W=0.0975U L=0.065U
M287_ GND n__O__f_59_6 O_af_59_6 GND nmos W=0.0975U L=0.065U
M288_ GND n__O__t_510_6 O_at_510_6 GND nmos W=0.0975U L=0.065U
M289_ GND n__O__f_510_6 O_af_510_6 GND nmos W=0.0975U L=0.065U
M290_ GND n__O__t_511_6 O_at_511_6 GND nmos W=0.0975U L=0.065U
M291_ GND n__O__f_511_6 O_af_511_6 GND nmos W=0.0975U L=0.065U
M292_ GND n__O__t_512_6 O_at_512_6 GND nmos W=0.0975U L=0.065U
M293_ GND n__O__f_512_6 O_af_512_6 GND nmos W=0.0975U L=0.065U
M294_ GND n__O__t_513_6 O_at_513_6 GND nmos W=0.0975U L=0.065U
M295_ GND n__O__f_513_6 O_af_513_6 GND nmos W=0.0975U L=0.065U
M296_ GND n__O__t_514_6 O_at_514_6 GND nmos W=0.0975U L=0.065U
M297_ GND n__O__f_514_6 O_af_514_6 GND nmos W=0.0975U L=0.065U
M298_ GND n__O__t_515_6 O_at_515_6 GND nmos W=0.0975U L=0.065U
M299_ GND n__O__f_515_6 O_af_515_6 GND nmos W=0.0975U L=0.065U
M300_ GND n__O__t_516_6 O_at_516_6 GND nmos W=0.0975U L=0.065U
M301_ GND n__O__f_516_6 O_af_516_6 GND nmos W=0.0975U L=0.065U
M302_ GND n__O__t_517_6 O_at_517_6 GND nmos W=0.0975U L=0.065U
M303_ GND n__O__f_517_6 O_af_517_6 GND nmos W=0.0975U L=0.065U
M304_ GND n__O__t_518_6 O_at_518_6 GND nmos W=0.0975U L=0.065U
M305_ GND n__O__f_518_6 O_af_518_6 GND nmos W=0.0975U L=0.065U
M306_ GND n__O__t_519_6 O_at_519_6 GND nmos W=0.0975U L=0.065U
M307_ GND n__O__f_519_6 O_af_519_6 GND nmos W=0.0975U L=0.065U
M308_ GND n__O__t_520_6 O_at_520_6 GND nmos W=0.0975U L=0.065U
M309_ GND n__O__f_520_6 O_af_520_6 GND nmos W=0.0975U L=0.065U
M310_ GND n__O__t_521_6 O_at_521_6 GND nmos W=0.0975U L=0.065U
M311_ GND n__O__f_521_6 O_af_521_6 GND nmos W=0.0975U L=0.065U
M312_ GND n__O__t_522_6 O_at_522_6 GND nmos W=0.0975U L=0.065U
M313_ GND n__O__f_522_6 O_af_522_6 GND nmos W=0.0975U L=0.065U
M314_ GND n__O__t_523_6 O_at_523_6 GND nmos W=0.0975U L=0.065U
M315_ GND n__O__f_523_6 O_af_523_6 GND nmos W=0.0975U L=0.065U
M316_ GND n__O__t_524_6 O_at_524_6 GND nmos W=0.0975U L=0.065U
M317_ GND n__O__f_524_6 O_af_524_6 GND nmos W=0.0975U L=0.065U
M318_ GND n__O__t_525_6 O_at_525_6 GND nmos W=0.0975U L=0.065U
M319_ GND n__O__f_525_6 O_af_525_6 GND nmos W=0.0975U L=0.065U
M320_ GND n__O__t_526_6 O_at_526_6 GND nmos W=0.0975U L=0.065U
M321_ GND n__O__f_526_6 O_af_526_6 GND nmos W=0.0975U L=0.065U
M322_ GND n__O__t_527_6 O_at_527_6 GND nmos W=0.0975U L=0.065U
M323_ GND n__O__f_527_6 O_af_527_6 GND nmos W=0.0975U L=0.065U
M324_ GND n__O__t_528_6 O_at_528_6 GND nmos W=0.0975U L=0.065U
M325_ GND n__O__f_528_6 O_af_528_6 GND nmos W=0.0975U L=0.065U
M326_ GND n__O__t_529_6 O_at_529_6 GND nmos W=0.0975U L=0.065U
M327_ GND n__O__f_529_6 O_af_529_6 GND nmos W=0.0975U L=0.065U
M328_ GND n__O__t_530_6 O_at_530_6 GND nmos W=0.0975U L=0.065U
M329_ GND n__O__f_530_6 O_af_530_6 GND nmos W=0.0975U L=0.065U
M330_ GND n__O__t_531_6 O_at_531_6 GND nmos W=0.0975U L=0.065U
M331_ GND n__O__f_531_6 O_af_531_6 GND nmos W=0.0975U L=0.065U
M332_ GND n__I0__a #fb329# GND nmos W=0.0975U L=0.13U
M333_ GND n__I1__a #fb332# GND nmos W=0.0975U L=0.13U
M334_keeper GND Vdd #331 GND nmos W=0.0975U L=0.715U
M335_keeper GND Vdd #334 GND nmos W=0.0975U L=0.715U
M336_ #3 I0_at_531_6 n__I0__a GND nmos W=0.0975U L=0.065U
M337_ #3 I0_af_531_6 n__I0__a GND nmos W=0.0975U L=0.065U
M338_keeper #330 #fb329# n__I0__a Vdd pmos W=0.0975U L=0.065U
M339_keeper #331 #fb329# n__I0__a GND nmos W=0.0975U L=0.065U
M340_ #8 I1_at_531_6 n__I1__a GND nmos W=0.0975U L=0.065U
M341_ #8 I1_af_531_6 n__I1__a GND nmos W=0.0975U L=0.065U
M342_keeper #333 #fb332# n__I1__a Vdd pmos W=0.0975U L=0.065U
M343_keeper #334 #fb332# n__I1__a GND nmos W=0.0975U L=0.065U
M344_ #14 I1_at_50_6 n__O__t_50_6 Vdd pmos W=0.1625U L=0.065U
M345_ #18 I1_af_50_6 n__O__f_50_6 Vdd pmos W=0.1625U L=0.065U
M346_ #22 I1_at_51_6 n__O__t_51_6 Vdd pmos W=0.1625U L=0.065U
M347_ #26 I1_af_51_6 n__O__f_51_6 Vdd pmos W=0.1625U L=0.065U
M348_ #30 I1_at_52_6 n__O__t_52_6 Vdd pmos W=0.1625U L=0.065U
M349_ #34 I1_af_52_6 n__O__f_52_6 Vdd pmos W=0.1625U L=0.065U
M350_ #38 I1_at_53_6 n__O__t_53_6 Vdd pmos W=0.1625U L=0.065U
M351_ #42 I1_af_53_6 n__O__f_53_6 Vdd pmos W=0.1625U L=0.065U
M352_ #46 I1_at_54_6 n__O__t_54_6 Vdd pmos W=0.1625U L=0.065U
M353_ #50 I1_af_54_6 n__O__f_54_6 Vdd pmos W=0.1625U L=0.065U
M354_ #54 I1_at_55_6 n__O__t_55_6 Vdd pmos W=0.1625U L=0.065U
M355_ #58 I1_af_55_6 n__O__f_55_6 Vdd pmos W=0.1625U L=0.065U
M356_ #62 I1_at_56_6 n__O__t_56_6 Vdd pmos W=0.1625U L=0.065U
M357_ #66 I1_af_56_6 n__O__f_56_6 Vdd pmos W=0.1625U L=0.065U
M358_ #70 I1_at_57_6 n__O__t_57_6 Vdd pmos W=0.1625U L=0.065U
M359_ #74 I1_af_57_6 n__O__f_57_6 Vdd pmos W=0.1625U L=0.065U
M360_ #78 I1_at_58_6 n__O__t_58_6 Vdd pmos W=0.1625U L=0.065U
M361_ #82 I1_af_58_6 n__O__f_58_6 Vdd pmos W=0.1625U L=0.065U
M362_ #86 I1_at_59_6 n__O__t_59_6 Vdd pmos W=0.1625U L=0.065U
M363_ #90 I1_af_59_6 n__O__f_59_6 Vdd pmos W=0.1625U L=0.065U
M364_ #94 I1_at_510_6 n__O__t_510_6 Vdd pmos W=0.1625U L=0.065U
M365_ #98 I1_af_510_6 n__O__f_510_6 Vdd pmos W=0.1625U L=0.065U
M366_ #102 I1_at_511_6 n__O__t_511_6 Vdd pmos W=0.1625U L=0.065U
M367_ #106 I1_af_511_6 n__O__f_511_6 Vdd pmos W=0.1625U L=0.065U
M368_ #110 I1_at_512_6 n__O__t_512_6 Vdd pmos W=0.1625U L=0.065U
M369_ #114 I1_af_512_6 n__O__f_512_6 Vdd pmos W=0.1625U L=0.065U
M370_ #118 I1_at_513_6 n__O__t_513_6 Vdd pmos W=0.1625U L=0.065U
M371_ #122 I1_af_513_6 n__O__f_513_6 Vdd pmos W=0.1625U L=0.065U
M372_ #126 I1_at_514_6 n__O__t_514_6 Vdd pmos W=0.1625U L=0.065U
M373_ #130 I1_af_514_6 n__O__f_514_6 Vdd pmos W=0.1625U L=0.065U
M374_ #134 I1_at_515_6 n__O__t_515_6 Vdd pmos W=0.1625U L=0.065U
M375_ #138 I1_af_515_6 n__O__f_515_6 Vdd pmos W=0.1625U L=0.065U
M376_ #142 I1_at_516_6 n__O__t_516_6 Vdd pmos W=0.1625U L=0.065U
M377_ #146 I1_af_516_6 n__O__f_516_6 Vdd pmos W=0.1625U L=0.065U
M378_ #150 I1_at_517_6 n__O__t_517_6 Vdd pmos W=0.1625U L=0.065U
M379_ #154 I1_af_517_6 n__O__f_517_6 Vdd pmos W=0.1625U L=0.065U
M380_ #158 I1_at_518_6 n__O__t_518_6 Vdd pmos W=0.1625U L=0.065U
M381_ #162 I1_af_518_6 n__O__f_518_6 Vdd pmos W=0.1625U L=0.065U
M382_ #166 I1_at_519_6 n__O__t_519_6 Vdd pmos W=0.1625U L=0.065U
M383_ #170 I1_af_519_6 n__O__f_519_6 Vdd pmos W=0.1625U L=0.065U
M384_ #174 I1_at_520_6 n__O__t_520_6 Vdd pmos W=0.1625U L=0.065U
M385_ #178 I1_af_520_6 n__O__f_520_6 Vdd pmos W=0.1625U L=0.065U
M386_ #182 I1_at_521_6 n__O__t_521_6 Vdd pmos W=0.1625U L=0.065U
M387_ #186 I1_af_521_6 n__O__f_521_6 Vdd pmos W=0.1625U L=0.065U
M388_ #190 I1_at_522_6 n__O__t_522_6 Vdd pmos W=0.1625U L=0.065U
M389_ #194 I1_af_522_6 n__O__f_522_6 Vdd pmos W=0.1625U L=0.065U
M390_ #198 I1_at_523_6 n__O__t_523_6 Vdd pmos W=0.1625U L=0.065U
M391_ #202 I1_af_523_6 n__O__f_523_6 Vdd pmos W=0.1625U L=0.065U
M392_ #206 I1_at_524_6 n__O__t_524_6 Vdd pmos W=0.1625U L=0.065U
M393_ #210 I1_af_524_6 n__O__f_524_6 Vdd pmos W=0.1625U L=0.065U
M394_ #214 I1_at_525_6 n__O__t_525_6 Vdd pmos W=0.1625U L=0.065U
M395_ #218 I1_af_525_6 n__O__f_525_6 Vdd pmos W=0.1625U L=0.065U
M396_ #222 I1_at_526_6 n__O__t_526_6 Vdd pmos W=0.1625U L=0.065U
M397_ #226 I1_af_526_6 n__O__f_526_6 Vdd pmos W=0.1625U L=0.065U
M398_ #230 I1_at_527_6 n__O__t_527_6 Vdd pmos W=0.1625U L=0.065U
M399_ #234 I1_af_527_6 n__O__f_527_6 Vdd pmos W=0.1625U L=0.065U
M400_ #238 I1_at_528_6 n__O__t_528_6 Vdd pmos W=0.1625U L=0.065U
M401_ #242 I1_af_528_6 n__O__f_528_6 Vdd pmos W=0.1625U L=0.065U
M402_ #246 I1_at_529_6 n__O__t_529_6 Vdd pmos W=0.1625U L=0.065U
M403_ #250 I1_af_529_6 n__O__f_529_6 Vdd pmos W=0.1625U L=0.065U
M404_ #254 I1_at_530_6 n__O__t_530_6 Vdd pmos W=0.1625U L=0.065U
M405_ #258 I1_af_530_6 n__O__f_530_6 Vdd pmos W=0.1625U L=0.065U
M406_ #260 I1_at_531_6 n__O__t_531_6 Vdd pmos W=0.1625U L=0.065U
M407_ #262 I1_af_531_6 n__O__f_531_6 Vdd pmos W=0.1625U L=0.065U
.ends
*---- end of process: Merge<32,t> -----
*
*---- act defproc: ParentRouter<> -----
* raw ports:  reset I.t[0] I.t[1] I.t[2] I.t[3] I.t[4] I.t[5] I.t[6] I.t[7] I.t[8] I.t[9] I.t[10] I.t[11] I.t[12] I.t[13] I.t[14] I.t[15] I.t[16] I.t[17] I.t[18] I.t[19] I.t[20] I.t[21] I.t[22] I.t[23] I.t[24] I.t[25] I.t[26] I.t[27] I.t[28] I.t[29] I.t[30] I.t[31] I.f[0] I.f[1] I.f[2] I.f[3] I.f[4] I.f[5] I.f[6] I.f[7] I.f[8] I.f[9] I.f[10] I.f[11] I.f[12] I.f[13] I.f[14] I.f[15] I.f[16] I.f[17] I.f[18] I.f[19] I.f[20] I.f[21] I.f[22] I.f[23] I.f[24] I.f[25] I.f[26] I.f[27] I.f[28] I.f[29] I.f[30] I.f[31] I.a M.t[0] M.t[1] M.t[2] M.t[3] M.t[4] M.t[5] M.t[6] M.t[7] M.t[8] M.t[9] M.t[10] M.t[11] M.t[12] M.t[13] M.t[14] M.t[15] M.t[16] M.t[17] M.t[18] M.t[19] M.t[20] M.t[21] M.t[22] M.t[23] M.t[24] M.t[25] M.t[26] M.t[27] M.t[28] M.t[29] M.t[30] M.t[31] M.f[0] M.f[1] M.f[2] M.f[3] M.f[4] M.f[5] M.f[6] M.f[7] M.f[8] M.f[9] M.f[10] M.f[11] M.f[12] M.f[13] M.f[14] M.f[15] M.f[16] M.f[17] M.f[18] M.f[19] M.f[20] M.f[21] M.f[22] M.f[23] M.f[24] M.f[25] M.f[26] M.f[27] M.f[28] M.f[29] M.f[30] M.f[31] M.a C0.t[0] C0.t[1] C0.t[2] C0.t[3] C0.t[4] C0.t[5] C0.t[6] C0.t[7] C0.t[8] C0.t[9] C0.t[10] C0.t[11] C0.t[12] C0.t[13] C0.t[14] C0.t[15] C0.t[16] C0.t[17] C0.t[18] C0.t[19] C0.t[20] C0.t[21] C0.t[22] C0.t[23] C0.t[24] C0.t[25] C0.t[26] C0.t[27] C0.t[28] C0.t[29] C0.t[30] C0.t[31] C0.f[0] C0.f[1] C0.f[2] C0.f[3] C0.f[4] C0.f[5] C0.f[6] C0.f[7] C0.f[8] C0.f[9] C0.f[10] C0.f[11] C0.f[12] C0.f[13] C0.f[14] C0.f[15] C0.f[16] C0.f[17] C0.f[18] C0.f[19] C0.f[20] C0.f[21] C0.f[22] C0.f[23] C0.f[24] C0.f[25] C0.f[26] C0.f[27] C0.f[28] C0.f[29] C0.f[30] C0.f[31] C0.a C1.t[0] C1.t[1] C1.t[2] C1.t[3] C1.t[4] C1.t[5] C1.t[6] C1.t[7] C1.t[8] C1.t[9] C1.t[10] C1.t[11] C1.t[12] C1.t[13] C1.t[14] C1.t[15] C1.t[16] C1.t[17] C1.t[18] C1.t[19] C1.t[20] C1.t[21] C1.t[22] C1.t[23] C1.t[24] C1.t[25] C1.t[26] C1.t[27] C1.t[28] C1.t[29] C1.t[30] C1.t[31] C1.f[0] C1.f[1] C1.f[2] C1.f[3] C1.f[4] C1.f[5] C1.f[6] C1.f[7] C1.f[8] C1.f[9] C1.f[10] C1.f[11] C1.f[12] C1.f[13] C1.f[14] C1.f[15] C1.f[16] C1.f[17] C1.f[18] C1.f[19] C1.f[20] C1.f[21] C1.f[22] C1.f[23] C1.f[24] C1.f[25] C1.f[26] C1.f[27] C1.f[28] C1.f[29] C1.f[30] C1.f[31] C1.a C2.t[0] C2.t[1] C2.t[2] C2.t[3] C2.t[4] C2.t[5] C2.t[6] C2.t[7] C2.t[8] C2.t[9] C2.t[10] C2.t[11] C2.t[12] C2.t[13] C2.t[14] C2.t[15] C2.t[16] C2.t[17] C2.t[18] C2.t[19] C2.t[20] C2.t[21] C2.t[22] C2.t[23] C2.t[24] C2.t[25] C2.t[26] C2.t[27] C2.t[28] C2.t[29] C2.t[30] C2.t[31] C2.f[0] C2.f[1] C2.f[2] C2.f[3] C2.f[4] C2.f[5] C2.f[6] C2.f[7] C2.f[8] C2.f[9] C2.f[10] C2.f[11] C2.f[12] C2.f[13] C2.f[14] C2.f[15] C2.f[16] C2.f[17] C2.f[18] C2.f[19] C2.f[20] C2.f[21] C2.f[22] C2.f[23] C2.f[24] C2.f[25] C2.f[26] C2.f[27] C2.f[28] C2.f[29] C2.f[30] C2.f[31] C2.a C3.t[0] C3.t[1] C3.t[2] C3.t[3] C3.t[4] C3.t[5] C3.t[6] C3.t[7] C3.t[8] C3.t[9] C3.t[10] C3.t[11] C3.t[12] C3.t[13] C3.t[14] C3.t[15] C3.t[16] C3.t[17] C3.t[18] C3.t[19] C3.t[20] C3.t[21] C3.t[22] C3.t[23] C3.t[24] C3.t[25] C3.t[26] C3.t[27] C3.t[28] C3.t[29] C3.t[30] C3.t[31] C3.f[0] C3.f[1] C3.f[2] C3.f[3] C3.f[4] C3.f[5] C3.f[6] C3.f[7] C3.f[8] C3.f[9] C3.f[10] C3.f[11] C3.f[12] C3.f[13] C3.f[14] C3.f[15] C3.f[16] C3.f[17] C3.f[18] C3.f[19] C3.f[20] C3.f[21] C3.f[22] C3.f[23] C3.f[24] C3.f[25] C3.f[26] C3.f[27] C3.f[28] C3.f[29] C3.f[30] C3.f[31] C3.a
*
.subckt ParentRouter reset I_at_50_6 I_at_51_6 I_at_52_6 I_at_53_6 I_at_54_6 I_at_55_6 I_at_56_6 I_at_57_6 I_at_58_6 I_at_59_6 I_at_510_6 I_at_511_6 I_at_512_6 I_at_513_6 I_at_514_6 I_at_515_6 I_at_516_6 I_at_517_6 I_at_518_6 I_at_519_6 I_at_520_6 I_at_521_6 I_at_522_6 I_at_523_6 I_at_524_6 I_at_525_6 I_at_526_6 I_at_527_6 I_at_528_6 I_at_529_6 I_at_530_6 I_at_531_6 I_af_50_6 I_af_51_6 I_af_52_6 I_af_53_6 I_af_54_6 I_af_55_6 I_af_56_6 I_af_57_6 I_af_58_6 I_af_59_6 I_af_510_6 I_af_511_6 I_af_512_6 I_af_513_6 I_af_514_6 I_af_515_6 I_af_516_6 I_af_517_6 I_af_518_6 I_af_519_6 I_af_520_6 I_af_521_6 I_af_522_6 I_af_523_6 I_af_524_6 I_af_525_6 I_af_526_6 I_af_527_6 I_af_528_6 I_af_529_6 I_af_530_6 I_af_531_6 I_aa M_at_50_6 M_at_51_6 M_at_52_6 M_at_53_6 M_at_54_6 M_at_55_6 M_at_56_6 M_at_57_6 M_at_58_6 M_at_59_6 M_at_510_6 M_at_511_6 M_at_512_6 M_at_513_6 M_at_514_6 M_at_515_6 M_at_516_6 M_at_517_6 M_at_518_6 M_at_519_6 M_at_520_6 M_at_521_6 M_at_522_6 M_at_523_6 M_at_524_6 M_at_525_6 M_at_526_6 M_at_527_6 M_at_528_6 M_at_529_6 M_at_530_6 M_at_531_6 M_af_50_6 M_af_51_6 M_af_52_6 M_af_53_6 M_af_54_6 M_af_55_6 M_af_56_6 M_af_57_6 M_af_58_6 M_af_59_6 M_af_510_6 M_af_511_6 M_af_512_6 M_af_513_6 M_af_514_6 M_af_515_6 M_af_516_6 M_af_517_6 M_af_518_6 M_af_519_6 M_af_520_6 M_af_521_6 M_af_522_6 M_af_523_6 M_af_524_6 M_af_525_6 M_af_526_6 M_af_527_6 M_af_528_6 M_af_529_6 M_af_530_6 M_af_531_6 M_aa C0_at_50_6 C0_at_51_6 C0_at_52_6 C0_at_53_6 C0_at_54_6 C0_at_55_6 C0_at_56_6 C0_at_57_6 C0_at_58_6 C0_at_59_6 C0_at_510_6 C0_at_511_6 C0_at_512_6 C0_at_513_6 C0_at_514_6 C0_at_515_6 C0_at_516_6 C0_at_517_6 C0_at_518_6 C0_at_519_6 C0_at_520_6 C0_at_521_6 C0_at_522_6 C0_at_523_6 C0_at_524_6 C0_at_525_6 C0_at_526_6 C0_at_527_6 C0_at_528_6 C0_at_529_6 C0_at_530_6 C0_at_531_6 C0_af_50_6 C0_af_51_6 C0_af_52_6 C0_af_53_6 C0_af_54_6 C0_af_55_6 C0_af_56_6 C0_af_57_6 C0_af_58_6 C0_af_59_6 C0_af_510_6 C0_af_511_6 C0_af_512_6 C0_af_513_6 C0_af_514_6 C0_af_515_6 C0_af_516_6 C0_af_517_6 C0_af_518_6 C0_af_519_6 C0_af_520_6 C0_af_521_6 C0_af_522_6 C0_af_523_6 C0_af_524_6 C0_af_525_6 C0_af_526_6 C0_af_527_6 C0_af_528_6 C0_af_529_6 C0_af_530_6 C0_af_531_6 C0_aa C1_at_50_6 C1_at_51_6 C1_at_52_6 C1_at_53_6 C1_at_54_6 C1_at_55_6 C1_at_56_6 C1_at_57_6 C1_at_58_6 C1_at_59_6 C1_at_510_6 C1_at_511_6 C1_at_512_6 C1_at_513_6 C1_at_514_6 C1_at_515_6 C1_at_516_6 C1_at_517_6 C1_at_518_6 C1_at_519_6 C1_at_520_6 C1_at_521_6 C1_at_522_6 C1_at_523_6 C1_at_524_6 C1_at_525_6 C1_at_526_6 C1_at_527_6 C1_at_528_6 C1_at_529_6 C1_at_530_6 C1_at_531_6 C1_af_50_6 C1_af_51_6 C1_af_52_6 C1_af_53_6 C1_af_54_6 C1_af_55_6 C1_af_56_6 C1_af_57_6 C1_af_58_6 C1_af_59_6 C1_af_510_6 C1_af_511_6 C1_af_512_6 C1_af_513_6 C1_af_514_6 C1_af_515_6 C1_af_516_6 C1_af_517_6 C1_af_518_6 C1_af_519_6 C1_af_520_6 C1_af_521_6 C1_af_522_6 C1_af_523_6 C1_af_524_6 C1_af_525_6 C1_af_526_6 C1_af_527_6 C1_af_528_6 C1_af_529_6 C1_af_530_6 C1_af_531_6 C1_aa C2_at_50_6 C2_at_51_6 C2_at_52_6 C2_at_53_6 C2_at_54_6 C2_at_55_6 C2_at_56_6 C2_at_57_6 C2_at_58_6 C2_at_59_6 C2_at_510_6 C2_at_511_6 C2_at_512_6 C2_at_513_6 C2_at_514_6 C2_at_515_6 C2_at_516_6 C2_at_517_6 C2_at_518_6 C2_at_519_6 C2_at_520_6 C2_at_521_6 C2_at_522_6 C2_at_523_6 C2_at_524_6 C2_at_525_6 C2_at_526_6 C2_at_527_6 C2_at_528_6 C2_at_529_6 C2_at_530_6 C2_at_531_6 C2_af_50_6 C2_af_51_6 C2_af_52_6 C2_af_53_6 C2_af_54_6 C2_af_55_6 C2_af_56_6 C2_af_57_6 C2_af_58_6 C2_af_59_6 C2_af_510_6 C2_af_511_6 C2_af_512_6 C2_af_513_6 C2_af_514_6 C2_af_515_6 C2_af_516_6 C2_af_517_6 C2_af_518_6 C2_af_519_6 C2_af_520_6 C2_af_521_6 C2_af_522_6 C2_af_523_6 C2_af_524_6 C2_af_525_6 C2_af_526_6 C2_af_527_6 C2_af_528_6 C2_af_529_6 C2_af_530_6 C2_af_531_6 C2_aa C3_at_50_6 C3_at_51_6 C3_at_52_6 C3_at_53_6 C3_at_54_6 C3_at_55_6 C3_at_56_6 C3_at_57_6 C3_at_58_6 C3_at_59_6 C3_at_510_6 C3_at_511_6 C3_at_512_6 C3_at_513_6 C3_at_514_6 C3_at_515_6 C3_at_516_6 C3_at_517_6 C3_at_518_6 C3_at_519_6 C3_at_520_6 C3_at_521_6 C3_at_522_6 C3_at_523_6 C3_at_524_6 C3_at_525_6 C3_at_526_6 C3_at_527_6 C3_at_528_6 C3_at_529_6 C3_at_530_6 C3_at_531_6 C3_af_50_6 C3_af_51_6 C3_af_52_6 C3_af_53_6 C3_af_54_6 C3_af_55_6 C3_af_56_6 C3_af_57_6 C3_af_58_6 C3_af_59_6 C3_af_510_6 C3_af_511_6 C3_af_512_6 C3_af_513_6 C3_af_514_6 C3_af_515_6 C3_af_516_6 C3_af_517_6 C3_af_518_6 C3_af_519_6 C3_af_520_6 C3_af_521_6 C3_af_522_6 C3_af_523_6 C3_af_524_6 C3_af_525_6 C3_af_526_6 C3_af_527_6 C3_af_528_6 C3_af_529_6 C3_af_530_6 C3_af_531_6 C3_aa
*.PININFO reset:I I_at_50_6:I I_at_51_6:I I_at_52_6:I I_at_53_6:I I_at_54_6:I I_at_55_6:I I_at_56_6:I I_at_57_6:I I_at_58_6:I I_at_59_6:I I_at_510_6:I I_at_511_6:I I_at_512_6:I I_at_513_6:I I_at_514_6:I I_at_515_6:I I_at_516_6:I I_at_517_6:I I_at_518_6:I I_at_519_6:I I_at_520_6:I I_at_521_6:I I_at_522_6:I I_at_523_6:I I_at_524_6:I I_at_525_6:I I_at_526_6:I I_at_527_6:I I_at_528_6:I I_at_529_6:I I_at_530_6:I I_at_531_6:I I_af_50_6:I I_af_51_6:I I_af_52_6:I I_af_53_6:I I_af_54_6:I I_af_55_6:I I_af_56_6:I I_af_57_6:I I_af_58_6:I I_af_59_6:I I_af_510_6:I I_af_511_6:I I_af_512_6:I I_af_513_6:I I_af_514_6:I I_af_515_6:I I_af_516_6:I I_af_517_6:I I_af_518_6:I I_af_519_6:I I_af_520_6:I I_af_521_6:I I_af_522_6:I I_af_523_6:I I_af_524_6:I I_af_525_6:I I_af_526_6:I I_af_527_6:I I_af_528_6:I I_af_529_6:I I_af_530_6:I I_af_531_6:I I_aa:O M_at_50_6:O M_at_51_6:O M_at_52_6:O M_at_53_6:O M_at_54_6:O M_at_55_6:O M_at_56_6:O M_at_57_6:O M_at_58_6:O M_at_59_6:O M_at_510_6:O M_at_511_6:O M_at_512_6:O M_at_513_6:O M_at_514_6:O M_at_515_6:O M_at_516_6:O M_at_517_6:O M_at_518_6:O M_at_519_6:O M_at_520_6:O M_at_521_6:O M_at_522_6:O M_at_523_6:O M_at_524_6:O M_at_525_6:O M_at_526_6:O M_at_527_6:O M_at_528_6:O M_at_529_6:O M_at_530_6:O M_at_531_6:O M_af_50_6:O M_af_51_6:O M_af_52_6:O M_af_53_6:O M_af_54_6:O M_af_55_6:O M_af_56_6:O M_af_57_6:O M_af_58_6:O M_af_59_6:O M_af_510_6:O M_af_511_6:O M_af_512_6:O M_af_513_6:O M_af_514_6:O M_af_515_6:O M_af_516_6:O M_af_517_6:O M_af_518_6:O M_af_519_6:O M_af_520_6:O M_af_521_6:O M_af_522_6:O M_af_523_6:O M_af_524_6:O M_af_525_6:O M_af_526_6:O M_af_527_6:O M_af_528_6:O M_af_529_6:O M_af_530_6:O M_af_531_6:O M_aa:I C0_at_50_6:O C0_at_51_6:O C0_at_52_6:O C0_at_53_6:O C0_at_54_6:O C0_at_55_6:O C0_at_56_6:O C0_at_57_6:O C0_at_58_6:O C0_at_59_6:O C0_at_510_6:O C0_at_511_6:O C0_at_512_6:O C0_at_513_6:O C0_at_514_6:O C0_at_515_6:O C0_at_516_6:O C0_at_517_6:O C0_at_518_6:O C0_at_519_6:O C0_at_520_6:O C0_at_521_6:O C0_at_522_6:O C0_at_523_6:O C0_at_524_6:O C0_at_525_6:O C0_at_526_6:O C0_at_527_6:O C0_at_528_6:O C0_at_529_6:O C0_at_530_6:O C0_at_531_6:O C0_af_50_6:O C0_af_51_6:O C0_af_52_6:O C0_af_53_6:O C0_af_54_6:O C0_af_55_6:O C0_af_56_6:O C0_af_57_6:O C0_af_58_6:O C0_af_59_6:O C0_af_510_6:O C0_af_511_6:O C0_af_512_6:O C0_af_513_6:O C0_af_514_6:O C0_af_515_6:O C0_af_516_6:O C0_af_517_6:O C0_af_518_6:O C0_af_519_6:O C0_af_520_6:O C0_af_521_6:O C0_af_522_6:O C0_af_523_6:O C0_af_524_6:O C0_af_525_6:O C0_af_526_6:O C0_af_527_6:O C0_af_528_6:O C0_af_529_6:O C0_af_530_6:O C0_af_531_6:O C0_aa:I C1_at_50_6:O C1_at_51_6:O C1_at_52_6:O C1_at_53_6:O C1_at_54_6:O C1_at_55_6:O C1_at_56_6:O C1_at_57_6:O C1_at_58_6:O C1_at_59_6:O C1_at_510_6:O C1_at_511_6:O C1_at_512_6:O C1_at_513_6:O C1_at_514_6:O C1_at_515_6:O C1_at_516_6:O C1_at_517_6:O C1_at_518_6:O C1_at_519_6:O C1_at_520_6:O C1_at_521_6:O C1_at_522_6:O C1_at_523_6:O C1_at_524_6:O C1_at_525_6:O C1_at_526_6:O C1_at_527_6:O C1_at_528_6:O C1_at_529_6:O C1_at_530_6:O C1_at_531_6:O C1_af_50_6:O C1_af_51_6:O C1_af_52_6:O C1_af_53_6:O C1_af_54_6:O C1_af_55_6:O C1_af_56_6:O C1_af_57_6:O C1_af_58_6:O C1_af_59_6:O C1_af_510_6:O C1_af_511_6:O C1_af_512_6:O C1_af_513_6:O C1_af_514_6:O C1_af_515_6:O C1_af_516_6:O C1_af_517_6:O C1_af_518_6:O C1_af_519_6:O C1_af_520_6:O C1_af_521_6:O C1_af_522_6:O C1_af_523_6:O C1_af_524_6:O C1_af_525_6:O C1_af_526_6:O C1_af_527_6:O C1_af_528_6:O C1_af_529_6:O C1_af_530_6:O C1_af_531_6:O C1_aa:I C2_at_50_6:O C2_at_51_6:O C2_at_52_6:O C2_at_53_6:O C2_at_54_6:O C2_at_55_6:O C2_at_56_6:O C2_at_57_6:O C2_at_58_6:O C2_at_59_6:O C2_at_510_6:O C2_at_511_6:O C2_at_512_6:O C2_at_513_6:O C2_at_514_6:O C2_at_515_6:O C2_at_516_6:O C2_at_517_6:O C2_at_518_6:O C2_at_519_6:O C2_at_520_6:O C2_at_521_6:O C2_at_522_6:O C2_at_523_6:O C2_at_524_6:O C2_at_525_6:O C2_at_526_6:O C2_at_527_6:O C2_at_528_6:O C2_at_529_6:O C2_at_530_6:O C2_at_531_6:O C2_af_50_6:O C2_af_51_6:O C2_af_52_6:O C2_af_53_6:O C2_af_54_6:O C2_af_55_6:O C2_af_56_6:O C2_af_57_6:O C2_af_58_6:O C2_af_59_6:O C2_af_510_6:O C2_af_511_6:O C2_af_512_6:O C2_af_513_6:O C2_af_514_6:O C2_af_515_6:O C2_af_516_6:O C2_af_517_6:O C2_af_518_6:O C2_af_519_6:O C2_af_520_6:O C2_af_521_6:O C2_af_522_6:O C2_af_523_6:O C2_af_524_6:O C2_af_525_6:O C2_af_526_6:O C2_af_527_6:O C2_af_528_6:O C2_af_529_6:O C2_af_530_6:O C2_af_531_6:O C2_aa:I C3_at_50_6:O C3_at_51_6:O C3_at_52_6:O C3_at_53_6:O C3_at_54_6:O C3_at_55_6:O C3_at_56_6:O C3_at_57_6:O C3_at_58_6:O C3_at_59_6:O C3_at_510_6:O C3_at_511_6:O C3_at_512_6:O C3_at_513_6:O C3_at_514_6:O C3_at_515_6:O C3_at_516_6:O C3_at_517_6:O C3_at_518_6:O C3_at_519_6:O C3_at_520_6:O C3_at_521_6:O C3_at_522_6:O C3_at_523_6:O C3_at_524_6:O C3_at_525_6:O C3_at_526_6:O C3_at_527_6:O C3_at_528_6:O C3_at_529_6:O C3_at_530_6:O C3_at_531_6:O C3_af_50_6:O C3_af_51_6:O C3_af_52_6:O C3_af_53_6:O C3_af_54_6:O C3_af_55_6:O C3_af_56_6:O C3_af_57_6:O C3_af_58_6:O C3_af_59_6:O C3_af_510_6:O C3_af_511_6:O C3_af_512_6:O C3_af_513_6:O C3_af_514_6:O C3_af_515_6:O C3_af_516_6:O C3_af_517_6:O C3_af_518_6:O C3_af_519_6:O C3_af_520_6:O C3_af_521_6:O C3_af_522_6:O C3_af_523_6:O C3_af_524_6:O C3_af_525_6:O C3_af_526_6:O C3_af_527_6:O C3_af_528_6:O C3_af_529_6:O C3_af_530_6:O C3_af_531_6:O C3_aa:I
*.POWER VDD Vdd
*.POWER GND GND
*.POWER NSUB GND
*.POWER PSUB Vdd
xCS reset CS_aI_at_50_6 CS_aI_at_51_6 CS_aI_at_52_6 CS_aI_at_53_6 CS_aI_at_54_6 CS_aI_at_55_6 CS_aI_at_56_6 CS_aI_at_57_6 CS_aI_at_58_6 CS_aI_at_59_6 CS_aI_at_510_6 CS_aI_at_511_6 CS_aI_at_512_6 CS_aI_at_513_6 CS_aI_at_514_6 CS_aI_at_515_6 CS_aI_at_516_6 CS_aI_at_517_6 CS_aI_at_518_6 CS_aI_at_519_6 CS_aI_at_520_6 CS_aI_at_521_6 CS_aI_at_522_6 CS_aI_at_523_6 CS_aI_at_524_6 CS_aI_at_525_6 CS_aI_at_526_6 CS_aI_at_527_6 CS_aI_at_528_6 CS_aI_at_529_6 CS_aI_at_530_6 CS_aI_at_531_6 CS_aI_af_50_6 CS_aI_af_51_6 CS_aI_af_52_6 CS_aI_af_53_6 CS_aI_af_54_6 CS_aI_af_55_6 CS_aI_af_56_6 CS_aI_af_57_6 CS_aI_af_58_6 CS_aI_af_59_6 CS_aI_af_510_6 CS_aI_af_511_6 CS_aI_af_512_6 CS_aI_af_513_6 CS_aI_af_514_6 CS_aI_af_515_6 CS_aI_af_516_6 CS_aI_af_517_6 CS_aI_af_518_6 CS_aI_af_519_6 CS_aI_af_520_6 CS_aI_af_521_6 CS_aI_af_522_6 CS_aI_af_523_6 CS_aI_af_524_6 CS_aI_af_525_6 CS_aI_af_526_6 CS_aI_af_527_6 CS_aI_af_528_6 CS_aI_af_529_6 CS_aI_af_530_6 CS_aI_af_531_6 CS_aI_aa C0_at_50_6 C0_at_51_6 C0_at_52_6 C0_at_53_6 C0_at_54_6 C0_at_55_6 C0_at_56_6 C0_at_57_6 C0_at_58_6 C0_at_59_6 C0_at_510_6 C0_at_511_6 C0_at_512_6 C0_at_513_6 C0_at_514_6 C0_at_515_6 C0_at_516_6 C0_at_517_6 C0_at_518_6 C0_at_519_6 C0_at_520_6 C0_at_521_6 C0_at_522_6 C0_at_523_6 C0_at_524_6 C0_at_525_6 C0_at_526_6 C0_at_527_6 C0_at_528_6 C0_at_529_6 C0_at_530_6 C0_at_531_6 C0_af_50_6 C0_af_51_6 C0_af_52_6 C0_af_53_6 C0_af_54_6 C0_af_55_6 C0_af_56_6 C0_af_57_6 C0_af_58_6 C0_af_59_6 C0_af_510_6 C0_af_511_6 C0_af_512_6 C0_af_513_6 C0_af_514_6 C0_af_515_6 C0_af_516_6 C0_af_517_6 C0_af_518_6 C0_af_519_6 C0_af_520_6 C0_af_521_6 C0_af_522_6 C0_af_523_6 C0_af_524_6 C0_af_525_6 C0_af_526_6 C0_af_527_6 C0_af_528_6 C0_af_529_6 C0_af_530_6 C0_af_531_6 C0_aa C1_at_50_6 C1_at_51_6 C1_at_52_6 C1_at_53_6 C1_at_54_6 C1_at_55_6 C1_at_56_6 C1_at_57_6 C1_at_58_6 C1_at_59_6 C1_at_510_6 C1_at_511_6 C1_at_512_6 C1_at_513_6 C1_at_514_6 C1_at_515_6 C1_at_516_6 C1_at_517_6 C1_at_518_6 C1_at_519_6 C1_at_520_6 C1_at_521_6 C1_at_522_6 C1_at_523_6 C1_at_524_6 C1_at_525_6 C1_at_526_6 C1_at_527_6 C1_at_528_6 C1_at_529_6 C1_at_530_6 C1_at_531_6 C1_af_50_6 C1_af_51_6 C1_af_52_6 C1_af_53_6 C1_af_54_6 C1_af_55_6 C1_af_56_6 C1_af_57_6 C1_af_58_6 C1_af_59_6 C1_af_510_6 C1_af_511_6 C1_af_512_6 C1_af_513_6 C1_af_514_6 C1_af_515_6 C1_af_516_6 C1_af_517_6 C1_af_518_6 C1_af_519_6 C1_af_520_6 C1_af_521_6 C1_af_522_6 C1_af_523_6 C1_af_524_6 C1_af_525_6 C1_af_526_6 C1_af_527_6 C1_af_528_6 C1_af_529_6 C1_af_530_6 C1_af_531_6 C1_aa C2_at_50_6 C2_at_51_6 C2_at_52_6 C2_at_53_6 C2_at_54_6 C2_at_55_6 C2_at_56_6 C2_at_57_6 C2_at_58_6 C2_at_59_6 C2_at_510_6 C2_at_511_6 C2_at_512_6 C2_at_513_6 C2_at_514_6 C2_at_515_6 C2_at_516_6 C2_at_517_6 C2_at_518_6 C2_at_519_6 C2_at_520_6 C2_at_521_6 C2_at_522_6 C2_at_523_6 C2_at_524_6 C2_at_525_6 C2_at_526_6 C2_at_527_6 C2_at_528_6 C2_at_529_6 C2_at_530_6 C2_at_531_6 C2_af_50_6 C2_af_51_6 C2_af_52_6 C2_af_53_6 C2_af_54_6 C2_af_55_6 C2_af_56_6 C2_af_57_6 C2_af_58_6 C2_af_59_6 C2_af_510_6 C2_af_511_6 C2_af_512_6 C2_af_513_6 C2_af_514_6 C2_af_515_6 C2_af_516_6 C2_af_517_6 C2_af_518_6 C2_af_519_6 C2_af_520_6 C2_af_521_6 C2_af_522_6 C2_af_523_6 C2_af_524_6 C2_af_525_6 C2_af_526_6 C2_af_527_6 C2_af_528_6 C2_af_529_6 C2_af_530_6 C2_af_531_6 C2_aa C3_at_50_6 C3_at_51_6 C3_at_52_6 C3_at_53_6 C3_at_54_6 C3_at_55_6 C3_at_56_6 C3_at_57_6 C3_at_58_6 C3_at_59_6 C3_at_510_6 C3_at_511_6 C3_at_512_6 C3_at_513_6 C3_at_514_6 C3_at_515_6 C3_at_516_6 C3_at_517_6 C3_at_518_6 C3_at_519_6 C3_at_520_6 C3_at_521_6 C3_at_522_6 C3_at_523_6 C3_at_524_6 C3_at_525_6 C3_at_526_6 C3_at_527_6 C3_at_528_6 C3_at_529_6 C3_at_530_6 C3_at_531_6 C3_af_50_6 C3_af_51_6 C3_af_52_6 C3_af_53_6 C3_af_54_6 C3_af_55_6 C3_af_56_6 C3_af_57_6 C3_af_58_6 C3_af_59_6 C3_af_510_6 C3_af_511_6 C3_af_512_6 C3_af_513_6 C3_af_514_6 C3_af_515_6 C3_af_516_6 C3_af_517_6 C3_af_518_6 C3_af_519_6 C3_af_520_6 C3_af_521_6 C3_af_522_6 C3_af_523_6 C3_af_524_6 C3_af_525_6 C3_af_526_6 C3_af_527_6 C3_af_528_6 C3_af_529_6 C3_af_530_6 C3_af_531_6 C3_aa ChildSel
xMUS reset I_at_50_6 I_at_51_6 I_at_52_6 I_at_53_6 I_at_54_6 I_at_55_6 I_at_56_6 I_at_57_6 I_at_58_6 I_at_59_6 I_at_510_6 I_at_511_6 I_at_512_6 I_at_513_6 I_at_514_6 I_at_515_6 I_at_516_6 I_at_517_6 I_at_518_6 I_at_519_6 I_at_520_6 I_at_521_6 I_at_522_6 I_at_523_6 I_at_524_6 I_at_525_6 I_at_526_6 I_at_527_6 I_at_528_6 I_at_529_6 I_at_530_6 I_at_531_6 I_af_50_6 I_af_51_6 I_af_52_6 I_af_53_6 I_af_54_6 I_af_55_6 I_af_56_6 I_af_57_6 I_af_58_6 I_af_59_6 I_af_510_6 I_af_511_6 I_af_512_6 I_af_513_6 I_af_514_6 I_af_515_6 I_af_516_6 I_af_517_6 I_af_518_6 I_af_519_6 I_af_520_6 I_af_521_6 I_af_522_6 I_af_523_6 I_af_524_6 I_af_525_6 I_af_526_6 I_af_527_6 I_af_528_6 I_af_529_6 I_af_530_6 I_af_531_6 I_aa M2_aI0_at_50_6 M2_aI0_at_51_6 M2_aI0_at_52_6 M2_aI0_at_53_6 M2_aI0_at_54_6 M2_aI0_at_55_6 M2_aI0_at_56_6 M2_aI0_at_57_6 M2_aI0_at_58_6 M2_aI0_at_59_6 M2_aI0_at_510_6 M2_aI0_at_511_6 M2_aI0_at_512_6 M2_aI0_at_513_6 M2_aI0_at_514_6 M2_aI0_at_515_6 M2_aI0_at_516_6 M2_aI0_at_517_6 M2_aI0_at_518_6 M2_aI0_at_519_6 M2_aI0_at_520_6 M2_aI0_at_521_6 M2_aI0_at_522_6 M2_aI0_at_523_6 M2_aI0_at_524_6 M2_aI0_at_525_6 M2_aI0_at_526_6 M2_aI0_at_527_6 M2_aI0_at_528_6 M2_aI0_at_529_6 M2_aI0_at_530_6 M2_aI0_at_531_6 M2_aI0_af_50_6 M2_aI0_af_51_6 M2_aI0_af_52_6 M2_aI0_af_53_6 M2_aI0_af_54_6 M2_aI0_af_55_6 M2_aI0_af_56_6 M2_aI0_af_57_6 M2_aI0_af_58_6 M2_aI0_af_59_6 M2_aI0_af_510_6 M2_aI0_af_511_6 M2_aI0_af_512_6 M2_aI0_af_513_6 M2_aI0_af_514_6 M2_aI0_af_515_6 M2_aI0_af_516_6 M2_aI0_af_517_6 M2_aI0_af_518_6 M2_aI0_af_519_6 M2_aI0_af_520_6 M2_aI0_af_521_6 M2_aI0_af_522_6 M2_aI0_af_523_6 M2_aI0_af_524_6 M2_aI0_af_525_6 M2_aI0_af_526_6 M2_aI0_af_527_6 M2_aI0_af_528_6 M2_aI0_af_529_6 M2_aI0_af_530_6 M2_aI0_af_531_6 M2_aI0_aa SS_aI_at_50_6 SS_aI_at_51_6 SS_aI_at_52_6 SS_aI_at_53_6 SS_aI_at_54_6 SS_aI_at_55_6 SS_aI_at_56_6 SS_aI_at_57_6 SS_aI_at_58_6 SS_aI_at_59_6 SS_aI_at_510_6 SS_aI_at_511_6 SS_aI_at_512_6 SS_aI_at_513_6 SS_aI_at_514_6 SS_aI_at_515_6 SS_aI_at_516_6 SS_aI_at_517_6 SS_aI_at_518_6 SS_aI_at_519_6 SS_aI_at_520_6 SS_aI_at_521_6 SS_aI_at_522_6 SS_aI_at_523_6 SS_aI_at_524_6 SS_aI_at_525_6 SS_aI_at_526_6 SS_aI_at_527_6 SS_aI_at_528_6 SS_aI_at_529_6 SS_aI_at_530_6 SS_aI_at_531_6 SS_aI_af_50_6 SS_aI_af_51_6 SS_aI_af_52_6 SS_aI_af_53_6 SS_aI_af_54_6 SS_aI_af_55_6 SS_aI_af_56_6 SS_aI_af_57_6 SS_aI_af_58_6 SS_aI_af_59_6 SS_aI_af_510_6 SS_aI_af_511_6 SS_aI_af_512_6 SS_aI_af_513_6 SS_aI_af_514_6 SS_aI_af_515_6 SS_aI_af_516_6 SS_aI_af_517_6 SS_aI_af_518_6 SS_aI_af_519_6 SS_aI_af_520_6 SS_aI_af_521_6 SS_aI_af_522_6 SS_aI_af_523_6 SS_aI_af_524_6 SS_aI_af_525_6 SS_aI_af_526_6 SS_aI_af_527_6 SS_aI_af_528_6 SS_aI_af_529_6 SS_aI_af_530_6 SS_aI_af_531_6 SS_aI_aa MltcSel
xSS reset SS_aI_at_50_6 SS_aI_at_51_6 SS_aI_at_52_6 SS_aI_at_53_6 SS_aI_at_54_6 SS_aI_at_55_6 SS_aI_at_56_6 SS_aI_at_57_6 SS_aI_at_58_6 SS_aI_at_59_6 SS_aI_at_510_6 SS_aI_at_511_6 SS_aI_at_512_6 SS_aI_at_513_6 SS_aI_at_514_6 SS_aI_at_515_6 SS_aI_at_516_6 SS_aI_at_517_6 SS_aI_at_518_6 SS_aI_at_519_6 SS_aI_at_520_6 SS_aI_at_521_6 SS_aI_at_522_6 SS_aI_at_523_6 SS_aI_at_524_6 SS_aI_at_525_6 SS_aI_at_526_6 SS_aI_at_527_6 SS_aI_at_528_6 SS_aI_at_529_6 SS_aI_at_530_6 SS_aI_at_531_6 SS_aI_af_50_6 SS_aI_af_51_6 SS_aI_af_52_6 SS_aI_af_53_6 SS_aI_af_54_6 SS_aI_af_55_6 SS_aI_af_56_6 SS_aI_af_57_6 SS_aI_af_58_6 SS_aI_af_59_6 SS_aI_af_510_6 SS_aI_af_511_6 SS_aI_af_512_6 SS_aI_af_513_6 SS_aI_af_514_6 SS_aI_af_515_6 SS_aI_af_516_6 SS_aI_af_517_6 SS_aI_af_518_6 SS_aI_af_519_6 SS_aI_af_520_6 SS_aI_af_521_6 SS_aI_af_522_6 SS_aI_af_523_6 SS_aI_af_524_6 SS_aI_af_525_6 SS_aI_af_526_6 SS_aI_af_527_6 SS_aI_af_528_6 SS_aI_af_529_6 SS_aI_af_530_6 SS_aI_af_531_6 SS_aI_aa M2_aI1_at_50_6 M2_aI1_at_51_6 M2_aI1_at_52_6 M2_aI1_at_53_6 M2_aI1_at_54_6 M2_aI1_at_55_6 M2_aI1_at_56_6 M2_aI1_at_57_6 M2_aI1_at_58_6 M2_aI1_at_59_6 M2_aI1_at_510_6 M2_aI1_at_511_6 M2_aI1_at_512_6 M2_aI1_at_513_6 M2_aI1_at_514_6 M2_aI1_at_515_6 M2_aI1_at_516_6 M2_aI1_at_517_6 M2_aI1_at_518_6 M2_aI1_at_519_6 M2_aI1_at_520_6 M2_aI1_at_521_6 M2_aI1_at_522_6 M2_aI1_at_523_6 M2_aI1_at_524_6 M2_aI1_at_525_6 M2_aI1_at_526_6 M2_aI1_at_527_6 M2_aI1_at_528_6 M2_aI1_at_529_6 M2_aI1_at_530_6 M2_aI1_at_531_6 M2_aI1_af_50_6 M2_aI1_af_51_6 M2_aI1_af_52_6 M2_aI1_af_53_6 M2_aI1_af_54_6 M2_aI1_af_55_6 M2_aI1_af_56_6 M2_aI1_af_57_6 M2_aI1_af_58_6 M2_aI1_af_59_6 M2_aI1_af_510_6 M2_aI1_af_511_6 M2_aI1_af_512_6 M2_aI1_af_513_6 M2_aI1_af_514_6 M2_aI1_af_515_6 M2_aI1_af_516_6 M2_aI1_af_517_6 M2_aI1_af_518_6 M2_aI1_af_519_6 M2_aI1_af_520_6 M2_aI1_af_521_6 M2_aI1_af_522_6 M2_aI1_af_523_6 M2_aI1_af_524_6 M2_aI1_af_525_6 M2_aI1_af_526_6 M2_aI1_af_527_6 M2_aI1_af_528_6 M2_aI1_af_529_6 M2_aI1_af_530_6 M2_aI1_af_531_6 M2_aI1_aa CS_aI_at_50_6 CS_aI_at_51_6 CS_aI_at_52_6 CS_aI_at_53_6 CS_aI_at_54_6 CS_aI_at_55_6 CS_aI_at_56_6 CS_aI_at_57_6 CS_aI_at_58_6 CS_aI_at_59_6 CS_aI_at_510_6 CS_aI_at_511_6 CS_aI_at_512_6 CS_aI_at_513_6 CS_aI_at_514_6 CS_aI_at_515_6 CS_aI_at_516_6 CS_aI_at_517_6 CS_aI_at_518_6 CS_aI_at_519_6 CS_aI_at_520_6 CS_aI_at_521_6 CS_aI_at_522_6 CS_aI_at_523_6 CS_aI_at_524_6 CS_aI_at_525_6 CS_aI_at_526_6 CS_aI_at_527_6 CS_aI_at_528_6 CS_aI_at_529_6 CS_aI_at_530_6 CS_aI_at_531_6 CS_aI_af_50_6 CS_aI_af_51_6 CS_aI_af_52_6 CS_aI_af_53_6 CS_aI_af_54_6 CS_aI_af_55_6 CS_aI_af_56_6 CS_aI_af_57_6 CS_aI_af_58_6 CS_aI_af_59_6 CS_aI_af_510_6 CS_aI_af_511_6 CS_aI_af_512_6 CS_aI_af_513_6 CS_aI_af_514_6 CS_aI_af_515_6 CS_aI_af_516_6 CS_aI_af_517_6 CS_aI_af_518_6 CS_aI_af_519_6 CS_aI_af_520_6 CS_aI_af_521_6 CS_aI_af_522_6 CS_aI_af_523_6 CS_aI_af_524_6 CS_aI_af_525_6 CS_aI_af_526_6 CS_aI_af_527_6 CS_aI_af_528_6 CS_aI_af_529_6 CS_aI_af_530_6 CS_aI_af_531_6 CS_aI_aa StopcodeSel
xM2 M2_aI0_at_50_6 M2_aI0_at_51_6 M2_aI0_at_52_6 M2_aI0_at_53_6 M2_aI0_at_54_6 M2_aI0_at_55_6 M2_aI0_at_56_6 M2_aI0_at_57_6 M2_aI0_at_58_6 M2_aI0_at_59_6 M2_aI0_at_510_6 M2_aI0_at_511_6 M2_aI0_at_512_6 M2_aI0_at_513_6 M2_aI0_at_514_6 M2_aI0_at_515_6 M2_aI0_at_516_6 M2_aI0_at_517_6 M2_aI0_at_518_6 M2_aI0_at_519_6 M2_aI0_at_520_6 M2_aI0_at_521_6 M2_aI0_at_522_6 M2_aI0_at_523_6 M2_aI0_at_524_6 M2_aI0_at_525_6 M2_aI0_at_526_6 M2_aI0_at_527_6 M2_aI0_at_528_6 M2_aI0_at_529_6 M2_aI0_at_530_6 M2_aI0_at_531_6 M2_aI0_af_50_6 M2_aI0_af_51_6 M2_aI0_af_52_6 M2_aI0_af_53_6 M2_aI0_af_54_6 M2_aI0_af_55_6 M2_aI0_af_56_6 M2_aI0_af_57_6 M2_aI0_af_58_6 M2_aI0_af_59_6 M2_aI0_af_510_6 M2_aI0_af_511_6 M2_aI0_af_512_6 M2_aI0_af_513_6 M2_aI0_af_514_6 M2_aI0_af_515_6 M2_aI0_af_516_6 M2_aI0_af_517_6 M2_aI0_af_518_6 M2_aI0_af_519_6 M2_aI0_af_520_6 M2_aI0_af_521_6 M2_aI0_af_522_6 M2_aI0_af_523_6 M2_aI0_af_524_6 M2_aI0_af_525_6 M2_aI0_af_526_6 M2_aI0_af_527_6 M2_aI0_af_528_6 M2_aI0_af_529_6 M2_aI0_af_530_6 M2_aI0_af_531_6 M2_aI0_aa M2_aI1_at_50_6 M2_aI1_at_51_6 M2_aI1_at_52_6 M2_aI1_at_53_6 M2_aI1_at_54_6 M2_aI1_at_55_6 M2_aI1_at_56_6 M2_aI1_at_57_6 M2_aI1_at_58_6 M2_aI1_at_59_6 M2_aI1_at_510_6 M2_aI1_at_511_6 M2_aI1_at_512_6 M2_aI1_at_513_6 M2_aI1_at_514_6 M2_aI1_at_515_6 M2_aI1_at_516_6 M2_aI1_at_517_6 M2_aI1_at_518_6 M2_aI1_at_519_6 M2_aI1_at_520_6 M2_aI1_at_521_6 M2_aI1_at_522_6 M2_aI1_at_523_6 M2_aI1_at_524_6 M2_aI1_at_525_6 M2_aI1_at_526_6 M2_aI1_at_527_6 M2_aI1_at_528_6 M2_aI1_at_529_6 M2_aI1_at_530_6 M2_aI1_at_531_6 M2_aI1_af_50_6 M2_aI1_af_51_6 M2_aI1_af_52_6 M2_aI1_af_53_6 M2_aI1_af_54_6 M2_aI1_af_55_6 M2_aI1_af_56_6 M2_aI1_af_57_6 M2_aI1_af_58_6 M2_aI1_af_59_6 M2_aI1_af_510_6 M2_aI1_af_511_6 M2_aI1_af_512_6 M2_aI1_af_513_6 M2_aI1_af_514_6 M2_aI1_af_515_6 M2_aI1_af_516_6 M2_aI1_af_517_6 M2_aI1_af_518_6 M2_aI1_af_519_6 M2_aI1_af_520_6 M2_aI1_af_521_6 M2_aI1_af_522_6 M2_aI1_af_523_6 M2_aI1_af_524_6 M2_aI1_af_525_6 M2_aI1_af_526_6 M2_aI1_af_527_6 M2_aI1_af_528_6 M2_aI1_af_529_6 M2_aI1_af_530_6 M2_aI1_af_531_6 M2_aI1_aa M_at_50_6 M_at_51_6 M_at_52_6 M_at_53_6 M_at_54_6 M_at_55_6 M_at_56_6 M_at_57_6 M_at_58_6 M_at_59_6 M_at_510_6 M_at_511_6 M_at_512_6 M_at_513_6 M_at_514_6 M_at_515_6 M_at_516_6 M_at_517_6 M_at_518_6 M_at_519_6 M_at_520_6 M_at_521_6 M_at_522_6 M_at_523_6 M_at_524_6 M_at_525_6 M_at_526_6 M_at_527_6 M_at_528_6 M_at_529_6 M_at_530_6 M_at_531_6 M_af_50_6 M_af_51_6 M_af_52_6 M_af_53_6 M_af_54_6 M_af_55_6 M_af_56_6 M_af_57_6 M_af_58_6 M_af_59_6 M_af_510_6 M_af_511_6 M_af_512_6 M_af_513_6 M_af_514_6 M_af_515_6 M_af_516_6 M_af_517_6 M_af_518_6 M_af_519_6 M_af_520_6 M_af_521_6 M_af_522_6 M_af_523_6 M_af_524_6 M_af_525_6 M_af_526_6 M_af_527_6 M_af_528_6 M_af_529_6 M_af_530_6 M_af_531_6 M_aa Merge_332_7t_4
.ends
*---- end of process: ParentRouter<> -----
*
*---- act defproc: Reg4<> -----
* raw ports:  reset W.t[0] W.t[1] W.t[2] W.t[3] W.f[0] W.f[1] W.f[2] W.f[3] W.a R.req R.t[0] R.t[1] R.t[2] R.t[3] R.f[0] R.f[1] R.f[2] R.f[3]
*
.subckt Reg4 reset W_at_50_6 W_at_51_6 W_at_52_6 W_at_53_6 W_af_50_6 W_af_51_6 W_af_52_6 W_af_53_6 W_aa R_areq R_at_50_6 R_at_51_6 R_at_52_6 R_at_53_6 R_af_50_6 R_af_51_6 R_af_52_6 R_af_53_6
*.PININFO reset:I W_at_50_6:I W_at_51_6:I W_at_52_6:I W_at_53_6:I W_af_50_6:I W_af_51_6:I W_af_52_6:I W_af_53_6:I W_aa:O R_areq:I R_at_50_6:O R_at_51_6:O R_at_52_6:O R_at_53_6:O R_af_50_6:O R_af_51_6:O R_af_52_6:O R_af_53_6:O
*.POWER VDD Vdd
*.POWER GND GND
*.POWER NSUB GND
*.POWER PSUB Vdd
*
* --- node flags ---
*
* __reg__pa (state-holding): pup_reff=3.2; pdn_reff=5.33333
* x_53_6 (state-holding): pup_reff=0.4; pdn_reff=0.666667
* __x_53_6 (combinational)
* x_52_6 (state-holding): pup_reff=0.4; pdn_reff=0.666667
* __x_52_6 (combinational)
* x_51_6 (state-holding): pup_reff=0.4; pdn_reff=0.666667
* __x_51_6 (combinational)
* x_50_6 (state-holding): pup_reff=0.4; pdn_reff=0.666667
* __x_50_6 (combinational)
* __pt_50_6 (combinational)
* R_at_50_6 (state-holding): pup_reff=0.8; pdn_reff=0.666667
* __qr (combinational)
* R_af_50_6 (state-holding): pup_reff=0.8; pdn_reff=0.666667
* __pt_51_6 (combinational)
* R_at_51_6 (state-holding): pup_reff=0.8; pdn_reff=0.666667
* R_af_51_6 (state-holding): pup_reff=0.8; pdn_reff=0.666667
* __pt_52_6 (combinational)
* R_at_52_6 (state-holding): pup_reff=0.8; pdn_reff=0.666667
* R_af_52_6 (state-holding): pup_reff=0.8; pdn_reff=0.666667
* __pt_53_6 (combinational)
* R_at_53_6 (state-holding): pup_reff=0.8; pdn_reff=0.666667
* R_af_53_6 (state-holding): pup_reff=0.8; pdn_reff=0.666667
* W_aa (combinational)
*
* --- end node flags ---
*
M0_ Vdd W_at_53_6 #33 Vdd pmos W=0.1625U L=0.065U
M1_ Vdd __pt_50_6 x_50_6 Vdd pmos W=0.1625U L=0.065U
M2_ Vdd __qr #40 Vdd pmos W=0.1625U L=0.065U
M3_ Vdd __qr #43 Vdd pmos W=0.1625U L=0.065U
M4_ Vdd __pt_51_6 x_51_6 Vdd pmos W=0.1625U L=0.065U
M5_ Vdd __qr #46 Vdd pmos W=0.1625U L=0.065U
M6_ Vdd __qr #48 Vdd pmos W=0.1625U L=0.065U
M7_ Vdd __pt_52_6 x_52_6 Vdd pmos W=0.1625U L=0.065U
M8_ Vdd __qr #51 Vdd pmos W=0.1625U L=0.065U
M9_ Vdd __qr #53 Vdd pmos W=0.1625U L=0.065U
M10_ Vdd __pt_53_6 x_53_6 Vdd pmos W=0.1625U L=0.065U
M11_ Vdd __qr #56 Vdd pmos W=0.1625U L=0.065U
M12_ Vdd __qr #58 Vdd pmos W=0.1625U L=0.065U
M13_ Vdd R_areq __qr Vdd pmos W=0.1625U L=0.065U
M14_ Vdd W_at_50_6 __pt_50_6 Vdd pmos W=0.1625U L=0.065U
M15_ Vdd x_50_6 __x_50_6 Vdd pmos W=0.1625U L=0.065U
M16_ Vdd W_at_51_6 __pt_51_6 Vdd pmos W=0.1625U L=0.065U
M17_ Vdd x_51_6 __x_51_6 Vdd pmos W=0.1625U L=0.065U
M18_ Vdd W_at_52_6 __pt_52_6 Vdd pmos W=0.1625U L=0.065U
M19_ Vdd x_52_6 __x_52_6 Vdd pmos W=0.1625U L=0.065U
M20_ Vdd W_at_53_6 __pt_53_6 Vdd pmos W=0.1625U L=0.065U
M21_ Vdd x_53_6 __x_53_6 Vdd pmos W=0.1625U L=0.065U
M22_ Vdd __reg__pa W_aa Vdd pmos W=0.1625U L=0.065U
M23_ Vdd __reg__pa #fb61# Vdd pmos W=0.1625U L=0.13U
M24_ Vdd x_53_6 #fb64# Vdd pmos W=0.1625U L=0.13U
M25_keeper Vdd GND #62 Vdd pmos W=0.0975U L=2.535U
M26_ Vdd x_52_6 #fb67# Vdd pmos W=0.1625U L=0.13U
M27_keeper Vdd GND #65 Vdd pmos W=0.0975U L=0.26U
M28_ Vdd x_51_6 #fb70# Vdd pmos W=0.1625U L=0.13U
M29_keeper Vdd GND #68 Vdd pmos W=0.0975U L=0.26U
M30_ Vdd x_50_6 #fb73# Vdd pmos W=0.1625U L=0.13U
M31_keeper Vdd GND #71 Vdd pmos W=0.0975U L=0.26U
M32_ Vdd R_at_50_6 #fb76# Vdd pmos W=0.1625U L=0.13U
M33_keeper Vdd GND #74 Vdd pmos W=0.0975U L=0.26U
M34_ Vdd R_af_50_6 #fb79# Vdd pmos W=0.1625U L=0.13U
M35_keeper Vdd GND #77 Vdd pmos W=0.0975U L=0.26U
M36_ Vdd R_at_51_6 #fb82# Vdd pmos W=0.1625U L=0.13U
M37_keeper Vdd GND #80 Vdd pmos W=0.0975U L=0.26U
M38_ Vdd R_af_51_6 #fb85# Vdd pmos W=0.1625U L=0.13U
M39_keeper Vdd GND #83 Vdd pmos W=0.0975U L=0.26U
M40_ Vdd R_at_52_6 #fb88# Vdd pmos W=0.1625U L=0.13U
M41_keeper Vdd GND #86 Vdd pmos W=0.0975U L=0.26U
M42_ Vdd R_af_52_6 #fb91# Vdd pmos W=0.1625U L=0.13U
M43_keeper Vdd GND #89 Vdd pmos W=0.0975U L=0.26U
M44_ Vdd R_at_53_6 #fb94# Vdd pmos W=0.1625U L=0.13U
M45_keeper Vdd GND #92 Vdd pmos W=0.0975U L=0.26U
M46_ Vdd R_af_53_6 #fb97# Vdd pmos W=0.1625U L=0.13U
M47_keeper Vdd GND #95 Vdd pmos W=0.0975U L=0.26U
M48_keeper Vdd GND #98 Vdd pmos W=0.0975U L=0.26U
M49_ GND W_at_53_6 #6 GND nmos W=0.0975U L=0.065U
M50_ GND W_af_53_6 #9 GND nmos W=0.0975U L=0.065U
M51_ GND W_af_50_6 x_50_6 GND nmos W=0.0975U L=0.065U
M52_ GND reset x_50_6 GND nmos W=0.0975U L=0.065U
M53_ GND __qr R_at_50_6 GND nmos W=0.0975U L=0.065U
M54_ GND __qr R_af_50_6 GND nmos W=0.0975U L=0.065U
M55_ GND W_af_51_6 x_51_6 GND nmos W=0.0975U L=0.065U
M56_ GND reset x_51_6 GND nmos W=0.0975U L=0.065U
M57_ GND __qr R_at_51_6 GND nmos W=0.0975U L=0.065U
M58_ GND __qr R_af_51_6 GND nmos W=0.0975U L=0.065U
M59_ GND W_af_52_6 x_52_6 GND nmos W=0.0975U L=0.065U
M60_ GND reset x_52_6 GND nmos W=0.0975U L=0.065U
M61_ GND __qr R_at_52_6 GND nmos W=0.0975U L=0.065U
M62_ GND __qr R_af_52_6 GND nmos W=0.0975U L=0.065U
M63_ GND W_af_53_6 x_53_6 GND nmos W=0.0975U L=0.065U
M64_ GND reset x_53_6 GND nmos W=0.0975U L=0.065U
M65_ GND __qr R_at_53_6 GND nmos W=0.0975U L=0.065U
M66_ GND __qr R_af_53_6 GND nmos W=0.0975U L=0.065U
M67_ GND R_areq __qr GND nmos W=0.0975U L=0.065U
M68_ GND W_at_50_6 __pt_50_6 GND nmos W=0.0975U L=0.065U
M69_ GND x_50_6 __x_50_6 GND nmos W=0.0975U L=0.065U
M70_ GND W_at_51_6 __pt_51_6 GND nmos W=0.0975U L=0.065U
M71_ GND x_51_6 __x_51_6 GND nmos W=0.0975U L=0.065U
M72_ GND W_at_52_6 __pt_52_6 GND nmos W=0.0975U L=0.065U
M73_ GND x_52_6 __x_52_6 GND nmos W=0.0975U L=0.065U
M74_ GND W_at_53_6 __pt_53_6 GND nmos W=0.0975U L=0.065U
M75_ GND x_53_6 __x_53_6 GND nmos W=0.0975U L=0.065U
M76_ GND __reg__pa W_aa GND nmos W=0.0975U L=0.065U
M77_ GND __reg__pa #fb61# GND nmos W=0.0975U L=0.13U
M78_ GND x_53_6 #fb64# GND nmos W=0.0975U L=0.13U
M79_keeper GND Vdd #63 GND nmos W=0.0975U L=6.175U
M80_ GND x_52_6 #fb67# GND nmos W=0.0975U L=0.13U
M81_keeper GND Vdd #66 GND nmos W=0.0975U L=0.715U
M82_ GND x_51_6 #fb70# GND nmos W=0.0975U L=0.13U
M83_keeper GND Vdd #69 GND nmos W=0.0975U L=0.715U
M84_ GND x_50_6 #fb73# GND nmos W=0.0975U L=0.13U
M85_keeper GND Vdd #72 GND nmos W=0.0975U L=0.715U
M86_ GND R_at_50_6 #fb76# GND nmos W=0.0975U L=0.13U
M87_keeper GND Vdd #75 GND nmos W=0.0975U L=0.715U
M88_ GND R_af_50_6 #fb79# GND nmos W=0.0975U L=0.13U
M89_keeper GND Vdd #78 GND nmos W=0.0975U L=1.495U
M90_ GND R_at_51_6 #fb82# GND nmos W=0.0975U L=0.13U
M91_keeper GND Vdd #81 GND nmos W=0.0975U L=1.495U
M92_ GND R_af_51_6 #fb85# GND nmos W=0.0975U L=0.13U
M93_keeper GND Vdd #84 GND nmos W=0.0975U L=1.495U
M94_ GND R_at_52_6 #fb88# GND nmos W=0.0975U L=0.13U
M95_keeper GND Vdd #87 GND nmos W=0.0975U L=1.495U
M96_ GND R_af_52_6 #fb91# GND nmos W=0.0975U L=0.13U
M97_keeper GND Vdd #90 GND nmos W=0.0975U L=1.495U
M98_ GND R_at_53_6 #fb94# GND nmos W=0.0975U L=0.13U
M99_keeper GND Vdd #93 GND nmos W=0.0975U L=1.495U
M100_ GND R_af_53_6 #fb97# GND nmos W=0.0975U L=0.13U
M101_keeper GND Vdd #96 GND nmos W=0.0975U L=1.495U
M102_keeper GND Vdd #99 GND nmos W=0.0975U L=1.495U
M103_ #24 x_50_6 __reg__pa GND nmos W=0.0975U L=0.065U
M104_ #27 __x_50_6 __reg__pa GND nmos W=0.0975U L=0.065U
M105_ #36 W_af_50_6 __reg__pa Vdd pmos W=0.1625U L=0.065U
M106_keeper #62 #fb61# __reg__pa Vdd pmos W=0.0975U L=0.065U
M107_keeper #63 #fb61# __reg__pa GND nmos W=0.0975U L=0.065U
M108_ #18 x_51_6 #3 GND nmos W=0.0975U L=0.065U
M109_ #21 __x_51_6 #3 GND nmos W=0.0975U L=0.065U
M110_ #3 W_at_50_6 #24 GND nmos W=0.0975U L=0.065U
M111_ #3 W_af_50_6 #27 GND nmos W=0.0975U L=0.065U
M112_ #12 x_52_6 #4 GND nmos W=0.0975U L=0.065U
M113_ #15 __x_52_6 #4 GND nmos W=0.0975U L=0.065U
M114_ #4 W_at_51_6 #18 GND nmos W=0.0975U L=0.065U
M115_ #4 W_af_51_6 #21 GND nmos W=0.0975U L=0.065U
M116_ #6 x_53_6 #5 GND nmos W=0.0975U L=0.065U
M117_ #9 __x_53_6 #5 GND nmos W=0.0975U L=0.065U
M118_ #5 W_at_52_6 #12 GND nmos W=0.0975U L=0.065U
M119_ #5 W_af_52_6 #15 GND nmos W=0.0975U L=0.065U
M120_keeper #65 #fb64# x_53_6 Vdd pmos W=0.0975U L=0.065U
M121_keeper #66 #fb64# x_53_6 GND nmos W=0.0975U L=0.065U
M122_keeper #68 #fb67# x_52_6 Vdd pmos W=0.0975U L=0.065U
M123_keeper #69 #fb67# x_52_6 GND nmos W=0.0975U L=0.065U
M124_keeper #71 #fb70# x_51_6 Vdd pmos W=0.0975U L=0.065U
M125_keeper #72 #fb70# x_51_6 GND nmos W=0.0975U L=0.065U
M126_keeper #74 #fb73# x_50_6 Vdd pmos W=0.0975U L=0.065U
M127_keeper #75 #fb73# x_50_6 GND nmos W=0.0975U L=0.065U
M128_ #35 W_af_51_6 #30 Vdd pmos W=0.1625U L=0.065U
M129_ #30 W_at_50_6 #36 Vdd pmos W=0.1625U L=0.065U
M130_ #34 W_af_52_6 #31 Vdd pmos W=0.1625U L=0.065U
M131_ #31 W_at_51_6 #35 Vdd pmos W=0.1625U L=0.065U
M132_ #33 W_af_53_6 #32 Vdd pmos W=0.1625U L=0.065U
M133_ #32 W_at_52_6 #34 Vdd pmos W=0.1625U L=0.065U
M134_ #40 __x_50_6 R_at_50_6 Vdd pmos W=0.1625U L=0.065U
M135_keeper #77 #fb76# R_at_50_6 Vdd pmos W=0.0975U L=0.065U
M136_keeper #78 #fb76# R_at_50_6 GND nmos W=0.0975U L=0.065U
M137_ #43 x_50_6 R_af_50_6 Vdd pmos W=0.1625U L=0.065U
M138_keeper #80 #fb79# R_af_50_6 Vdd pmos W=0.0975U L=0.065U
M139_keeper #81 #fb79# R_af_50_6 GND nmos W=0.0975U L=0.065U
M140_ #46 __x_51_6 R_at_51_6 Vdd pmos W=0.1625U L=0.065U
M141_keeper #83 #fb82# R_at_51_6 Vdd pmos W=0.0975U L=0.065U
M142_keeper #84 #fb82# R_at_51_6 GND nmos W=0.0975U L=0.065U
M143_ #48 x_51_6 R_af_51_6 Vdd pmos W=0.1625U L=0.065U
M144_keeper #86 #fb85# R_af_51_6 Vdd pmos W=0.0975U L=0.065U
M145_keeper #87 #fb85# R_af_51_6 GND nmos W=0.0975U L=0.065U
M146_ #51 __x_52_6 R_at_52_6 Vdd pmos W=0.1625U L=0.065U
M147_keeper #89 #fb88# R_at_52_6 Vdd pmos W=0.0975U L=0.065U
M148_keeper #90 #fb88# R_at_52_6 GND nmos W=0.0975U L=0.065U
M149_ #53 x_52_6 R_af_52_6 Vdd pmos W=0.1625U L=0.065U
M150_keeper #92 #fb91# R_af_52_6 Vdd pmos W=0.0975U L=0.065U
M151_keeper #93 #fb91# R_af_52_6 GND nmos W=0.0975U L=0.065U
M152_ #56 __x_53_6 R_at_53_6 Vdd pmos W=0.1625U L=0.065U
M153_keeper #95 #fb94# R_at_53_6 Vdd pmos W=0.0975U L=0.065U
M154_keeper #96 #fb94# R_at_53_6 GND nmos W=0.0975U L=0.065U
M155_ #58 x_53_6 R_af_53_6 Vdd pmos W=0.1625U L=0.065U
M156_keeper #98 #fb97# R_af_53_6 Vdd pmos W=0.0975U L=0.065U
M157_keeper #99 #fb97# R_af_53_6 GND nmos W=0.0975U L=0.065U
.ends
*---- end of process: Reg4<> -----
*
*---- act defproc: QBuffer<> -----
* raw ports:  reset I.req I.t[0] I.t[1] I.t[2] I.t[3] I.f[0] I.f[1] I.f[2] I.f[3] O.t[0] O.t[1] O.t[2] O.t[3] O.f[0] O.f[1] O.f[2] O.f[3] O.a R.req R.a L.req L.a
*
.subckt QBuffer reset I_areq I_at_50_6 I_at_51_6 I_at_52_6 I_at_53_6 I_af_50_6 I_af_51_6 I_af_52_6 I_af_53_6 O_at_50_6 O_at_51_6 O_at_52_6 O_at_53_6 O_af_50_6 O_af_51_6 O_af_52_6 O_af_53_6 O_aa R_areq R_aa L_areq L_aa
*.PININFO reset:I I_areq:O I_at_50_6:I I_at_51_6:I I_at_52_6:I I_at_53_6:I I_af_50_6:I I_af_51_6:I I_af_52_6:I I_af_53_6:I O_at_50_6:O O_at_51_6:O O_at_52_6:O O_at_53_6:O O_af_50_6:O O_af_51_6:O O_af_52_6:O O_af_53_6:O O_aa:I R_areq:O R_aa:I L_areq:I L_aa:O
*.POWER VDD Vdd
*.POWER GND GND
*.POWER NSUB GND
*.POWER PSUB Vdd
*
* --- node flags ---
*
* __a (state-holding): pup_reff=0.4; pdn_reff=0.666667
* L_aa (state-holding): pup_reff=1.6; pdn_reff=1.33333
* __pa (combinational)
* __r (combinational)
* __b (state-holding): pup_reff=0.4; pdn_reff=0.666667
* p__a (combinational)
* __ra (combinational)
* __c (state-holding): pup_reff=0.4; pdn_reff=0.666667
* __oa (combinational)
* I_areq (state-holding): pup_reff=0.8; pdn_reff=1.33333
* b (combinational)
* __lr (combinational)
* c (combinational)
* a (combinational)
* R_areq (state-holding): pup_reff=0.8; pdn_reff=1.33333
* q__r (state-holding): pup_reff=0.8; pdn_reff=0.666667
*
* --- end node flags ---
*
M0_ Vdd __pa __a Vdd pmos W=0.1625U L=0.065U
M1_ Vdd __r __a Vdd pmos W=0.1625U L=0.065U
M2_ Vdd __ra __b Vdd pmos W=0.1625U L=0.065U
M3_ Vdd __r __b Vdd pmos W=0.1625U L=0.065U
M4_ Vdd __oa __c Vdd pmos W=0.1625U L=0.065U
M5_ Vdd __r __c Vdd pmos W=0.1625U L=0.065U
M6_ Vdd __a #13 Vdd pmos W=0.1625U L=0.065U
M7_ Vdd __lr #19 Vdd pmos W=0.1625U L=0.065U
M8_ Vdd __b #26 Vdd pmos W=0.1625U L=0.065U
M9_ Vdd __c #29 Vdd pmos W=0.1625U L=0.065U
M10_ Vdd p__a __pa Vdd pmos W=0.1625U L=0.065U
M11_ Vdd R_aa __ra Vdd pmos W=0.1625U L=0.065U
M12_ Vdd O_aa __oa Vdd pmos W=0.1625U L=0.065U
M13_ Vdd L_areq __lr Vdd pmos W=0.1625U L=0.065U
M14_ Vdd reset __r Vdd pmos W=0.1625U L=0.065U
M15_ Vdd __a a Vdd pmos W=0.1625U L=0.065U
M16_ Vdd __b b Vdd pmos W=0.1625U L=0.065U
M17_ Vdd __c c Vdd pmos W=0.1625U L=0.065U
M18_ Vdd __a #fb31# Vdd pmos W=0.1625U L=0.13U
M19_ Vdd L_aa #fb34# Vdd pmos W=0.1625U L=0.13U
M20_keeper Vdd GND #32 Vdd pmos W=0.0975U L=0.26U
M21_ Vdd __b #fb37# Vdd pmos W=0.1625U L=0.13U
M22_keeper Vdd GND #35 Vdd pmos W=0.0975U L=0.585U
M23_ Vdd __c #fb40# Vdd pmos W=0.1625U L=0.13U
M24_keeper Vdd GND #38 Vdd pmos W=0.0975U L=0.26U
M25_ Vdd I_areq #fb43# Vdd pmos W=0.1625U L=0.13U
M26_keeper Vdd GND #41 Vdd pmos W=0.0975U L=0.26U
M27_ Vdd R_areq #fb46# Vdd pmos W=0.1625U L=0.13U
M28_keeper Vdd GND #44 Vdd pmos W=0.0975U L=0.585U
M29_ Vdd q__r #fb49# Vdd pmos W=0.1625U L=0.13U
M30_keeper Vdd GND #47 Vdd pmos W=0.0975U L=0.585U
M31_keeper Vdd GND #50 Vdd pmos W=0.0975U L=0.26U
M32_ GND L_aa __a GND nmos W=0.0975U L=0.065U
M33_ GND p__a __b GND nmos W=0.0975U L=0.065U
M34_ GND R_aa __c GND nmos W=0.0975U L=0.065U
M35_ GND __a #14 GND nmos W=0.0975U L=0.065U
M36_ GND reset I_areq GND nmos W=0.0975U L=0.065U
M37_ GND __lr #23 GND nmos W=0.0975U L=0.065U
M38_ GND reset L_aa GND nmos W=0.0975U L=0.065U
M39_ GND c #27 GND nmos W=0.0975U L=0.065U
M40_ GND reset R_areq GND nmos W=0.0975U L=0.065U
M41_ GND __c q__r GND nmos W=0.0975U L=0.065U
M42_ GND p__a __pa GND nmos W=0.0975U L=0.065U
M43_ GND R_aa __ra GND nmos W=0.0975U L=0.065U
M44_ GND O_aa __oa GND nmos W=0.0975U L=0.065U
M45_ GND L_areq __lr GND nmos W=0.0975U L=0.065U
M46_ GND reset __r GND nmos W=0.0975U L=0.065U
M47_ GND __a a GND nmos W=0.0975U L=0.065U
M48_ GND __b b GND nmos W=0.0975U L=0.065U
M49_ GND __c c GND nmos W=0.0975U L=0.065U
M50_ GND __a #fb31# GND nmos W=0.0975U L=0.13U
M51_ GND L_aa #fb34# GND nmos W=0.0975U L=0.13U
M52_keeper GND Vdd #33 GND nmos W=0.0975U L=0.715U
M53_ GND __b #fb37# GND nmos W=0.0975U L=0.13U
M54_keeper GND Vdd #36 GND nmos W=0.0975U L=3.055U
M55_ GND __c #fb40# GND nmos W=0.0975U L=0.13U
M56_keeper GND Vdd #39 GND nmos W=0.0975U L=0.715U
M57_ GND I_areq #fb43# GND nmos W=0.0975U L=0.13U
M58_keeper GND Vdd #42 GND nmos W=0.0975U L=0.715U
M59_ GND R_areq #fb46# GND nmos W=0.0975U L=0.13U
M60_keeper GND Vdd #45 GND nmos W=0.0975U L=1.495U
M61_ GND q__r #fb49# GND nmos W=0.0975U L=0.13U
M62_keeper GND Vdd #48 GND nmos W=0.0975U L=1.495U
M63_keeper GND Vdd #51 GND nmos W=0.0975U L=1.495U
M64_keeper #32 #fb31# __a Vdd pmos W=0.0975U L=0.065U
M65_keeper #33 #fb31# __a GND nmos W=0.0975U L=0.065U
M66_ #17 reset L_aa Vdd pmos W=0.1625U L=0.065U
M67_ #23 a L_aa GND nmos W=0.0975U L=0.065U
M68_keeper #35 #fb34# L_aa Vdd pmos W=0.0975U L=0.065U
M69_keeper #36 #fb34# L_aa GND nmos W=0.0975U L=0.065U
M70_keeper #38 #fb37# __b Vdd pmos W=0.0975U L=0.065U
M71_keeper #39 #fb37# __b GND nmos W=0.0975U L=0.065U
M72_keeper #41 #fb40# __c Vdd pmos W=0.0975U L=0.065U
M73_keeper #42 #fb40# __c GND nmos W=0.0975U L=0.065U
M74_ #13 L_aa I_areq Vdd pmos W=0.1625U L=0.065U
M75_ #14 b I_areq GND nmos W=0.0975U L=0.065U
M76_keeper #44 #fb43# I_areq Vdd pmos W=0.0975U L=0.065U
M77_keeper #45 #fb43# I_areq GND nmos W=0.0975U L=0.065U
M78_ #18 O_aa #17 Vdd pmos W=0.1625U L=0.065U
M79_ #19 c #18 Vdd pmos W=0.1625U L=0.065U
M80_ #26 p__a R_areq Vdd pmos W=0.1625U L=0.065U
M81_ #27 __b R_areq GND nmos W=0.0975U L=0.065U
M82_keeper #47 #fb46# R_areq Vdd pmos W=0.0975U L=0.065U
M83_keeper #48 #fb46# R_areq GND nmos W=0.0975U L=0.065U
M84_ #29 R_aa q__r Vdd pmos W=0.1625U L=0.065U
M85_keeper #50 #fb49# q__r Vdd pmos W=0.0975U L=0.065U
M86_keeper #51 #fb49# q__r GND nmos W=0.0975U L=0.065U
xreg reset I_at_50_6 I_at_51_6 I_at_52_6 I_at_53_6 I_af_50_6 I_af_51_6 I_af_52_6 I_af_53_6 p__a q__r O_at_50_6 O_at_51_6 O_at_52_6 O_at_53_6 O_af_50_6 O_af_51_6 O_af_52_6 O_af_53_6 Reg4
.ends
*---- end of process: QBuffer<> -----
*
*---- act defproc: InputAnalyzer<> -----
* raw ports:  reset I.t[0] I.t[1] I.t[2] I.t[3] I.f[0] I.f[1] I.f[2] I.f[3] I.a O.req O.t[0] O.t[1] O.t[2] O.t[3] O.f[0] O.f[1] O.f[2] O.f[3] R.req R.a L.req L.a
*
.subckt InputAnalyzer reset I_at_50_6 I_at_51_6 I_at_52_6 I_at_53_6 I_af_50_6 I_af_51_6 I_af_52_6 I_af_53_6 I_aa O_areq O_at_50_6 O_at_51_6 O_at_52_6 O_at_53_6 O_af_50_6 O_af_51_6 O_af_52_6 O_af_53_6 R_areq R_aa L_areq L_aa
*.PININFO reset:I I_at_50_6:I I_at_51_6:I I_at_52_6:I I_at_53_6:I I_af_50_6:I I_af_51_6:I I_af_52_6:I I_af_53_6:I I_aa:O O_areq:I O_at_50_6:O O_at_51_6:O O_at_52_6:O O_at_53_6:O O_af_50_6:O O_af_51_6:O O_af_52_6:O O_af_53_6:O R_areq:O R_aa:I L_areq:I L_aa:O
*.POWER VDD Vdd
*.POWER GND GND
*.POWER NSUB GND
*.POWER PSUB Vdd
*
* --- node flags ---
*
* m (state-holding): pup_reff=0.8; pdn_reff=6
* __or (combinational)
* __it_53_6 (combinational)
* __it_52_6 (combinational)
* __it_51_6 (combinational)
* __it_50_6 (combinational)
* I_aa (state-holding): pup_reff=1.2; pdn_reff=1.33333
* __ot_53_6 (state-holding): pup_reff=0.4; pdn_reff=1.33333
* __of_53_6 (state-holding): pup_reff=0.8; pdn_reff=2
* __ot_52_6 (state-holding): pup_reff=0.4; pdn_reff=1.33333
* __of_52_6 (state-holding): pup_reff=0.8; pdn_reff=2
* __ot_51_6 (state-holding): pup_reff=0.4; pdn_reff=1.33333
* __of_51_6 (state-holding): pup_reff=0.8; pdn_reff=2
* __ot_50_6 (state-holding): pup_reff=0.4; pdn_reff=1.33333
* __of_50_6 (state-holding): pup_reff=0.8; pdn_reff=2
* v (state-holding): pup_reff=1.2; pdn_reff=0.666667
* __m (combinational)
* __f (state-holding): pup_reff=1.2; pdn_reff=2
* k (state-holding): pup_reff=2; pdn_reff=2.66667
* __lr (combinational)
* __r (combinational)
* __if_53_6 (combinational)
* __if_52_6 (combinational)
* __if_51_6 (combinational)
* __if_50_6 (combinational)
* __k (combinational)
* __v (combinational)
* __s (state-holding): pup_reff=0.4; pdn_reff=2
* __rr (combinational)
* L_aa (state-holding): pup_reff=0.8; pdn_reff=0.666667
* R_areq (state-holding): pup_reff=1.2; pdn_reff=1.33333
* O_at_50_6 (combinational)
* O_af_50_6 (combinational)
* O_at_51_6 (combinational)
* O_af_51_6 (combinational)
* O_at_52_6 (combinational)
* O_af_52_6 (combinational)
* O_at_53_6 (combinational)
* O_af_53_6 (combinational)
*
* --- end node flags ---
*
M0_ Vdd __or #3 Vdd pmos W=0.1625U L=0.065U
M1_ Vdd L_areq #29 Vdd pmos W=0.1625U L=0.065U
M2_ Vdd __lr #38 Vdd pmos W=0.1625U L=0.065U
M3_ Vdd __r __f Vdd pmos W=0.1625U L=0.065U
M4_ Vdd __or #41 Vdd pmos W=0.1625U L=0.065U
M5_ Vdd __f #53 Vdd pmos W=0.1625U L=0.065U
M6_ Vdd __v #56 Vdd pmos W=0.1625U L=0.065U
M7_ Vdd v #58 Vdd pmos W=0.1625U L=0.065U
M8_ Vdd __rr __s Vdd pmos W=0.1625U L=0.065U
M9_ Vdd __r __s Vdd pmos W=0.1625U L=0.065U
M10_ Vdd __s #65 Vdd pmos W=0.1625U L=0.065U
M11_ Vdd __s #68 Vdd pmos W=0.1625U L=0.065U
M12_ Vdd __r R_areq Vdd pmos W=0.1625U L=0.065U
M13_ Vdd I_at_50_6 __ot_50_6 Vdd pmos W=0.1625U L=0.065U
M14_ Vdd I_af_50_6 __of_50_6 Vdd pmos W=0.1625U L=0.065U
M15_ Vdd __f #77 Vdd pmos W=0.1625U L=0.065U
M16_ Vdd I_at_51_6 __ot_51_6 Vdd pmos W=0.1625U L=0.065U
M17_ Vdd I_af_51_6 __of_51_6 Vdd pmos W=0.1625U L=0.065U
M18_ Vdd __f #84 Vdd pmos W=0.1625U L=0.065U
M19_ Vdd I_at_52_6 __ot_52_6 Vdd pmos W=0.1625U L=0.065U
M20_ Vdd I_af_52_6 __of_52_6 Vdd pmos W=0.1625U L=0.065U
M21_ Vdd __f #91 Vdd pmos W=0.1625U L=0.065U
M22_ Vdd I_at_53_6 __ot_53_6 Vdd pmos W=0.1625U L=0.065U
M23_ Vdd I_af_53_6 __of_53_6 Vdd pmos W=0.1625U L=0.065U
M24_ Vdd __f #98 Vdd pmos W=0.1625U L=0.065U
M25_ Vdd O_areq __or Vdd pmos W=0.1625U L=0.065U
M26_ Vdd m __m Vdd pmos W=0.1625U L=0.065U
M27_ Vdd k __k Vdd pmos W=0.1625U L=0.065U
M28_ Vdd v __v Vdd pmos W=0.1625U L=0.065U
M29_ Vdd L_areq __lr Vdd pmos W=0.1625U L=0.065U
M30_ Vdd R_areq __rr Vdd pmos W=0.1625U L=0.065U
M31_ Vdd reset __r Vdd pmos W=0.1625U L=0.065U
M32_ Vdd I_at_50_6 __it_50_6 Vdd pmos W=0.1625U L=0.065U
M33_ Vdd I_af_50_6 __if_50_6 Vdd pmos W=0.1625U L=0.065U
M34_ Vdd __ot_50_6 O_at_50_6 Vdd pmos W=0.1625U L=0.065U
M35_ Vdd __of_50_6 O_af_50_6 Vdd pmos W=0.1625U L=0.065U
M36_ Vdd I_at_51_6 __it_51_6 Vdd pmos W=0.1625U L=0.065U
M37_ Vdd I_af_51_6 __if_51_6 Vdd pmos W=0.1625U L=0.065U
M38_ Vdd __ot_51_6 O_at_51_6 Vdd pmos W=0.1625U L=0.065U
M39_ Vdd __of_51_6 O_af_51_6 Vdd pmos W=0.1625U L=0.065U
M40_ Vdd I_at_52_6 __it_52_6 Vdd pmos W=0.1625U L=0.065U
M41_ Vdd I_af_52_6 __if_52_6 Vdd pmos W=0.1625U L=0.065U
M42_ Vdd __ot_52_6 O_at_52_6 Vdd pmos W=0.1625U L=0.065U
M43_ Vdd __of_52_6 O_af_52_6 Vdd pmos W=0.1625U L=0.065U
M44_ Vdd I_at_53_6 __it_53_6 Vdd pmos W=0.1625U L=0.065U
M45_ Vdd I_af_53_6 __if_53_6 Vdd pmos W=0.1625U L=0.065U
M46_ Vdd __ot_53_6 O_at_53_6 Vdd pmos W=0.1625U L=0.065U
M47_ Vdd __of_53_6 O_af_53_6 Vdd pmos W=0.1625U L=0.065U
M48_ Vdd m #fb107# Vdd pmos W=0.1625U L=0.13U
M49_ Vdd I_aa #fb110# Vdd pmos W=0.1625U L=0.13U
M50_keeper Vdd GND #108 Vdd pmos W=0.0975U L=2.86U
M51_ Vdd __ot_53_6 #fb113# Vdd pmos W=0.1625U L=0.13U
M52_keeper Vdd GND #111 Vdd pmos W=0.0975U L=0.585U
M53_ Vdd __of_53_6 #fb116# Vdd pmos W=0.1625U L=0.13U
M54_keeper Vdd GND #114 Vdd pmos W=0.0975U L=0.585U
M55_ Vdd __ot_52_6 #fb119# Vdd pmos W=0.1625U L=0.13U
M56_keeper Vdd GND #117 Vdd pmos W=0.0975U L=0.91U
M57_ Vdd __of_52_6 #fb122# Vdd pmos W=0.1625U L=0.13U
M58_keeper Vdd GND #120 Vdd pmos W=0.0975U L=0.585U
M59_ Vdd __ot_51_6 #fb125# Vdd pmos W=0.1625U L=0.13U
M60_keeper Vdd GND #123 Vdd pmos W=0.0975U L=0.91U
M61_ Vdd __of_51_6 #fb128# Vdd pmos W=0.1625U L=0.13U
M62_keeper Vdd GND #126 Vdd pmos W=0.0975U L=0.585U
M63_ Vdd __ot_50_6 #fb131# Vdd pmos W=0.1625U L=0.13U
M64_keeper Vdd GND #129 Vdd pmos W=0.0975U L=0.91U
M65_ Vdd __of_50_6 #fb134# Vdd pmos W=0.1625U L=0.13U
M66_keeper Vdd GND #132 Vdd pmos W=0.0975U L=0.585U
M67_ Vdd v #fb137# Vdd pmos W=0.1625U L=0.13U
M68_keeper Vdd GND #135 Vdd pmos W=0.0975U L=0.91U
M69_ Vdd __f #fb140# Vdd pmos W=0.1625U L=0.13U
M70_keeper Vdd GND #138 Vdd pmos W=0.0975U L=0.26U
M71_ Vdd k #fb143# Vdd pmos W=0.1625U L=0.13U
M72_keeper Vdd GND #141 Vdd pmos W=0.0975U L=0.91U
M73_ Vdd __s #fb146# Vdd pmos W=0.1625U L=0.13U
M74_keeper Vdd GND #144 Vdd pmos W=0.0975U L=1.235U
M75_ Vdd L_aa #fb149# Vdd pmos W=0.1625U L=0.13U
M76_keeper Vdd GND #147 Vdd pmos W=0.0975U L=0.91U
M77_ Vdd R_areq #fb152# Vdd pmos W=0.1625U L=0.13U
M78_keeper Vdd GND #150 Vdd pmos W=0.0975U L=0.26U
M79_keeper Vdd GND #153 Vdd pmos W=0.0975U L=0.585U
M80_ GND I_aa #9 GND nmos W=0.0975U L=0.065U
M81_ GND reset m GND nmos W=0.0975U L=0.065U
M82_ GND L_areq v GND nmos W=0.0975U L=0.065U
M83_ GND reset v GND nmos W=0.0975U L=0.065U
M84_ GND k #35 GND nmos W=0.0975U L=0.065U
M85_ GND __if_53_6 #51 GND nmos W=0.0975U L=0.065U
M86_ GND reset k GND nmos W=0.0975U L=0.065U
M87_ GND __k #59 GND nmos W=0.0975U L=0.065U
M88_ GND L_areq #62 GND nmos W=0.0975U L=0.065U
M89_ GND __lr L_aa GND nmos W=0.0975U L=0.065U
M90_ GND reset L_aa GND nmos W=0.0975U L=0.065U
M91_ GND R_aa #69 GND nmos W=0.0975U L=0.065U
M92_ GND m #71 GND nmos W=0.0975U L=0.065U
M93_ GND m #73 GND nmos W=0.0975U L=0.065U
M94_ GND O_areq #76 GND nmos W=0.0975U L=0.065U
M95_ GND m #78 GND nmos W=0.0975U L=0.065U
M96_ GND m #80 GND nmos W=0.0975U L=0.065U
M97_ GND O_areq #83 GND nmos W=0.0975U L=0.065U
M98_ GND m #85 GND nmos W=0.0975U L=0.065U
M99_ GND m #87 GND nmos W=0.0975U L=0.065U
M100_ GND O_areq #90 GND nmos W=0.0975U L=0.065U
M101_ GND m #92 GND nmos W=0.0975U L=0.065U
M102_ GND m #94 GND nmos W=0.0975U L=0.065U
M103_ GND O_areq #97 GND nmos W=0.0975U L=0.065U
M104_ GND O_areq __or GND nmos W=0.0975U L=0.065U
M105_ GND m __m GND nmos W=0.0975U L=0.065U
M106_ GND k __k GND nmos W=0.0975U L=0.065U
M107_ GND v __v GND nmos W=0.0975U L=0.065U
M108_ GND L_areq __lr GND nmos W=0.0975U L=0.065U
M109_ GND R_areq __rr GND nmos W=0.0975U L=0.065U
M110_ GND reset __r GND nmos W=0.0975U L=0.065U
M111_ GND I_at_50_6 __it_50_6 GND nmos W=0.0975U L=0.065U
M112_ GND I_af_50_6 __if_50_6 GND nmos W=0.0975U L=0.065U
M113_ GND __ot_50_6 O_at_50_6 GND nmos W=0.0975U L=0.065U
M114_ GND __of_50_6 O_af_50_6 GND nmos W=0.0975U L=0.065U
M115_ GND I_at_51_6 __it_51_6 GND nmos W=0.0975U L=0.065U
M116_ GND I_af_51_6 __if_51_6 GND nmos W=0.0975U L=0.065U
M117_ GND __ot_51_6 O_at_51_6 GND nmos W=0.0975U L=0.065U
M118_ GND __of_51_6 O_af_51_6 GND nmos W=0.0975U L=0.065U
M119_ GND I_at_52_6 __it_52_6 GND nmos W=0.0975U L=0.065U
M120_ GND I_af_52_6 __if_52_6 GND nmos W=0.0975U L=0.065U
M121_ GND __ot_52_6 O_at_52_6 GND nmos W=0.0975U L=0.065U
M122_ GND __of_52_6 O_af_52_6 GND nmos W=0.0975U L=0.065U
M123_ GND I_at_53_6 __it_53_6 GND nmos W=0.0975U L=0.065U
M124_ GND I_af_53_6 __if_53_6 GND nmos W=0.0975U L=0.065U
M125_ GND __ot_53_6 O_at_53_6 GND nmos W=0.0975U L=0.065U
M126_ GND __of_53_6 O_af_53_6 GND nmos W=0.0975U L=0.065U
M127_ GND m #fb107# GND nmos W=0.0975U L=0.13U
M128_ GND I_aa #fb110# GND nmos W=0.0975U L=0.13U
M129_keeper GND Vdd #109 GND nmos W=0.0975U L=1.495U
M130_ GND __ot_53_6 #fb113# GND nmos W=0.0975U L=0.13U
M131_keeper GND Vdd #112 GND nmos W=0.0975U L=2.275U
M132_ GND __of_53_6 #fb116# GND nmos W=0.0975U L=0.13U
M133_keeper GND Vdd #115 GND nmos W=0.0975U L=0.715U
M134_ GND __ot_52_6 #fb119# GND nmos W=0.0975U L=0.13U
M135_keeper GND Vdd #118 GND nmos W=0.0975U L=1.495U
M136_ GND __of_52_6 #fb122# GND nmos W=0.0975U L=0.13U
M137_keeper GND Vdd #121 GND nmos W=0.0975U L=0.715U
M138_ GND __ot_51_6 #fb125# GND nmos W=0.0975U L=0.13U
M139_keeper GND Vdd #124 GND nmos W=0.0975U L=1.495U
M140_ GND __of_51_6 #fb128# GND nmos W=0.0975U L=0.13U
M141_keeper GND Vdd #127 GND nmos W=0.0975U L=0.715U
M142_ GND __ot_50_6 #fb131# GND nmos W=0.0975U L=0.13U
M143_keeper GND Vdd #130 GND nmos W=0.0975U L=1.495U
M144_ GND __of_50_6 #fb134# GND nmos W=0.0975U L=0.13U
M145_keeper GND Vdd #133 GND nmos W=0.0975U L=0.715U
M146_ GND v #fb137# GND nmos W=0.0975U L=0.13U
M147_keeper GND Vdd #136 GND nmos W=0.0975U L=1.495U
M148_ GND __f #fb140# GND nmos W=0.0975U L=0.13U
M149_keeper GND Vdd #139 GND nmos W=0.0975U L=2.275U
M150_ GND k #fb143# GND nmos W=0.0975U L=0.13U
M151_keeper GND Vdd #142 GND nmos W=0.0975U L=2.275U
M152_ GND __s #fb146# GND nmos W=0.0975U L=0.13U
M153_keeper GND Vdd #145 GND nmos W=0.0975U L=3.835U
M154_ GND L_aa #fb149# GND nmos W=0.0975U L=0.13U
M155_keeper GND Vdd #148 GND nmos W=0.0975U L=0.715U
M156_ GND R_areq #fb152# GND nmos W=0.0975U L=0.13U
M157_keeper GND Vdd #151 GND nmos W=0.0975U L=1.495U
M158_keeper GND Vdd #154 GND nmos W=0.0975U L=2.275U
M159_ #3 __it_53_6 m Vdd pmos W=0.1625U L=0.065U
M160_ #3 __it_52_6 m Vdd pmos W=0.1625U L=0.065U
M161_ #3 __it_51_6 m Vdd pmos W=0.1625U L=0.065U
M162_ #3 __it_50_6 m Vdd pmos W=0.1625U L=0.065U
M163_ #23 __of_50_6 m GND nmos W=0.0975U L=0.065U
M164_keeper #108 #fb107# m Vdd pmos W=0.0975U L=0.065U
M165_keeper #109 #fb107# m GND nmos W=0.0975U L=0.065U
M166_ #9 __ot_53_6 #14 GND nmos W=0.0975U L=0.065U
M167_ #52 __k I_aa Vdd pmos W=0.1625U L=0.065U
M168_ #55 O_areq I_aa Vdd pmos W=0.1625U L=0.065U
M169_ #58 __k I_aa Vdd pmos W=0.1625U L=0.065U
M170_ #59 __m I_aa GND nmos W=0.0975U L=0.065U
M171_keeper #111 #fb110# I_aa Vdd pmos W=0.0975U L=0.065U
M172_keeper #112 #fb110# I_aa GND nmos W=0.0975U L=0.065U
M173_ #20 __of_51_6 #11 GND nmos W=0.0975U L=0.065U
M174_ #11 __ot_50_6 #23 GND nmos W=0.0975U L=0.065U
M175_ #17 __of_52_6 #12 GND nmos W=0.0975U L=0.065U
M176_ #12 __ot_51_6 #20 GND nmos W=0.0975U L=0.065U
M177_ #14 __of_53_6 #13 GND nmos W=0.0975U L=0.065U
M178_ #13 __ot_52_6 #17 GND nmos W=0.0975U L=0.065U
M179_ #92 I_at_53_6 __ot_53_6 GND nmos W=0.0975U L=0.065U
M180_keeper #114 #fb113# __ot_53_6 Vdd pmos W=0.0975U L=0.065U
M181_keeper #115 #fb113# __ot_53_6 GND nmos W=0.0975U L=0.065U
M182_ #94 I_af_53_6 __of_53_6 GND nmos W=0.0975U L=0.065U
M183_ #96 k __of_53_6 GND nmos W=0.0975U L=0.065U
M184_ #98 O_areq __of_53_6 Vdd pmos W=0.1625U L=0.065U
M185_keeper #117 #fb116# __of_53_6 Vdd pmos W=0.0975U L=0.065U
M186_keeper #118 #fb116# __of_53_6 GND nmos W=0.0975U L=0.065U
M187_ #85 I_at_52_6 __ot_52_6 GND nmos W=0.0975U L=0.065U
M188_keeper #120 #fb119# __ot_52_6 Vdd pmos W=0.0975U L=0.065U
M189_keeper #121 #fb119# __ot_52_6 GND nmos W=0.0975U L=0.065U
M190_ #87 I_af_52_6 __of_52_6 GND nmos W=0.0975U L=0.065U
M191_ #89 k __of_52_6 GND nmos W=0.0975U L=0.065U
M192_ #91 O_areq __of_52_6 Vdd pmos W=0.1625U L=0.065U
M193_keeper #123 #fb122# __of_52_6 Vdd pmos W=0.0975U L=0.065U
M194_keeper #124 #fb122# __of_52_6 GND nmos W=0.0975U L=0.065U
M195_ #78 I_at_51_6 __ot_51_6 GND nmos W=0.0975U L=0.065U
M196_keeper #126 #fb125# __ot_51_6 Vdd pmos W=0.0975U L=0.065U
M197_keeper #127 #fb125# __ot_51_6 GND nmos W=0.0975U L=0.065U
M198_ #80 I_af_51_6 __of_51_6 GND nmos W=0.0975U L=0.065U
M199_ #82 k __of_51_6 GND nmos W=0.0975U L=0.065U
M200_ #84 O_areq __of_51_6 Vdd pmos W=0.1625U L=0.065U
M201_keeper #129 #fb128# __of_51_6 Vdd pmos W=0.0975U L=0.065U
M202_keeper #130 #fb128# __of_51_6 GND nmos W=0.0975U L=0.065U
M203_ #71 I_at_50_6 __ot_50_6 GND nmos W=0.0975U L=0.065U
M204_keeper #132 #fb131# __ot_50_6 Vdd pmos W=0.0975U L=0.065U
M205_keeper #133 #fb131# __ot_50_6 GND nmos W=0.0975U L=0.065U
M206_ #73 I_af_50_6 __of_50_6 GND nmos W=0.0975U L=0.065U
M207_ #75 k __of_50_6 GND nmos W=0.0975U L=0.065U
M208_ #77 O_areq __of_50_6 Vdd pmos W=0.1625U L=0.065U
M209_keeper #135 #fb134# __of_50_6 Vdd pmos W=0.0975U L=0.065U
M210_keeper #136 #fb134# __of_50_6 GND nmos W=0.0975U L=0.065U
M211_ #28 __m v Vdd pmos W=0.1625U L=0.065U
M212_keeper #138 #fb137# v Vdd pmos W=0.0975U L=0.065U
M213_keeper #139 #fb137# v GND nmos W=0.0975U L=0.065U
M214_ #29 O_areq #28 Vdd pmos W=0.1625U L=0.065U
M215_ #34 __or __f GND nmos W=0.0975U L=0.065U
M216_ #37 k __f Vdd pmos W=0.1625U L=0.065U
M217_keeper #141 #fb140# __f Vdd pmos W=0.0975U L=0.065U
M218_keeper #142 #fb140# __f GND nmos W=0.0975U L=0.065U
M219_ #35 v #34 GND nmos W=0.0975U L=0.065U
M220_ #42 __if_50_6 k Vdd pmos W=0.1625U L=0.065U
M221_ #49 __if_50_6 k GND nmos W=0.0975U L=0.065U
M222_keeper #144 #fb143# k Vdd pmos W=0.0975U L=0.065U
M223_keeper #145 #fb143# k GND nmos W=0.0975U L=0.065U
M224_ #38 I_aa #37 Vdd pmos W=0.1625U L=0.065U
M225_ #41 __if_53_6 #44 Vdd pmos W=0.1625U L=0.065U
M226_ #43 __if_51_6 #42 Vdd pmos W=0.1625U L=0.065U
M227_ #44 __if_52_6 #43 Vdd pmos W=0.1625U L=0.065U
M228_ #50 __if_51_6 #49 GND nmos W=0.0975U L=0.065U
M229_ #51 __if_52_6 #50 GND nmos W=0.0975U L=0.065U
M230_ #53 __lr #52 Vdd pmos W=0.1625U L=0.065U
M231_ #56 __m #55 Vdd pmos W=0.1625U L=0.065U
M232_ #61 __f __s GND nmos W=0.0975U L=0.065U
M233_keeper #147 #fb146# __s Vdd pmos W=0.0975U L=0.065U
M234_keeper #148 #fb146# __s GND nmos W=0.0975U L=0.065U
M235_ #62 __v #61 GND nmos W=0.0975U L=0.065U
M236_ #65 __lr L_aa Vdd pmos W=0.1625U L=0.065U
M237_keeper #150 #fb149# L_aa Vdd pmos W=0.0975U L=0.065U
M238_keeper #151 #fb149# L_aa GND nmos W=0.0975U L=0.065U
M239_ #67 L_areq R_areq Vdd pmos W=0.1625U L=0.065U
M240_ #69 __s R_areq GND nmos W=0.0975U L=0.065U
M241_keeper #153 #fb152# R_areq Vdd pmos W=0.0975U L=0.065U
M242_keeper #154 #fb152# R_areq GND nmos W=0.0975U L=0.065U
M243_ #68 L_aa #67 Vdd pmos W=0.1625U L=0.065U
M244_ #76 v #75 GND nmos W=0.0975U L=0.065U
M245_ #83 v #82 GND nmos W=0.0975U L=0.065U
M246_ #90 v #89 GND nmos W=0.0975U L=0.065U
M247_ #97 v #96 GND nmos W=0.0975U L=0.065U
.ends
*---- end of process: InputAnalyzer<> -----
*
*---- act defproc: Split<> -----
* raw ports:  I.req I.t[0] I.t[1] I.t[2] I.t[3] I.f[0] I.f[1] I.f[2] I.f[3] O0.req O0.t[0] O0.t[1] O0.t[2] O0.t[3] O0.f[0] O0.f[1] O0.f[2] O0.f[3] O1.req O1.t[0] O1.t[1] O1.t[2] O1.t[3] O1.f[0] O1.f[1] O1.f[2] O1.f[3]
*
.subckt Split I_areq I_at_50_6 I_at_51_6 I_at_52_6 I_at_53_6 I_af_50_6 I_af_51_6 I_af_52_6 I_af_53_6 O0_areq O0_at_50_6 O0_at_51_6 O0_at_52_6 O0_at_53_6 O0_af_50_6 O0_af_51_6 O0_af_52_6 O0_af_53_6 O1_areq O1_at_50_6 O1_at_51_6 O1_at_52_6 O1_at_53_6 O1_af_50_6 O1_af_51_6 O1_af_52_6 O1_af_53_6
*.PININFO I_areq:O I_at_50_6:I I_at_51_6:I I_at_52_6:I I_at_53_6:I I_af_50_6:I I_af_51_6:I I_af_52_6:I I_af_53_6:I O0_areq:I O0_at_50_6:O O0_at_51_6:O O0_at_52_6:O O0_at_53_6:O O0_af_50_6:O O0_af_51_6:O O0_af_52_6:O O0_af_53_6:O O1_areq:I O1_at_50_6:O O1_at_51_6:O O1_at_52_6:O O1_at_53_6:O O1_af_50_6:O O1_af_51_6:O O1_af_52_6:O O1_af_53_6:O
*.POWER VDD Vdd
*.POWER GND GND
*.POWER NSUB GND
*.POWER PSUB Vdd
*
* --- node flags ---
*
* __ir (combinational)
* __o0t_50_6 (state-holding): pup_reff=0.4; pdn_reff=1.33333
* __o0f_50_6 (state-holding): pup_reff=0.4; pdn_reff=1.33333
* __o1t_50_6 (state-holding): pup_reff=0.4; pdn_reff=1.33333
* __o1f_50_6 (state-holding): pup_reff=0.4; pdn_reff=1.33333
* __o0t_51_6 (state-holding): pup_reff=0.4; pdn_reff=1.33333
* __o0f_51_6 (state-holding): pup_reff=0.4; pdn_reff=1.33333
* __o1t_51_6 (state-holding): pup_reff=0.4; pdn_reff=1.33333
* __o1f_51_6 (state-holding): pup_reff=0.4; pdn_reff=1.33333
* __o0t_52_6 (state-holding): pup_reff=0.4; pdn_reff=1.33333
* __o0f_52_6 (state-holding): pup_reff=0.4; pdn_reff=1.33333
* __o1t_52_6 (state-holding): pup_reff=0.4; pdn_reff=1.33333
* __o1f_52_6 (state-holding): pup_reff=0.4; pdn_reff=1.33333
* __o0t_53_6 (state-holding): pup_reff=0.4; pdn_reff=1.33333
* __o0f_53_6 (state-holding): pup_reff=0.4; pdn_reff=1.33333
* __o1t_53_6 (state-holding): pup_reff=0.4; pdn_reff=1.33333
* __o1f_53_6 (state-holding): pup_reff=0.4; pdn_reff=1.33333
* I_areq (combinational)
* O0_at_50_6 (combinational)
* O0_af_50_6 (combinational)
* O1_at_50_6 (combinational)
* O1_af_50_6 (combinational)
* O0_at_51_6 (combinational)
* O0_af_51_6 (combinational)
* O1_at_51_6 (combinational)
* O1_af_51_6 (combinational)
* O0_at_52_6 (combinational)
* O0_af_52_6 (combinational)
* O1_at_52_6 (combinational)
* O1_af_52_6 (combinational)
* O0_at_53_6 (combinational)
* O0_af_53_6 (combinational)
* O1_at_53_6 (combinational)
* O1_af_53_6 (combinational)
*
* --- end node flags ---
*
M0_ Vdd O0_areq #3 Vdd pmos W=0.1625U L=0.065U
M1_ Vdd I_at_50_6 __o0t_50_6 Vdd pmos W=0.1625U L=0.065U
M2_ Vdd I_af_50_6 __o0f_50_6 Vdd pmos W=0.1625U L=0.065U
M3_ Vdd I_at_50_6 __o1t_50_6 Vdd pmos W=0.1625U L=0.065U
M4_ Vdd I_af_50_6 __o1f_50_6 Vdd pmos W=0.1625U L=0.065U
M5_ Vdd I_at_51_6 __o0t_51_6 Vdd pmos W=0.1625U L=0.065U
M6_ Vdd I_af_51_6 __o0f_51_6 Vdd pmos W=0.1625U L=0.065U
M7_ Vdd I_at_51_6 __o1t_51_6 Vdd pmos W=0.1625U L=0.065U
M8_ Vdd I_af_51_6 __o1f_51_6 Vdd pmos W=0.1625U L=0.065U
M9_ Vdd I_at_52_6 __o0t_52_6 Vdd pmos W=0.1625U L=0.065U
M10_ Vdd I_af_52_6 __o0f_52_6 Vdd pmos W=0.1625U L=0.065U
M11_ Vdd I_at_52_6 __o1t_52_6 Vdd pmos W=0.1625U L=0.065U
M12_ Vdd I_af_52_6 __o1f_52_6 Vdd pmos W=0.1625U L=0.065U
M13_ Vdd I_at_53_6 __o0t_53_6 Vdd pmos W=0.1625U L=0.065U
M14_ Vdd I_af_53_6 __o0f_53_6 Vdd pmos W=0.1625U L=0.065U
M15_ Vdd I_at_53_6 __o1t_53_6 Vdd pmos W=0.1625U L=0.065U
M16_ Vdd I_af_53_6 __o1f_53_6 Vdd pmos W=0.1625U L=0.065U
M17_ Vdd __ir I_areq Vdd pmos W=0.1625U L=0.065U
M18_ Vdd __o0t_50_6 O0_at_50_6 Vdd pmos W=0.1625U L=0.065U
M19_ Vdd __o0f_50_6 O0_af_50_6 Vdd pmos W=0.1625U L=0.065U
M20_ Vdd __o1t_50_6 O1_at_50_6 Vdd pmos W=0.1625U L=0.065U
M21_ Vdd __o1f_50_6 O1_af_50_6 Vdd pmos W=0.1625U L=0.065U
M22_ Vdd __o0t_51_6 O0_at_51_6 Vdd pmos W=0.1625U L=0.065U
M23_ Vdd __o0f_51_6 O0_af_51_6 Vdd pmos W=0.1625U L=0.065U
M24_ Vdd __o1t_51_6 O1_at_51_6 Vdd pmos W=0.1625U L=0.065U
M25_ Vdd __o1f_51_6 O1_af_51_6 Vdd pmos W=0.1625U L=0.065U
M26_ Vdd __o0t_52_6 O0_at_52_6 Vdd pmos W=0.1625U L=0.065U
M27_ Vdd __o0f_52_6 O0_af_52_6 Vdd pmos W=0.1625U L=0.065U
M28_ Vdd __o1t_52_6 O1_at_52_6 Vdd pmos W=0.1625U L=0.065U
M29_ Vdd __o1f_52_6 O1_af_52_6 Vdd pmos W=0.1625U L=0.065U
M30_ Vdd __o0t_53_6 O0_at_53_6 Vdd pmos W=0.1625U L=0.065U
M31_ Vdd __o0f_53_6 O0_af_53_6 Vdd pmos W=0.1625U L=0.065U
M32_ Vdd __o1t_53_6 O1_at_53_6 Vdd pmos W=0.1625U L=0.065U
M33_ Vdd __o1f_53_6 O1_af_53_6 Vdd pmos W=0.1625U L=0.065U
M34_ Vdd __o0t_50_6 #fb63# Vdd pmos W=0.1625U L=0.13U
M35_ Vdd __o0f_50_6 #fb66# Vdd pmos W=0.1625U L=0.13U
M36_keeper Vdd GND #64 Vdd pmos W=0.0975U L=0.585U
M37_ Vdd __o1t_50_6 #fb69# Vdd pmos W=0.1625U L=0.13U
M38_keeper Vdd GND #67 Vdd pmos W=0.0975U L=0.585U
M39_ Vdd __o1f_50_6 #fb72# Vdd pmos W=0.1625U L=0.13U
M40_keeper Vdd GND #70 Vdd pmos W=0.0975U L=0.585U
M41_ Vdd __o0t_51_6 #fb75# Vdd pmos W=0.1625U L=0.13U
M42_keeper Vdd GND #73 Vdd pmos W=0.0975U L=0.585U
M43_ Vdd __o0f_51_6 #fb78# Vdd pmos W=0.1625U L=0.13U
M44_keeper Vdd GND #76 Vdd pmos W=0.0975U L=0.585U
M45_ Vdd __o1t_51_6 #fb81# Vdd pmos W=0.1625U L=0.13U
M46_keeper Vdd GND #79 Vdd pmos W=0.0975U L=0.585U
M47_ Vdd __o1f_51_6 #fb84# Vdd pmos W=0.1625U L=0.13U
M48_keeper Vdd GND #82 Vdd pmos W=0.0975U L=0.585U
M49_ Vdd __o0t_52_6 #fb87# Vdd pmos W=0.1625U L=0.13U
M50_keeper Vdd GND #85 Vdd pmos W=0.0975U L=0.585U
M51_ Vdd __o0f_52_6 #fb90# Vdd pmos W=0.1625U L=0.13U
M52_keeper Vdd GND #88 Vdd pmos W=0.0975U L=0.585U
M53_ Vdd __o1t_52_6 #fb93# Vdd pmos W=0.1625U L=0.13U
M54_keeper Vdd GND #91 Vdd pmos W=0.0975U L=0.585U
M55_ Vdd __o1f_52_6 #fb96# Vdd pmos W=0.1625U L=0.13U
M56_keeper Vdd GND #94 Vdd pmos W=0.0975U L=0.585U
M57_ Vdd __o0t_53_6 #fb99# Vdd pmos W=0.1625U L=0.13U
M58_keeper Vdd GND #97 Vdd pmos W=0.0975U L=0.585U
M59_ Vdd __o0f_53_6 #fb102# Vdd pmos W=0.1625U L=0.13U
M60_keeper Vdd GND #100 Vdd pmos W=0.0975U L=0.585U
M61_ Vdd __o1t_53_6 #fb105# Vdd pmos W=0.1625U L=0.13U
M62_keeper Vdd GND #103 Vdd pmos W=0.0975U L=0.585U
M63_ Vdd __o1f_53_6 #fb108# Vdd pmos W=0.1625U L=0.13U
M64_keeper Vdd GND #106 Vdd pmos W=0.0975U L=0.585U
M65_keeper Vdd GND #109 Vdd pmos W=0.0975U L=0.585U
M66_ GND O0_areq __ir GND nmos W=0.0975U L=0.065U
M67_ GND O1_areq __ir GND nmos W=0.0975U L=0.065U
M68_ GND O0_areq #7 GND nmos W=0.0975U L=0.065U
M69_ GND O0_areq #10 GND nmos W=0.0975U L=0.065U
M70_ GND O1_areq #13 GND nmos W=0.0975U L=0.065U
M71_ GND O1_areq #15 GND nmos W=0.0975U L=0.065U
M72_ GND O0_areq #17 GND nmos W=0.0975U L=0.065U
M73_ GND O0_areq #20 GND nmos W=0.0975U L=0.065U
M74_ GND O1_areq #23 GND nmos W=0.0975U L=0.065U
M75_ GND O1_areq #25 GND nmos W=0.0975U L=0.065U
M76_ GND O0_areq #27 GND nmos W=0.0975U L=0.065U
M77_ GND O0_areq #30 GND nmos W=0.0975U L=0.065U
M78_ GND O1_areq #33 GND nmos W=0.0975U L=0.065U
M79_ GND O1_areq #35 GND nmos W=0.0975U L=0.065U
M80_ GND O0_areq #37 GND nmos W=0.0975U L=0.065U
M81_ GND O0_areq #40 GND nmos W=0.0975U L=0.065U
M82_ GND O1_areq #43 GND nmos W=0.0975U L=0.065U
M83_ GND O1_areq #45 GND nmos W=0.0975U L=0.065U
M84_ GND __ir I_areq GND nmos W=0.0975U L=0.065U
M85_ GND __o0t_50_6 O0_at_50_6 GND nmos W=0.0975U L=0.065U
M86_ GND __o0f_50_6 O0_af_50_6 GND nmos W=0.0975U L=0.065U
M87_ GND __o1t_50_6 O1_at_50_6 GND nmos W=0.0975U L=0.065U
M88_ GND __o1f_50_6 O1_af_50_6 GND nmos W=0.0975U L=0.065U
M89_ GND __o0t_51_6 O0_at_51_6 GND nmos W=0.0975U L=0.065U
M90_ GND __o0f_51_6 O0_af_51_6 GND nmos W=0.0975U L=0.065U
M91_ GND __o1t_51_6 O1_at_51_6 GND nmos W=0.0975U L=0.065U
M92_ GND __o1f_51_6 O1_af_51_6 GND nmos W=0.0975U L=0.065U
M93_ GND __o0t_52_6 O0_at_52_6 GND nmos W=0.0975U L=0.065U
M94_ GND __o0f_52_6 O0_af_52_6 GND nmos W=0.0975U L=0.065U
M95_ GND __o1t_52_6 O1_at_52_6 GND nmos W=0.0975U L=0.065U
M96_ GND __o1f_52_6 O1_af_52_6 GND nmos W=0.0975U L=0.065U
M97_ GND __o0t_53_6 O0_at_53_6 GND nmos W=0.0975U L=0.065U
M98_ GND __o0f_53_6 O0_af_53_6 GND nmos W=0.0975U L=0.065U
M99_ GND __o1t_53_6 O1_at_53_6 GND nmos W=0.0975U L=0.065U
M100_ GND __o1f_53_6 O1_af_53_6 GND nmos W=0.0975U L=0.065U
M101_ GND __o0t_50_6 #fb63# GND nmos W=0.0975U L=0.13U
M102_ GND __o0f_50_6 #fb66# GND nmos W=0.0975U L=0.13U
M103_keeper GND Vdd #65 GND nmos W=0.0975U L=0.715U
M104_ GND __o1t_50_6 #fb69# GND nmos W=0.0975U L=0.13U
M105_keeper GND Vdd #68 GND nmos W=0.0975U L=0.715U
M106_ GND __o1f_50_6 #fb72# GND nmos W=0.0975U L=0.13U
M107_keeper GND Vdd #71 GND nmos W=0.0975U L=0.715U
M108_ GND __o0t_51_6 #fb75# GND nmos W=0.0975U L=0.13U
M109_keeper GND Vdd #74 GND nmos W=0.0975U L=0.715U
M110_ GND __o0f_51_6 #fb78# GND nmos W=0.0975U L=0.13U
M111_keeper GND Vdd #77 GND nmos W=0.0975U L=0.715U
M112_ GND __o1t_51_6 #fb81# GND nmos W=0.0975U L=0.13U
M113_keeper GND Vdd #80 GND nmos W=0.0975U L=0.715U
M114_ GND __o1f_51_6 #fb84# GND nmos W=0.0975U L=0.13U
M115_keeper GND Vdd #83 GND nmos W=0.0975U L=0.715U
M116_ GND __o0t_52_6 #fb87# GND nmos W=0.0975U L=0.13U
M117_keeper GND Vdd #86 GND nmos W=0.0975U L=0.715U
M118_ GND __o0f_52_6 #fb90# GND nmos W=0.0975U L=0.13U
M119_keeper GND Vdd #89 GND nmos W=0.0975U L=0.715U
M120_ GND __o1t_52_6 #fb93# GND nmos W=0.0975U L=0.13U
M121_keeper GND Vdd #92 GND nmos W=0.0975U L=0.715U
M122_ GND __o1f_52_6 #fb96# GND nmos W=0.0975U L=0.13U
M123_keeper GND Vdd #95 GND nmos W=0.0975U L=0.715U
M124_ GND __o0t_53_6 #fb99# GND nmos W=0.0975U L=0.13U
M125_keeper GND Vdd #98 GND nmos W=0.0975U L=0.715U
M126_ GND __o0f_53_6 #fb102# GND nmos W=0.0975U L=0.13U
M127_keeper GND Vdd #101 GND nmos W=0.0975U L=0.715U
M128_ GND __o1t_53_6 #fb105# GND nmos W=0.0975U L=0.13U
M129_keeper GND Vdd #104 GND nmos W=0.0975U L=0.715U
M130_ GND __o1f_53_6 #fb108# GND nmos W=0.0975U L=0.13U
M131_keeper GND Vdd #107 GND nmos W=0.0975U L=0.715U
M132_keeper GND Vdd #110 GND nmos W=0.0975U L=0.715U
M133_ #3 O1_areq __ir Vdd pmos W=0.1625U L=0.065U
M134_ #7 I_at_50_6 __o0t_50_6 GND nmos W=0.0975U L=0.065U
M135_keeper #64 #fb63# __o0t_50_6 Vdd pmos W=0.0975U L=0.065U
M136_keeper #65 #fb63# __o0t_50_6 GND nmos W=0.0975U L=0.065U
M137_ #10 I_af_50_6 __o0f_50_6 GND nmos W=0.0975U L=0.065U
M138_keeper #67 #fb66# __o0f_50_6 Vdd pmos W=0.0975U L=0.065U
M139_keeper #68 #fb66# __o0f_50_6 GND nmos W=0.0975U L=0.065U
M140_ #13 I_at_50_6 __o1t_50_6 GND nmos W=0.0975U L=0.065U
M141_keeper #70 #fb69# __o1t_50_6 Vdd pmos W=0.0975U L=0.065U
M142_keeper #71 #fb69# __o1t_50_6 GND nmos W=0.0975U L=0.065U
M143_ #15 I_af_50_6 __o1f_50_6 GND nmos W=0.0975U L=0.065U
M144_keeper #73 #fb72# __o1f_50_6 Vdd pmos W=0.0975U L=0.065U
M145_keeper #74 #fb72# __o1f_50_6 GND nmos W=0.0975U L=0.065U
M146_ #17 I_at_51_6 __o0t_51_6 GND nmos W=0.0975U L=0.065U
M147_keeper #76 #fb75# __o0t_51_6 Vdd pmos W=0.0975U L=0.065U
M148_keeper #77 #fb75# __o0t_51_6 GND nmos W=0.0975U L=0.065U
M149_ #20 I_af_51_6 __o0f_51_6 GND nmos W=0.0975U L=0.065U
M150_keeper #79 #fb78# __o0f_51_6 Vdd pmos W=0.0975U L=0.065U
M151_keeper #80 #fb78# __o0f_51_6 GND nmos W=0.0975U L=0.065U
M152_ #23 I_at_51_6 __o1t_51_6 GND nmos W=0.0975U L=0.065U
M153_keeper #82 #fb81# __o1t_51_6 Vdd pmos W=0.0975U L=0.065U
M154_keeper #83 #fb81# __o1t_51_6 GND nmos W=0.0975U L=0.065U
M155_ #25 I_af_51_6 __o1f_51_6 GND nmos W=0.0975U L=0.065U
M156_keeper #85 #fb84# __o1f_51_6 Vdd pmos W=0.0975U L=0.065U
M157_keeper #86 #fb84# __o1f_51_6 GND nmos W=0.0975U L=0.065U
M158_ #27 I_at_52_6 __o0t_52_6 GND nmos W=0.0975U L=0.065U
M159_keeper #88 #fb87# __o0t_52_6 Vdd pmos W=0.0975U L=0.065U
M160_keeper #89 #fb87# __o0t_52_6 GND nmos W=0.0975U L=0.065U
M161_ #30 I_af_52_6 __o0f_52_6 GND nmos W=0.0975U L=0.065U
M162_keeper #91 #fb90# __o0f_52_6 Vdd pmos W=0.0975U L=0.065U
M163_keeper #92 #fb90# __o0f_52_6 GND nmos W=0.0975U L=0.065U
M164_ #33 I_at_52_6 __o1t_52_6 GND nmos W=0.0975U L=0.065U
M165_keeper #94 #fb93# __o1t_52_6 Vdd pmos W=0.0975U L=0.065U
M166_keeper #95 #fb93# __o1t_52_6 GND nmos W=0.0975U L=0.065U
M167_ #35 I_af_52_6 __o1f_52_6 GND nmos W=0.0975U L=0.065U
M168_keeper #97 #fb96# __o1f_52_6 Vdd pmos W=0.0975U L=0.065U
M169_keeper #98 #fb96# __o1f_52_6 GND nmos W=0.0975U L=0.065U
M170_ #37 I_at_53_6 __o0t_53_6 GND nmos W=0.0975U L=0.065U
M171_keeper #100 #fb99# __o0t_53_6 Vdd pmos W=0.0975U L=0.065U
M172_keeper #101 #fb99# __o0t_53_6 GND nmos W=0.0975U L=0.065U
M173_ #40 I_af_53_6 __o0f_53_6 GND nmos W=0.0975U L=0.065U
M174_keeper #103 #fb102# __o0f_53_6 Vdd pmos W=0.0975U L=0.065U
M175_keeper #104 #fb102# __o0f_53_6 GND nmos W=0.0975U L=0.065U
M176_ #43 I_at_53_6 __o1t_53_6 GND nmos W=0.0975U L=0.065U
M177_keeper #106 #fb105# __o1t_53_6 Vdd pmos W=0.0975U L=0.065U
M178_keeper #107 #fb105# __o1t_53_6 GND nmos W=0.0975U L=0.065U
M179_ #45 I_af_53_6 __o1f_53_6 GND nmos W=0.0975U L=0.065U
M180_keeper #109 #fb108# __o1f_53_6 Vdd pmos W=0.0975U L=0.065U
M181_keeper #110 #fb108# __o1f_53_6 GND nmos W=0.0975U L=0.065U
.ends
*---- end of process: Split<> -----
*
*---- act defproc: SplitTree7<> -----
* raw ports:  I.req I.t[0] I.t[1] I.t[2] I.t[3] I.f[0] I.f[1] I.f[2] I.f[3] O0.req O0.t[0] O0.t[1] O0.t[2] O0.t[3] O0.f[0] O0.f[1] O0.f[2] O0.f[3] O1.req O1.t[0] O1.t[1] O1.t[2] O1.t[3] O1.f[0] O1.f[1] O1.f[2] O1.f[3] O2.req O2.t[0] O2.t[1] O2.t[2] O2.t[3] O2.f[0] O2.f[1] O2.f[2] O2.f[3] O3.req O3.t[0] O3.t[1] O3.t[2] O3.t[3] O3.f[0] O3.f[1] O3.f[2] O3.f[3] O4.req O4.t[0] O4.t[1] O4.t[2] O4.t[3] O4.f[0] O4.f[1] O4.f[2] O4.f[3] O5.req O5.t[0] O5.t[1] O5.t[2] O5.t[3] O5.f[0] O5.f[1] O5.f[2] O5.f[3] O6.req O6.t[0] O6.t[1] O6.t[2] O6.t[3] O6.f[0] O6.f[1] O6.f[2] O6.f[3]
*
.subckt SplitTree7 I_areq I_at_50_6 I_at_51_6 I_at_52_6 I_at_53_6 I_af_50_6 I_af_51_6 I_af_52_6 I_af_53_6 O0_areq O0_at_50_6 O0_at_51_6 O0_at_52_6 O0_at_53_6 O0_af_50_6 O0_af_51_6 O0_af_52_6 O0_af_53_6 O1_areq O1_at_50_6 O1_at_51_6 O1_at_52_6 O1_at_53_6 O1_af_50_6 O1_af_51_6 O1_af_52_6 O1_af_53_6 O2_areq O2_at_50_6 O2_at_51_6 O2_at_52_6 O2_at_53_6 O2_af_50_6 O2_af_51_6 O2_af_52_6 O2_af_53_6 O3_areq O3_at_50_6 O3_at_51_6 O3_at_52_6 O3_at_53_6 O3_af_50_6 O3_af_51_6 O3_af_52_6 O3_af_53_6 O4_areq O4_at_50_6 O4_at_51_6 O4_at_52_6 O4_at_53_6 O4_af_50_6 O4_af_51_6 O4_af_52_6 O4_af_53_6 O5_areq O5_at_50_6 O5_at_51_6 O5_at_52_6 O5_at_53_6 O5_af_50_6 O5_af_51_6 O5_af_52_6 O5_af_53_6 O6_areq O6_at_50_6 O6_at_51_6 O6_at_52_6 O6_at_53_6 O6_af_50_6 O6_af_51_6 O6_af_52_6 O6_af_53_6
*.PININFO I_areq:O I_at_50_6:I I_at_51_6:I I_at_52_6:I I_at_53_6:I I_af_50_6:I I_af_51_6:I I_af_52_6:I I_af_53_6:I O0_areq:I O0_at_50_6:O O0_at_51_6:O O0_at_52_6:O O0_at_53_6:O O0_af_50_6:O O0_af_51_6:O O0_af_52_6:O O0_af_53_6:O O1_areq:I O1_at_50_6:O O1_at_51_6:O O1_at_52_6:O O1_at_53_6:O O1_af_50_6:O O1_af_51_6:O O1_af_52_6:O O1_af_53_6:O O2_areq:I O2_at_50_6:O O2_at_51_6:O O2_at_52_6:O O2_at_53_6:O O2_af_50_6:O O2_af_51_6:O O2_af_52_6:O O2_af_53_6:O O3_areq:I O3_at_50_6:O O3_at_51_6:O O3_at_52_6:O O3_at_53_6:O O3_af_50_6:O O3_af_51_6:O O3_af_52_6:O O3_af_53_6:O O4_areq:I O4_at_50_6:O O4_at_51_6:O O4_at_52_6:O O4_at_53_6:O O4_af_50_6:O O4_af_51_6:O O4_af_52_6:O O4_af_53_6:O O5_areq:I O5_at_50_6:O O5_at_51_6:O O5_at_52_6:O O5_at_53_6:O O5_af_50_6:O O5_af_51_6:O O5_af_52_6:O O5_af_53_6:O O6_areq:I O6_at_50_6:O O6_at_51_6:O O6_at_52_6:O O6_at_53_6:O O6_af_50_6:O O6_af_51_6:O O6_af_52_6:O O6_af_53_6:O
*.POWER VDD Vdd
*.POWER GND GND
*.POWER NSUB GND
*.POWER PSUB Vdd
xhi hi_aI_areq hi_aI_at_50_6 hi_aI_at_51_6 hi_aI_at_52_6 hi_aI_at_53_6 hi_aI_af_50_6 hi_aI_af_51_6 hi_aI_af_52_6 hi_aI_af_53_6 hi_aO0_areq hi_aO0_at_50_6 hi_aO0_at_51_6 hi_aO0_at_52_6 hi_aO0_at_53_6 hi_aO0_af_50_6 hi_aO0_af_51_6 hi_aO0_af_52_6 hi_aO0_af_53_6 hi_aO1_areq hi_aO1_at_50_6 hi_aO1_at_51_6 hi_aO1_at_52_6 hi_aO1_at_53_6 hi_aO1_af_50_6 hi_aO1_af_51_6 hi_aO1_af_52_6 hi_aO1_af_53_6 Split
xs32 lo_aO0_areq lo_aO0_at_50_6 lo_aO0_at_51_6 lo_aO0_at_52_6 lo_aO0_at_53_6 lo_aO0_af_50_6 lo_aO0_af_51_6 lo_aO0_af_52_6 lo_aO0_af_53_6 O2_areq O2_at_50_6 O2_at_51_6 O2_at_52_6 O2_at_53_6 O2_af_50_6 O2_af_51_6 O2_af_52_6 O2_af_53_6 O1_areq O1_at_50_6 O1_at_51_6 O1_at_52_6 O1_at_53_6 O1_af_50_6 O1_af_51_6 O1_af_52_6 O1_af_53_6 Split
xlo lo_aI_areq lo_aI_at_50_6 lo_aI_at_51_6 lo_aI_at_52_6 lo_aI_at_53_6 lo_aI_af_50_6 lo_aI_af_51_6 lo_aI_af_52_6 lo_aI_af_53_6 lo_aO0_areq lo_aO0_at_50_6 lo_aO0_at_51_6 lo_aO0_at_52_6 lo_aO0_at_53_6 lo_aO0_af_50_6 lo_aO0_af_51_6 lo_aO0_af_52_6 lo_aO0_af_53_6 O0_areq O0_at_50_6 O0_at_51_6 O0_at_52_6 O0_at_53_6 O0_af_50_6 O0_af_51_6 O0_af_52_6 O0_af_53_6 Split
xroot I_areq I_at_50_6 I_at_51_6 I_at_52_6 I_at_53_6 I_af_50_6 I_af_51_6 I_af_52_6 I_af_53_6 hi_aI_areq hi_aI_at_50_6 hi_aI_at_51_6 hi_aI_at_52_6 hi_aI_at_53_6 hi_aI_af_50_6 hi_aI_af_51_6 hi_aI_af_52_6 hi_aI_af_53_6 lo_aI_areq lo_aI_at_50_6 lo_aI_at_51_6 lo_aI_at_52_6 lo_aI_at_53_6 lo_aI_af_50_6 lo_aI_af_51_6 lo_aI_af_52_6 lo_aI_af_53_6 Split
xs54 hi_aO1_areq hi_aO1_at_50_6 hi_aO1_at_51_6 hi_aO1_at_52_6 hi_aO1_at_53_6 hi_aO1_af_50_6 hi_aO1_af_51_6 hi_aO1_af_52_6 hi_aO1_af_53_6 O4_areq O4_at_50_6 O4_at_51_6 O4_at_52_6 O4_at_53_6 O4_af_50_6 O4_af_51_6 O4_af_52_6 O4_af_53_6 O3_areq O3_at_50_6 O3_at_51_6 O3_at_52_6 O3_at_53_6 O3_af_50_6 O3_af_51_6 O3_af_52_6 O3_af_53_6 Split
xs76 hi_aO0_areq hi_aO0_at_50_6 hi_aO0_at_51_6 hi_aO0_at_52_6 hi_aO0_at_53_6 hi_aO0_af_50_6 hi_aO0_af_51_6 hi_aO0_af_52_6 hi_aO0_af_53_6 O6_areq O6_at_50_6 O6_at_51_6 O6_at_52_6 O6_at_53_6 O6_af_50_6 O6_af_51_6 O6_af_52_6 O6_af_53_6 O5_areq O5_at_50_6 O5_at_51_6 O5_at_52_6 O5_at_53_6 O5_af_50_6 O5_af_51_6 O5_af_52_6 O5_af_53_6 Split
.ends
*---- end of process: SplitTree7<> -----
*
*---- act defproc: Deserializer<> -----
* raw ports:  reset I.t[0] I.t[1] I.t[2] I.t[3] I.f[0] I.f[1] I.f[2] I.f[3] I.a O.t[0] O.t[1] O.t[2] O.t[3] O.t[4] O.t[5] O.t[6] O.t[7] O.t[8] O.t[9] O.t[10] O.t[11] O.t[12] O.t[13] O.t[14] O.t[15] O.t[16] O.t[17] O.t[18] O.t[19] O.t[20] O.t[21] O.t[22] O.t[23] O.t[24] O.t[25] O.t[26] O.t[27] O.t[28] O.t[29] O.t[30] O.t[31] O.f[0] O.f[1] O.f[2] O.f[3] O.f[4] O.f[5] O.f[6] O.f[7] O.f[8] O.f[9] O.f[10] O.f[11] O.f[12] O.f[13] O.f[14] O.f[15] O.f[16] O.f[17] O.f[18] O.f[19] O.f[20] O.f[21] O.f[22] O.f[23] O.f[24] O.f[25] O.f[26] O.f[27] O.f[28] O.f[29] O.f[30] O.f[31] O.a
*
.subckt Deserializer reset I_at_50_6 I_at_51_6 I_at_52_6 I_at_53_6 I_af_50_6 I_af_51_6 I_af_52_6 I_af_53_6 I_aa O_at_50_6 O_at_51_6 O_at_52_6 O_at_53_6 O_at_54_6 O_at_55_6 O_at_56_6 O_at_57_6 O_at_58_6 O_at_59_6 O_at_510_6 O_at_511_6 O_at_512_6 O_at_513_6 O_at_514_6 O_at_515_6 O_at_516_6 O_at_517_6 O_at_518_6 O_at_519_6 O_at_520_6 O_at_521_6 O_at_522_6 O_at_523_6 O_at_524_6 O_at_525_6 O_at_526_6 O_at_527_6 O_at_528_6 O_at_529_6 O_at_530_6 O_at_531_6 O_af_50_6 O_af_51_6 O_af_52_6 O_af_53_6 O_af_54_6 O_af_55_6 O_af_56_6 O_af_57_6 O_af_58_6 O_af_59_6 O_af_510_6 O_af_511_6 O_af_512_6 O_af_513_6 O_af_514_6 O_af_515_6 O_af_516_6 O_af_517_6 O_af_518_6 O_af_519_6 O_af_520_6 O_af_521_6 O_af_522_6 O_af_523_6 O_af_524_6 O_af_525_6 O_af_526_6 O_af_527_6 O_af_528_6 O_af_529_6 O_af_530_6 O_af_531_6 O_aa
*.PININFO reset:I I_at_50_6:I I_at_51_6:I I_at_52_6:I I_at_53_6:I I_af_50_6:I I_af_51_6:I I_af_52_6:I I_af_53_6:I I_aa:O O_at_50_6:O O_at_51_6:O O_at_52_6:O O_at_53_6:O O_at_54_6:O O_at_55_6:O O_at_56_6:O O_at_57_6:O O_at_58_6:O O_at_59_6:O O_at_510_6:O O_at_511_6:O O_at_512_6:O O_at_513_6:O O_at_514_6:O O_at_515_6:O O_at_516_6:O O_at_517_6:O O_at_518_6:O O_at_519_6:O O_at_520_6:O O_at_521_6:O O_at_522_6:O O_at_523_6:O O_at_524_6:O O_at_525_6:O O_at_526_6:O O_at_527_6:O O_at_528_6:O O_at_529_6:O O_at_530_6:O O_at_531_6:O O_af_50_6:O O_af_51_6:O O_af_52_6:O O_af_53_6:O O_af_54_6:O O_af_55_6:O O_af_56_6:O O_af_57_6:O O_af_58_6:O O_af_59_6:O O_af_510_6:O O_af_511_6:O O_af_512_6:O O_af_513_6:O O_af_514_6:O O_af_515_6:O O_af_516_6:O O_af_517_6:O O_af_518_6:O O_af_519_6:O O_af_520_6:O O_af_521_6:O O_af_522_6:O O_af_523_6:O O_af_524_6:O O_af_525_6:O O_af_526_6:O O_af_527_6:O O_af_528_6:O O_af_529_6:O O_af_530_6:O O_af_531_6:O O_aa:I
*.POWER VDD Vdd
*.POWER GND GND
*.POWER NSUB GND
*.POWER PSUB Vdd
*
* --- node flags ---
*
* low__gnd (combinational)
*
* --- end node flags ---
*
M0_ GND Vdd low__gnd GND nmos W=0.0975U L=0.065U
xqb5 reset qb5_aI_areq qb5_aI_at_50_6 qb5_aI_at_51_6 qb5_aI_at_52_6 qb5_aI_at_53_6 qb5_aI_af_50_6 qb5_aI_af_51_6 qb5_aI_af_52_6 qb5_aI_af_53_6 O_at_520_6 O_at_521_6 O_at_522_6 O_at_523_6 O_af_520_6 O_af_521_6 O_af_522_6 O_af_523_6 O_aa qb4_aL_areq qb4_aL_aa qb5_aL_areq qb5_aL_aa QBuffer
xqb3 reset qb3_aI_areq qb3_aI_at_50_6 qb3_aI_at_51_6 qb3_aI_at_52_6 qb3_aI_at_53_6 qb3_aI_af_50_6 qb3_aI_af_51_6 qb3_aI_af_52_6 qb3_aI_af_53_6 O_at_512_6 O_at_513_6 O_at_514_6 O_at_515_6 O_af_512_6 O_af_513_6 O_af_514_6 O_af_515_6 O_aa qb2_aL_areq qb2_aL_aa qb3_aL_areq qb3_aL_aa QBuffer
xqb0 reset qb0_aI_af_50_6 low__gnd qb0_aI_af_50_6 low__gnd low__gnd qb0_aI_af_50_6 low__gnd qb0_aI_af_50_6 qb0_aI_af_50_6 O_at_50_6 O_at_51_6 O_at_52_6 O_at_53_6 O_af_50_6 O_af_51_6 O_af_52_6 O_af_53_6 O_aa qb0_aR_areq qb0_aR_aa qb0_aL_areq qb0_aL_aa QBuffer
xqb7 reset qb7_aI_areq qb7_aI_at_50_6 qb7_aI_at_51_6 qb7_aI_at_52_6 qb7_aI_at_53_6 qb7_aI_af_50_6 qb7_aI_af_51_6 qb7_aI_af_52_6 qb7_aI_af_53_6 O_at_528_6 O_at_529_6 O_at_530_6 O_at_531_6 O_af_528_6 O_af_529_6 O_af_530_6 O_af_531_6 O_aa qb6_aL_areq qb6_aL_aa qb7_aL_areq qb7_aL_aa QBuffer
xqb4 reset qb4_aI_areq qb4_aI_at_50_6 qb4_aI_at_51_6 qb4_aI_at_52_6 qb4_aI_at_53_6 qb4_aI_af_50_6 qb4_aI_af_51_6 qb4_aI_af_52_6 qb4_aI_af_53_6 O_at_516_6 O_at_517_6 O_at_518_6 O_at_519_6 O_af_516_6 O_af_517_6 O_af_518_6 O_af_519_6 O_aa qb3_aL_areq qb3_aL_aa qb4_aL_areq qb4_aL_aa QBuffer
xanalyzer reset I_at_50_6 I_at_51_6 I_at_52_6 I_at_53_6 I_af_50_6 I_af_51_6 I_af_52_6 I_af_53_6 I_aa split_aI_areq split_aI_at_50_6 split_aI_at_51_6 split_aI_at_52_6 split_aI_at_53_6 split_aI_af_50_6 split_aI_af_51_6 split_aI_af_52_6 split_aI_af_53_6 qb7_aL_areq qb7_aL_aa qb0_aR_areq qb0_aR_aa InputAnalyzer
xqb1 reset qb1_aI_areq qb1_aI_at_50_6 qb1_aI_at_51_6 qb1_aI_at_52_6 qb1_aI_at_53_6 qb1_aI_af_50_6 qb1_aI_af_51_6 qb1_aI_af_52_6 qb1_aI_af_53_6 O_at_54_6 O_at_55_6 O_at_56_6 O_at_57_6 O_af_54_6 O_af_55_6 O_af_56_6 O_af_57_6 O_aa qb0_aL_areq qb0_aL_aa qb1_aL_areq qb1_aL_aa QBuffer
xqb2 reset qb2_aI_areq qb2_aI_at_50_6 qb2_aI_at_51_6 qb2_aI_at_52_6 qb2_aI_at_53_6 qb2_aI_af_50_6 qb2_aI_af_51_6 qb2_aI_af_52_6 qb2_aI_af_53_6 O_at_58_6 O_at_59_6 O_at_510_6 O_at_511_6 O_af_58_6 O_af_59_6 O_af_510_6 O_af_511_6 O_aa qb1_aL_areq qb1_aL_aa qb2_aL_areq qb2_aL_aa QBuffer
xqb6 reset qb6_aI_areq qb6_aI_at_50_6 qb6_aI_at_51_6 qb6_aI_at_52_6 qb6_aI_at_53_6 qb6_aI_af_50_6 qb6_aI_af_51_6 qb6_aI_af_52_6 qb6_aI_af_53_6 O_at_524_6 O_at_525_6 O_at_526_6 O_at_527_6 O_af_524_6 O_af_525_6 O_af_526_6 O_af_527_6 O_aa qb5_aL_areq qb5_aL_aa qb6_aL_areq qb6_aL_aa QBuffer
xsplit split_aI_areq split_aI_at_50_6 split_aI_at_51_6 split_aI_at_52_6 split_aI_at_53_6 split_aI_af_50_6 split_aI_af_51_6 split_aI_af_52_6 split_aI_af_53_6 qb1_aI_areq qb1_aI_at_50_6 qb1_aI_at_51_6 qb1_aI_at_52_6 qb1_aI_at_53_6 qb1_aI_af_50_6 qb1_aI_af_51_6 qb1_aI_af_52_6 qb1_aI_af_53_6 qb2_aI_areq qb2_aI_at_50_6 qb2_aI_at_51_6 qb2_aI_at_52_6 qb2_aI_at_53_6 qb2_aI_af_50_6 qb2_aI_af_51_6 qb2_aI_af_52_6 qb2_aI_af_53_6 qb3_aI_areq qb3_aI_at_50_6 qb3_aI_at_51_6 qb3_aI_at_52_6 qb3_aI_at_53_6 qb3_aI_af_50_6 qb3_aI_af_51_6 qb3_aI_af_52_6 qb3_aI_af_53_6 qb4_aI_areq qb4_aI_at_50_6 qb4_aI_at_51_6 qb4_aI_at_52_6 qb4_aI_at_53_6 qb4_aI_af_50_6 qb4_aI_af_51_6 qb4_aI_af_52_6 qb4_aI_af_53_6 qb5_aI_areq qb5_aI_at_50_6 qb5_aI_at_51_6 qb5_aI_at_52_6 qb5_aI_at_53_6 qb5_aI_af_50_6 qb5_aI_af_51_6 qb5_aI_af_52_6 qb5_aI_af_53_6 qb6_aI_areq qb6_aI_at_50_6 qb6_aI_at_51_6 qb6_aI_at_52_6 qb6_aI_at_53_6 qb6_aI_af_50_6 qb6_aI_af_51_6 qb6_aI_af_52_6 qb6_aI_af_53_6 qb7_aI_areq qb7_aI_at_50_6 qb7_aI_at_51_6 qb7_aI_at_52_6 qb7_aI_at_53_6 qb7_aI_af_50_6 qb7_aI_af_51_6 qb7_aI_af_52_6 qb7_aI_af_53_6 SplitTree7
.ends
*---- end of process: Deserializer<> -----
*
*---- act defproc: Reg8<> -----
* raw ports:  reset W.t[0] W.t[1] W.t[2] W.t[3] W.t[4] W.t[5] W.t[6] W.t[7] W.f[0] W.f[1] W.f[2] W.f[3] W.f[4] W.f[5] W.f[6] W.f[7] W.a R.req R.t[0] R.t[1] R.t[2] R.t[3] R.t[4] R.t[5] R.t[6] R.t[7] R.f[0] R.f[1] R.f[2] R.f[3] R.f[4] R.f[5] R.f[6] R.f[7]
*
.subckt Reg8 reset W_at_50_6 W_at_51_6 W_at_52_6 W_at_53_6 W_at_54_6 W_at_55_6 W_at_56_6 W_at_57_6 W_af_50_6 W_af_51_6 W_af_52_6 W_af_53_6 W_af_54_6 W_af_55_6 W_af_56_6 W_af_57_6 W_aa R_areq R_at_50_6 R_at_51_6 R_at_52_6 R_at_53_6 R_at_54_6 R_at_55_6 R_at_56_6 R_at_57_6 R_af_50_6 R_af_51_6 R_af_52_6 R_af_53_6 R_af_54_6 R_af_55_6 R_af_56_6 R_af_57_6
*.PININFO reset:I W_at_50_6:I W_at_51_6:I W_at_52_6:I W_at_53_6:I W_at_54_6:I W_at_55_6:I W_at_56_6:I W_at_57_6:I W_af_50_6:I W_af_51_6:I W_af_52_6:I W_af_53_6:I W_af_54_6:I W_af_55_6:I W_af_56_6:I W_af_57_6:I W_aa:O R_areq:I R_at_50_6:O R_at_51_6:O R_at_52_6:O R_at_53_6:O R_at_54_6:O R_at_55_6:O R_at_56_6:O R_at_57_6:O R_af_50_6:O R_af_51_6:O R_af_52_6:O R_af_53_6:O R_af_54_6:O R_af_55_6:O R_af_56_6:O R_af_57_6:O
*.POWER VDD Vdd
*.POWER GND GND
*.POWER NSUB GND
*.POWER PSUB Vdd
*
* --- node flags ---
*
* __p__a (state-holding): pup_reff=6.4; pdn_reff=10.6667
* x_57_6 (state-holding): pup_reff=0.4; pdn_reff=0.666667
* __x_57_6 (combinational)
* x_56_6 (state-holding): pup_reff=0.4; pdn_reff=0.666667
* __x_56_6 (combinational)
* x_55_6 (state-holding): pup_reff=0.4; pdn_reff=0.666667
* __x_55_6 (combinational)
* x_54_6 (state-holding): pup_reff=0.4; pdn_reff=0.666667
* __x_54_6 (combinational)
* x_53_6 (state-holding): pup_reff=0.4; pdn_reff=0.666667
* __x_53_6 (combinational)
* x_52_6 (state-holding): pup_reff=0.4; pdn_reff=0.666667
* __x_52_6 (combinational)
* x_51_6 (state-holding): pup_reff=0.4; pdn_reff=0.666667
* __x_51_6 (combinational)
* x_50_6 (state-holding): pup_reff=0.4; pdn_reff=0.666667
* __x_50_6 (combinational)
* __pt_50_6 (combinational)
* R_at_50_6 (state-holding): pup_reff=0.8; pdn_reff=0.666667
* __qr (combinational)
* R_af_50_6 (state-holding): pup_reff=0.8; pdn_reff=0.666667
* __pt_51_6 (combinational)
* R_at_51_6 (state-holding): pup_reff=0.8; pdn_reff=0.666667
* R_af_51_6 (state-holding): pup_reff=0.8; pdn_reff=0.666667
* __pt_52_6 (combinational)
* R_at_52_6 (state-holding): pup_reff=0.8; pdn_reff=0.666667
* R_af_52_6 (state-holding): pup_reff=0.8; pdn_reff=0.666667
* __pt_53_6 (combinational)
* R_at_53_6 (state-holding): pup_reff=0.8; pdn_reff=0.666667
* R_af_53_6 (state-holding): pup_reff=0.8; pdn_reff=0.666667
* __pt_54_6 (combinational)
* R_at_54_6 (state-holding): pup_reff=0.8; pdn_reff=0.666667
* R_af_54_6 (state-holding): pup_reff=0.8; pdn_reff=0.666667
* __pt_55_6 (combinational)
* R_at_55_6 (state-holding): pup_reff=0.8; pdn_reff=0.666667
* R_af_55_6 (state-holding): pup_reff=0.8; pdn_reff=0.666667
* __pt_56_6 (combinational)
* R_at_56_6 (state-holding): pup_reff=0.8; pdn_reff=0.666667
* R_af_56_6 (state-holding): pup_reff=0.8; pdn_reff=0.666667
* __pt_57_6 (combinational)
* R_at_57_6 (state-holding): pup_reff=0.8; pdn_reff=0.666667
* R_af_57_6 (state-holding): pup_reff=0.8; pdn_reff=0.666667
* W_aa (combinational)
*
* --- end node flags ---
*
M0_ Vdd W_at_57_6 #65 Vdd pmos W=0.1625U L=0.065U
M1_ Vdd __pt_50_6 x_50_6 Vdd pmos W=0.1625U L=0.065U
M2_ Vdd __qr #76 Vdd pmos W=0.1625U L=0.065U
M3_ Vdd __qr #79 Vdd pmos W=0.1625U L=0.065U
M4_ Vdd __pt_51_6 x_51_6 Vdd pmos W=0.1625U L=0.065U
M5_ Vdd __qr #82 Vdd pmos W=0.1625U L=0.065U
M6_ Vdd __qr #84 Vdd pmos W=0.1625U L=0.065U
M7_ Vdd __pt_52_6 x_52_6 Vdd pmos W=0.1625U L=0.065U
M8_ Vdd __qr #87 Vdd pmos W=0.1625U L=0.065U
M9_ Vdd __qr #89 Vdd pmos W=0.1625U L=0.065U
M10_ Vdd __pt_53_6 x_53_6 Vdd pmos W=0.1625U L=0.065U
M11_ Vdd __qr #92 Vdd pmos W=0.1625U L=0.065U
M12_ Vdd __qr #94 Vdd pmos W=0.1625U L=0.065U
M13_ Vdd __pt_54_6 x_54_6 Vdd pmos W=0.1625U L=0.065U
M14_ Vdd __qr #97 Vdd pmos W=0.1625U L=0.065U
M15_ Vdd __qr #99 Vdd pmos W=0.1625U L=0.065U
M16_ Vdd __pt_55_6 x_55_6 Vdd pmos W=0.1625U L=0.065U
M17_ Vdd __qr #102 Vdd pmos W=0.1625U L=0.065U
M18_ Vdd __qr #104 Vdd pmos W=0.1625U L=0.065U
M19_ Vdd __pt_56_6 x_56_6 Vdd pmos W=0.1625U L=0.065U
M20_ Vdd __qr #107 Vdd pmos W=0.1625U L=0.065U
M21_ Vdd __qr #109 Vdd pmos W=0.1625U L=0.065U
M22_ Vdd __pt_57_6 x_57_6 Vdd pmos W=0.1625U L=0.065U
M23_ Vdd __qr #112 Vdd pmos W=0.1625U L=0.065U
M24_ Vdd __qr #114 Vdd pmos W=0.1625U L=0.065U
M25_ Vdd R_areq __qr Vdd pmos W=0.1625U L=0.065U
M26_ Vdd W_at_50_6 __pt_50_6 Vdd pmos W=0.1625U L=0.065U
M27_ Vdd x_50_6 __x_50_6 Vdd pmos W=0.1625U L=0.065U
M28_ Vdd W_at_51_6 __pt_51_6 Vdd pmos W=0.1625U L=0.065U
M29_ Vdd x_51_6 __x_51_6 Vdd pmos W=0.1625U L=0.065U
M30_ Vdd W_at_52_6 __pt_52_6 Vdd pmos W=0.1625U L=0.065U
M31_ Vdd x_52_6 __x_52_6 Vdd pmos W=0.1625U L=0.065U
M32_ Vdd W_at_53_6 __pt_53_6 Vdd pmos W=0.1625U L=0.065U
M33_ Vdd x_53_6 __x_53_6 Vdd pmos W=0.1625U L=0.065U
M34_ Vdd W_at_54_6 __pt_54_6 Vdd pmos W=0.1625U L=0.065U
M35_ Vdd x_54_6 __x_54_6 Vdd pmos W=0.1625U L=0.065U
M36_ Vdd W_at_55_6 __pt_55_6 Vdd pmos W=0.1625U L=0.065U
M37_ Vdd x_55_6 __x_55_6 Vdd pmos W=0.1625U L=0.065U
M38_ Vdd W_at_56_6 __pt_56_6 Vdd pmos W=0.1625U L=0.065U
M39_ Vdd x_56_6 __x_56_6 Vdd pmos W=0.1625U L=0.065U
M40_ Vdd W_at_57_6 __pt_57_6 Vdd pmos W=0.1625U L=0.065U
M41_ Vdd x_57_6 __x_57_6 Vdd pmos W=0.1625U L=0.065U
M42_ Vdd __p__a W_aa Vdd pmos W=0.1625U L=0.065U
M43_ Vdd __p__a #fb117# Vdd pmos W=0.1625U L=0.13U
M44_ Vdd x_57_6 #fb120# Vdd pmos W=0.1625U L=0.13U
M45_keeper Vdd GND #118 Vdd pmos W=0.0975U L=5.135U
M46_ Vdd x_56_6 #fb123# Vdd pmos W=0.1625U L=0.13U
M47_keeper Vdd GND #121 Vdd pmos W=0.0975U L=0.26U
M48_ Vdd x_55_6 #fb126# Vdd pmos W=0.1625U L=0.13U
M49_keeper Vdd GND #124 Vdd pmos W=0.0975U L=0.26U
M50_ Vdd x_54_6 #fb129# Vdd pmos W=0.1625U L=0.13U
M51_keeper Vdd GND #127 Vdd pmos W=0.0975U L=0.26U
M52_ Vdd x_53_6 #fb132# Vdd pmos W=0.1625U L=0.13U
M53_keeper Vdd GND #130 Vdd pmos W=0.0975U L=0.26U
M54_ Vdd x_52_6 #fb135# Vdd pmos W=0.1625U L=0.13U
M55_keeper Vdd GND #133 Vdd pmos W=0.0975U L=0.26U
M56_ Vdd x_51_6 #fb138# Vdd pmos W=0.1625U L=0.13U
M57_keeper Vdd GND #136 Vdd pmos W=0.0975U L=0.26U
M58_ Vdd x_50_6 #fb141# Vdd pmos W=0.1625U L=0.13U
M59_keeper Vdd GND #139 Vdd pmos W=0.0975U L=0.26U
M60_ Vdd R_at_50_6 #fb144# Vdd pmos W=0.1625U L=0.13U
M61_keeper Vdd GND #142 Vdd pmos W=0.0975U L=0.26U
M62_ Vdd R_af_50_6 #fb147# Vdd pmos W=0.1625U L=0.13U
M63_keeper Vdd GND #145 Vdd pmos W=0.0975U L=0.26U
M64_ Vdd R_at_51_6 #fb150# Vdd pmos W=0.1625U L=0.13U
M65_keeper Vdd GND #148 Vdd pmos W=0.0975U L=0.26U
M66_ Vdd R_af_51_6 #fb153# Vdd pmos W=0.1625U L=0.13U
M67_keeper Vdd GND #151 Vdd pmos W=0.0975U L=0.26U
M68_ Vdd R_at_52_6 #fb156# Vdd pmos W=0.1625U L=0.13U
M69_keeper Vdd GND #154 Vdd pmos W=0.0975U L=0.26U
M70_ Vdd R_af_52_6 #fb159# Vdd pmos W=0.1625U L=0.13U
M71_keeper Vdd GND #157 Vdd pmos W=0.0975U L=0.26U
M72_ Vdd R_at_53_6 #fb162# Vdd pmos W=0.1625U L=0.13U
M73_keeper Vdd GND #160 Vdd pmos W=0.0975U L=0.26U
M74_ Vdd R_af_53_6 #fb165# Vdd pmos W=0.1625U L=0.13U
M75_keeper Vdd GND #163 Vdd pmos W=0.0975U L=0.26U
M76_ Vdd R_at_54_6 #fb168# Vdd pmos W=0.1625U L=0.13U
M77_keeper Vdd GND #166 Vdd pmos W=0.0975U L=0.26U
M78_ Vdd R_af_54_6 #fb171# Vdd pmos W=0.1625U L=0.13U
M79_keeper Vdd GND #169 Vdd pmos W=0.0975U L=0.26U
M80_ Vdd R_at_55_6 #fb174# Vdd pmos W=0.1625U L=0.13U
M81_keeper Vdd GND #172 Vdd pmos W=0.0975U L=0.26U
M82_ Vdd R_af_55_6 #fb177# Vdd pmos W=0.1625U L=0.13U
M83_keeper Vdd GND #175 Vdd pmos W=0.0975U L=0.26U
M84_ Vdd R_at_56_6 #fb180# Vdd pmos W=0.1625U L=0.13U
M85_keeper Vdd GND #178 Vdd pmos W=0.0975U L=0.26U
M86_ Vdd R_af_56_6 #fb183# Vdd pmos W=0.1625U L=0.13U
M87_keeper Vdd GND #181 Vdd pmos W=0.0975U L=0.26U
M88_ Vdd R_at_57_6 #fb186# Vdd pmos W=0.1625U L=0.13U
M89_keeper Vdd GND #184 Vdd pmos W=0.0975U L=0.26U
M90_ Vdd R_af_57_6 #fb189# Vdd pmos W=0.1625U L=0.13U
M91_keeper Vdd GND #187 Vdd pmos W=0.0975U L=0.26U
M92_keeper Vdd GND #190 Vdd pmos W=0.0975U L=0.26U
M93_ GND W_at_57_6 #10 GND nmos W=0.0975U L=0.065U
M94_ GND W_af_57_6 #13 GND nmos W=0.0975U L=0.065U
M95_ GND W_af_50_6 x_50_6 GND nmos W=0.0975U L=0.065U
M96_ GND reset x_50_6 GND nmos W=0.0975U L=0.065U
M97_ GND __qr R_at_50_6 GND nmos W=0.0975U L=0.065U
M98_ GND __qr R_af_50_6 GND nmos W=0.0975U L=0.065U
M99_ GND W_af_51_6 x_51_6 GND nmos W=0.0975U L=0.065U
M100_ GND reset x_51_6 GND nmos W=0.0975U L=0.065U
M101_ GND __qr R_at_51_6 GND nmos W=0.0975U L=0.065U
M102_ GND __qr R_af_51_6 GND nmos W=0.0975U L=0.065U
M103_ GND W_af_52_6 x_52_6 GND nmos W=0.0975U L=0.065U
M104_ GND reset x_52_6 GND nmos W=0.0975U L=0.065U
M105_ GND __qr R_at_52_6 GND nmos W=0.0975U L=0.065U
M106_ GND __qr R_af_52_6 GND nmos W=0.0975U L=0.065U
M107_ GND W_af_53_6 x_53_6 GND nmos W=0.0975U L=0.065U
M108_ GND reset x_53_6 GND nmos W=0.0975U L=0.065U
M109_ GND __qr R_at_53_6 GND nmos W=0.0975U L=0.065U
M110_ GND __qr R_af_53_6 GND nmos W=0.0975U L=0.065U
M111_ GND W_af_54_6 x_54_6 GND nmos W=0.0975U L=0.065U
M112_ GND reset x_54_6 GND nmos W=0.0975U L=0.065U
M113_ GND __qr R_at_54_6 GND nmos W=0.0975U L=0.065U
M114_ GND __qr R_af_54_6 GND nmos W=0.0975U L=0.065U
M115_ GND W_af_55_6 x_55_6 GND nmos W=0.0975U L=0.065U
M116_ GND reset x_55_6 GND nmos W=0.0975U L=0.065U
M117_ GND __qr R_at_55_6 GND nmos W=0.0975U L=0.065U
M118_ GND __qr R_af_55_6 GND nmos W=0.0975U L=0.065U
M119_ GND W_af_56_6 x_56_6 GND nmos W=0.0975U L=0.065U
M120_ GND reset x_56_6 GND nmos W=0.0975U L=0.065U
M121_ GND __qr R_at_56_6 GND nmos W=0.0975U L=0.065U
M122_ GND __qr R_af_56_6 GND nmos W=0.0975U L=0.065U
M123_ GND W_af_57_6 x_57_6 GND nmos W=0.0975U L=0.065U
M124_ GND reset x_57_6 GND nmos W=0.0975U L=0.065U
M125_ GND __qr R_at_57_6 GND nmos W=0.0975U L=0.065U
M126_ GND __qr R_af_57_6 GND nmos W=0.0975U L=0.065U
M127_ GND R_areq __qr GND nmos W=0.0975U L=0.065U
M128_ GND W_at_50_6 __pt_50_6 GND nmos W=0.0975U L=0.065U
M129_ GND x_50_6 __x_50_6 GND nmos W=0.0975U L=0.065U
M130_ GND W_at_51_6 __pt_51_6 GND nmos W=0.0975U L=0.065U
M131_ GND x_51_6 __x_51_6 GND nmos W=0.0975U L=0.065U
M132_ GND W_at_52_6 __pt_52_6 GND nmos W=0.0975U L=0.065U
M133_ GND x_52_6 __x_52_6 GND nmos W=0.0975U L=0.065U
M134_ GND W_at_53_6 __pt_53_6 GND nmos W=0.0975U L=0.065U
M135_ GND x_53_6 __x_53_6 GND nmos W=0.0975U L=0.065U
M136_ GND W_at_54_6 __pt_54_6 GND nmos W=0.0975U L=0.065U
M137_ GND x_54_6 __x_54_6 GND nmos W=0.0975U L=0.065U
M138_ GND W_at_55_6 __pt_55_6 GND nmos W=0.0975U L=0.065U
M139_ GND x_55_6 __x_55_6 GND nmos W=0.0975U L=0.065U
M140_ GND W_at_56_6 __pt_56_6 GND nmos W=0.0975U L=0.065U
M141_ GND x_56_6 __x_56_6 GND nmos W=0.0975U L=0.065U
M142_ GND W_at_57_6 __pt_57_6 GND nmos W=0.0975U L=0.065U
M143_ GND x_57_6 __x_57_6 GND nmos W=0.0975U L=0.065U
M144_ GND __p__a W_aa GND nmos W=0.0975U L=0.065U
M145_ GND __p__a #fb117# GND nmos W=0.0975U L=0.13U
M146_ GND x_57_6 #fb120# GND nmos W=0.0975U L=0.13U
M147_keeper GND Vdd #119 GND nmos W=0.0975U L=12.415U
M148_ GND x_56_6 #fb123# GND nmos W=0.0975U L=0.13U
M149_keeper GND Vdd #122 GND nmos W=0.0975U L=0.715U
M150_ GND x_55_6 #fb126# GND nmos W=0.0975U L=0.13U
M151_keeper GND Vdd #125 GND nmos W=0.0975U L=0.715U
M152_ GND x_54_6 #fb129# GND nmos W=0.0975U L=0.13U
M153_keeper GND Vdd #128 GND nmos W=0.0975U L=0.715U
M154_ GND x_53_6 #fb132# GND nmos W=0.0975U L=0.13U
M155_keeper GND Vdd #131 GND nmos W=0.0975U L=0.715U
M156_ GND x_52_6 #fb135# GND nmos W=0.0975U L=0.13U
M157_keeper GND Vdd #134 GND nmos W=0.0975U L=0.715U
M158_ GND x_51_6 #fb138# GND nmos W=0.0975U L=0.13U
M159_keeper GND Vdd #137 GND nmos W=0.0975U L=0.715U
M160_ GND x_50_6 #fb141# GND nmos W=0.0975U L=0.13U
M161_keeper GND Vdd #140 GND nmos W=0.0975U L=0.715U
M162_ GND R_at_50_6 #fb144# GND nmos W=0.0975U L=0.13U
M163_keeper GND Vdd #143 GND nmos W=0.0975U L=0.715U
M164_ GND R_af_50_6 #fb147# GND nmos W=0.0975U L=0.13U
M165_keeper GND Vdd #146 GND nmos W=0.0975U L=1.495U
M166_ GND R_at_51_6 #fb150# GND nmos W=0.0975U L=0.13U
M167_keeper GND Vdd #149 GND nmos W=0.0975U L=1.495U
M168_ GND R_af_51_6 #fb153# GND nmos W=0.0975U L=0.13U
M169_keeper GND Vdd #152 GND nmos W=0.0975U L=1.495U
M170_ GND R_at_52_6 #fb156# GND nmos W=0.0975U L=0.13U
M171_keeper GND Vdd #155 GND nmos W=0.0975U L=1.495U
M172_ GND R_af_52_6 #fb159# GND nmos W=0.0975U L=0.13U
M173_keeper GND Vdd #158 GND nmos W=0.0975U L=1.495U
M174_ GND R_at_53_6 #fb162# GND nmos W=0.0975U L=0.13U
M175_keeper GND Vdd #161 GND nmos W=0.0975U L=1.495U
M176_ GND R_af_53_6 #fb165# GND nmos W=0.0975U L=0.13U
M177_keeper GND Vdd #164 GND nmos W=0.0975U L=1.495U
M178_ GND R_at_54_6 #fb168# GND nmos W=0.0975U L=0.13U
M179_keeper GND Vdd #167 GND nmos W=0.0975U L=1.495U
M180_ GND R_af_54_6 #fb171# GND nmos W=0.0975U L=0.13U
M181_keeper GND Vdd #170 GND nmos W=0.0975U L=1.495U
M182_ GND R_at_55_6 #fb174# GND nmos W=0.0975U L=0.13U
M183_keeper GND Vdd #173 GND nmos W=0.0975U L=1.495U
M184_ GND R_af_55_6 #fb177# GND nmos W=0.0975U L=0.13U
M185_keeper GND Vdd #176 GND nmos W=0.0975U L=1.495U
M186_ GND R_at_56_6 #fb180# GND nmos W=0.0975U L=0.13U
M187_keeper GND Vdd #179 GND nmos W=0.0975U L=1.495U
M188_ GND R_af_56_6 #fb183# GND nmos W=0.0975U L=0.13U
M189_keeper GND Vdd #182 GND nmos W=0.0975U L=1.495U
M190_ GND R_at_57_6 #fb186# GND nmos W=0.0975U L=0.13U
M191_keeper GND Vdd #185 GND nmos W=0.0975U L=1.495U
M192_ GND R_af_57_6 #fb189# GND nmos W=0.0975U L=0.13U
M193_keeper GND Vdd #188 GND nmos W=0.0975U L=1.495U
M194_keeper GND Vdd #191 GND nmos W=0.0975U L=1.495U
M195_ #52 x_50_6 __p__a GND nmos W=0.0975U L=0.065U
M196_ #55 __x_50_6 __p__a GND nmos W=0.0975U L=0.065U
M197_ #72 W_af_50_6 __p__a Vdd pmos W=0.1625U L=0.065U
M198_keeper #118 #fb117# __p__a Vdd pmos W=0.0975U L=0.065U
M199_keeper #119 #fb117# __p__a GND nmos W=0.0975U L=0.065U
M200_ #46 x_51_6 #3 GND nmos W=0.0975U L=0.065U
M201_ #49 __x_51_6 #3 GND nmos W=0.0975U L=0.065U
M202_ #3 W_at_50_6 #52 GND nmos W=0.0975U L=0.065U
M203_ #3 W_af_50_6 #55 GND nmos W=0.0975U L=0.065U
M204_ #40 x_52_6 #4 GND nmos W=0.0975U L=0.065U
M205_ #43 __x_52_6 #4 GND nmos W=0.0975U L=0.065U
M206_ #4 W_at_51_6 #46 GND nmos W=0.0975U L=0.065U
M207_ #4 W_af_51_6 #49 GND nmos W=0.0975U L=0.065U
M208_ #34 x_53_6 #5 GND nmos W=0.0975U L=0.065U
M209_ #37 __x_53_6 #5 GND nmos W=0.0975U L=0.065U
M210_ #5 W_at_52_6 #40 GND nmos W=0.0975U L=0.065U
M211_ #5 W_af_52_6 #43 GND nmos W=0.0975U L=0.065U
M212_ #28 x_54_6 #6 GND nmos W=0.0975U L=0.065U
M213_ #31 __x_54_6 #6 GND nmos W=0.0975U L=0.065U
M214_ #6 W_at_53_6 #34 GND nmos W=0.0975U L=0.065U
M215_ #6 W_af_53_6 #37 GND nmos W=0.0975U L=0.065U
M216_ #22 x_55_6 #7 GND nmos W=0.0975U L=0.065U
M217_ #25 __x_55_6 #7 GND nmos W=0.0975U L=0.065U
M218_ #7 W_at_54_6 #28 GND nmos W=0.0975U L=0.065U
M219_ #7 W_af_54_6 #31 GND nmos W=0.0975U L=0.065U
M220_ #16 x_56_6 #8 GND nmos W=0.0975U L=0.065U
M221_ #19 __x_56_6 #8 GND nmos W=0.0975U L=0.065U
M222_ #8 W_at_55_6 #22 GND nmos W=0.0975U L=0.065U
M223_ #8 W_af_55_6 #25 GND nmos W=0.0975U L=0.065U
M224_ #10 x_57_6 #9 GND nmos W=0.0975U L=0.065U
M225_ #13 __x_57_6 #9 GND nmos W=0.0975U L=0.065U
M226_ #9 W_at_56_6 #16 GND nmos W=0.0975U L=0.065U
M227_ #9 W_af_56_6 #19 GND nmos W=0.0975U L=0.065U
M228_keeper #121 #fb120# x_57_6 Vdd pmos W=0.0975U L=0.065U
M229_keeper #122 #fb120# x_57_6 GND nmos W=0.0975U L=0.065U
M230_keeper #124 #fb123# x_56_6 Vdd pmos W=0.0975U L=0.065U
M231_keeper #125 #fb123# x_56_6 GND nmos W=0.0975U L=0.065U
M232_keeper #127 #fb126# x_55_6 Vdd pmos W=0.0975U L=0.065U
M233_keeper #128 #fb126# x_55_6 GND nmos W=0.0975U L=0.065U
M234_keeper #130 #fb129# x_54_6 Vdd pmos W=0.0975U L=0.065U
M235_keeper #131 #fb129# x_54_6 GND nmos W=0.0975U L=0.065U
M236_keeper #133 #fb132# x_53_6 Vdd pmos W=0.0975U L=0.065U
M237_keeper #134 #fb132# x_53_6 GND nmos W=0.0975U L=0.065U
M238_keeper #136 #fb135# x_52_6 Vdd pmos W=0.0975U L=0.065U
M239_keeper #137 #fb135# x_52_6 GND nmos W=0.0975U L=0.065U
M240_keeper #139 #fb138# x_51_6 Vdd pmos W=0.0975U L=0.065U
M241_keeper #140 #fb138# x_51_6 GND nmos W=0.0975U L=0.065U
M242_keeper #142 #fb141# x_50_6 Vdd pmos W=0.0975U L=0.065U
M243_keeper #143 #fb141# x_50_6 GND nmos W=0.0975U L=0.065U
M244_ #71 W_af_51_6 #58 Vdd pmos W=0.1625U L=0.065U
M245_ #58 W_at_50_6 #72 Vdd pmos W=0.1625U L=0.065U
M246_ #70 W_af_52_6 #59 Vdd pmos W=0.1625U L=0.065U
M247_ #59 W_at_51_6 #71 Vdd pmos W=0.1625U L=0.065U
M248_ #69 W_af_53_6 #60 Vdd pmos W=0.1625U L=0.065U
M249_ #60 W_at_52_6 #70 Vdd pmos W=0.1625U L=0.065U
M250_ #68 W_af_54_6 #61 Vdd pmos W=0.1625U L=0.065U
M251_ #61 W_at_53_6 #69 Vdd pmos W=0.1625U L=0.065U
M252_ #67 W_af_55_6 #62 Vdd pmos W=0.1625U L=0.065U
M253_ #62 W_at_54_6 #68 Vdd pmos W=0.1625U L=0.065U
M254_ #66 W_af_56_6 #63 Vdd pmos W=0.1625U L=0.065U
M255_ #63 W_at_55_6 #67 Vdd pmos W=0.1625U L=0.065U
M256_ #65 W_af_57_6 #64 Vdd pmos W=0.1625U L=0.065U
M257_ #64 W_at_56_6 #66 Vdd pmos W=0.1625U L=0.065U
M258_ #76 __x_50_6 R_at_50_6 Vdd pmos W=0.1625U L=0.065U
M259_keeper #145 #fb144# R_at_50_6 Vdd pmos W=0.0975U L=0.065U
M260_keeper #146 #fb144# R_at_50_6 GND nmos W=0.0975U L=0.065U
M261_ #79 x_50_6 R_af_50_6 Vdd pmos W=0.1625U L=0.065U
M262_keeper #148 #fb147# R_af_50_6 Vdd pmos W=0.0975U L=0.065U
M263_keeper #149 #fb147# R_af_50_6 GND nmos W=0.0975U L=0.065U
M264_ #82 __x_51_6 R_at_51_6 Vdd pmos W=0.1625U L=0.065U
M265_keeper #151 #fb150# R_at_51_6 Vdd pmos W=0.0975U L=0.065U
M266_keeper #152 #fb150# R_at_51_6 GND nmos W=0.0975U L=0.065U
M267_ #84 x_51_6 R_af_51_6 Vdd pmos W=0.1625U L=0.065U
M268_keeper #154 #fb153# R_af_51_6 Vdd pmos W=0.0975U L=0.065U
M269_keeper #155 #fb153# R_af_51_6 GND nmos W=0.0975U L=0.065U
M270_ #87 __x_52_6 R_at_52_6 Vdd pmos W=0.1625U L=0.065U
M271_keeper #157 #fb156# R_at_52_6 Vdd pmos W=0.0975U L=0.065U
M272_keeper #158 #fb156# R_at_52_6 GND nmos W=0.0975U L=0.065U
M273_ #89 x_52_6 R_af_52_6 Vdd pmos W=0.1625U L=0.065U
M274_keeper #160 #fb159# R_af_52_6 Vdd pmos W=0.0975U L=0.065U
M275_keeper #161 #fb159# R_af_52_6 GND nmos W=0.0975U L=0.065U
M276_ #92 __x_53_6 R_at_53_6 Vdd pmos W=0.1625U L=0.065U
M277_keeper #163 #fb162# R_at_53_6 Vdd pmos W=0.0975U L=0.065U
M278_keeper #164 #fb162# R_at_53_6 GND nmos W=0.0975U L=0.065U
M279_ #94 x_53_6 R_af_53_6 Vdd pmos W=0.1625U L=0.065U
M280_keeper #166 #fb165# R_af_53_6 Vdd pmos W=0.0975U L=0.065U
M281_keeper #167 #fb165# R_af_53_6 GND nmos W=0.0975U L=0.065U
M282_ #97 __x_54_6 R_at_54_6 Vdd pmos W=0.1625U L=0.065U
M283_keeper #169 #fb168# R_at_54_6 Vdd pmos W=0.0975U L=0.065U
M284_keeper #170 #fb168# R_at_54_6 GND nmos W=0.0975U L=0.065U
M285_ #99 x_54_6 R_af_54_6 Vdd pmos W=0.1625U L=0.065U
M286_keeper #172 #fb171# R_af_54_6 Vdd pmos W=0.0975U L=0.065U
M287_keeper #173 #fb171# R_af_54_6 GND nmos W=0.0975U L=0.065U
M288_ #102 __x_55_6 R_at_55_6 Vdd pmos W=0.1625U L=0.065U
M289_keeper #175 #fb174# R_at_55_6 Vdd pmos W=0.0975U L=0.065U
M290_keeper #176 #fb174# R_at_55_6 GND nmos W=0.0975U L=0.065U
M291_ #104 x_55_6 R_af_55_6 Vdd pmos W=0.1625U L=0.065U
M292_keeper #178 #fb177# R_af_55_6 Vdd pmos W=0.0975U L=0.065U
M293_keeper #179 #fb177# R_af_55_6 GND nmos W=0.0975U L=0.065U
M294_ #107 __x_56_6 R_at_56_6 Vdd pmos W=0.1625U L=0.065U
M295_keeper #181 #fb180# R_at_56_6 Vdd pmos W=0.0975U L=0.065U
M296_keeper #182 #fb180# R_at_56_6 GND nmos W=0.0975U L=0.065U
M297_ #109 x_56_6 R_af_56_6 Vdd pmos W=0.1625U L=0.065U
M298_keeper #184 #fb183# R_af_56_6 Vdd pmos W=0.0975U L=0.065U
M299_keeper #185 #fb183# R_af_56_6 GND nmos W=0.0975U L=0.065U
M300_ #112 __x_57_6 R_at_57_6 Vdd pmos W=0.1625U L=0.065U
M301_keeper #187 #fb186# R_at_57_6 Vdd pmos W=0.0975U L=0.065U
M302_keeper #188 #fb186# R_at_57_6 GND nmos W=0.0975U L=0.065U
M303_ #114 x_57_6 R_af_57_6 Vdd pmos W=0.1625U L=0.065U
M304_keeper #190 #fb189# R_af_57_6 Vdd pmos W=0.0975U L=0.065U
M305_keeper #191 #fb189# R_af_57_6 GND nmos W=0.0975U L=0.065U
.ends
*---- end of process: Reg8<> -----
*
*---- act defproc: FullAdder<> -----
* raw ports:  a.t a.f b.t b.f c.t c.f d.t d.f s.t s.f
*
.subckt FullAdder a_at a_af b_at b_af c_at c_af d_at d_af s_at s_af
*.PININFO a_at:I a_af:I b_at:I b_af:I c_at:I c_af:I d_at:O d_af:O s_at:O s_af:O
*.POWER VDD Vdd
*.POWER GND GND
*.POWER NSUB GND
*.POWER PSUB Vdd
*
* --- node flags ---
*
* __dt (state-holding): pup_reff=1.6; pdn_reff=1.33333
* __df (state-holding): pup_reff=1.6; pdn_reff=1.33333
* __st (state-holding): pup_reff=0.8; pdn_reff=2
* __sf (state-holding): pup_reff=0.8; pdn_reff=2
* d_at (combinational)
* d_af (combinational)
* s_at (combinational)
* s_af (combinational)
*
* --- end node flags ---
*
M0_ Vdd a_at #10 Vdd pmos W=0.1625U L=0.065U
M1_ Vdd a_at #19 Vdd pmos W=0.1625U L=0.065U
M2_ Vdd c_at #27 Vdd pmos W=0.1625U L=0.065U
M3_ Vdd c_at #35 Vdd pmos W=0.1625U L=0.065U
M4_ Vdd __dt d_at Vdd pmos W=0.1625U L=0.065U
M5_ Vdd __df d_af Vdd pmos W=0.1625U L=0.065U
M6_ Vdd __st s_at Vdd pmos W=0.1625U L=0.065U
M7_ Vdd __sf s_af Vdd pmos W=0.1625U L=0.065U
M8_ Vdd __dt #fb40# Vdd pmos W=0.1625U L=0.13U
M9_ Vdd __df #fb43# Vdd pmos W=0.1625U L=0.13U
M10_keeper Vdd GND #41 Vdd pmos W=0.0975U L=0.585U
M11_ Vdd __st #fb46# Vdd pmos W=0.1625U L=0.13U
M12_keeper Vdd GND #44 Vdd pmos W=0.0975U L=0.585U
M13_ Vdd __sf #fb49# Vdd pmos W=0.1625U L=0.13U
M14_keeper Vdd GND #47 Vdd pmos W=0.0975U L=0.91U
M15_keeper Vdd GND #50 Vdd pmos W=0.0975U L=0.91U
M16_ GND a_at #3 GND nmos W=0.0975U L=0.065U
M17_ GND a_at #6 GND nmos W=0.0975U L=0.065U
M18_ GND b_at #6 GND nmos W=0.0975U L=0.065U
M19_ GND a_af #14 GND nmos W=0.0975U L=0.065U
M20_ GND a_af #15 GND nmos W=0.0975U L=0.065U
M21_ GND b_af #15 GND nmos W=0.0975U L=0.065U
M22_ GND c_at #21 GND nmos W=0.0975U L=0.065U
M23_ GND c_af #24 GND nmos W=0.0975U L=0.065U
M24_ GND c_af #29 GND nmos W=0.0975U L=0.065U
M25_ GND c_at #32 GND nmos W=0.0975U L=0.065U
M26_ GND __dt d_at GND nmos W=0.0975U L=0.065U
M27_ GND __df d_af GND nmos W=0.0975U L=0.065U
M28_ GND __st s_at GND nmos W=0.0975U L=0.065U
M29_ GND __sf s_af GND nmos W=0.0975U L=0.065U
M30_ GND __dt #fb40# GND nmos W=0.0975U L=0.13U
M31_ GND __df #fb43# GND nmos W=0.0975U L=0.13U
M32_keeper GND Vdd #42 GND nmos W=0.0975U L=3.055U
M33_ GND __st #fb46# GND nmos W=0.0975U L=0.13U
M34_keeper GND Vdd #45 GND nmos W=0.0975U L=3.055U
M35_ GND __sf #fb49# GND nmos W=0.0975U L=0.13U
M36_keeper GND Vdd #48 GND nmos W=0.0975U L=1.495U
M37_keeper GND Vdd #51 GND nmos W=0.0975U L=1.495U
M38_ #3 b_at __dt GND nmos W=0.0975U L=0.065U
M39_ #6 c_at __dt GND nmos W=0.0975U L=0.065U
M40_ #8 b_af __dt Vdd pmos W=0.1625U L=0.065U
M41_keeper #41 #fb40# __dt Vdd pmos W=0.0975U L=0.065U
M42_keeper #42 #fb40# __dt GND nmos W=0.0975U L=0.065U
M43_ #9 b_at #8 Vdd pmos W=0.1625U L=0.065U
M44_ #10 a_af #9 Vdd pmos W=0.1625U L=0.065U
M45_ #14 b_af __df GND nmos W=0.0975U L=0.065U
M46_ #15 c_af __df GND nmos W=0.0975U L=0.065U
M47_ #17 b_af __df Vdd pmos W=0.1625U L=0.065U
M48_keeper #44 #fb43# __df Vdd pmos W=0.0975U L=0.065U
M49_keeper #45 #fb43# __df GND nmos W=0.0975U L=0.065U
M50_ #18 b_at #17 Vdd pmos W=0.1625U L=0.065U
M51_ #19 a_af #18 Vdd pmos W=0.1625U L=0.065U
M52_ #22 b_at __st GND nmos W=0.0975U L=0.065U
M53_ #23 b_af __st GND nmos W=0.0975U L=0.065U
M54_ #25 b_af __st GND nmos W=0.0975U L=0.065U
M55_ #26 b_at __st GND nmos W=0.0975U L=0.065U
M56_ #27 c_af __st Vdd pmos W=0.1625U L=0.065U
M57_keeper #47 #fb46# __st Vdd pmos W=0.0975U L=0.065U
M58_keeper #48 #fb46# __st GND nmos W=0.0975U L=0.065U
M59_ #21 a_at #22 GND nmos W=0.0975U L=0.065U
M60_ #21 a_af #23 GND nmos W=0.0975U L=0.065U
M61_ #24 a_at #25 GND nmos W=0.0975U L=0.065U
M62_ #24 a_af #26 GND nmos W=0.0975U L=0.065U
M63_ #30 b_at __sf GND nmos W=0.0975U L=0.065U
M64_ #31 b_af __sf GND nmos W=0.0975U L=0.065U
M65_ #33 b_af __sf GND nmos W=0.0975U L=0.065U
M66_ #34 b_at __sf GND nmos W=0.0975U L=0.065U
M67_ #35 c_af __sf Vdd pmos W=0.1625U L=0.065U
M68_keeper #50 #fb49# __sf Vdd pmos W=0.0975U L=0.065U
M69_keeper #51 #fb49# __sf GND nmos W=0.0975U L=0.065U
M70_ #29 a_at #30 GND nmos W=0.0975U L=0.065U
M71_ #29 a_af #31 GND nmos W=0.0975U L=0.065U
M72_ #32 a_at #33 GND nmos W=0.0975U L=0.065U
M73_ #32 a_af #34 GND nmos W=0.0975U L=0.065U
.ends
*---- end of process: FullAdder<> -----
*
*---- act defproc: HalfAdder<> -----
* raw ports:  a.t a.f b.t b.f d.t d.f s.t s.f
*
.subckt HalfAdder a_at a_af b_at b_af d_at d_af s_at s_af
*.PININFO a_at:I a_af:I b_at:I b_af:I d_at:O d_af:O s_at:O s_af:O
*.POWER VDD Vdd
*.POWER GND GND
*.POWER NSUB GND
*.POWER PSUB Vdd
*
* --- node flags ---
*
* __dt (state-holding): pup_reff=1.6; pdn_reff=1.33333
* __df (state-holding): pup_reff=1.6; pdn_reff=0.666667
* __st (state-holding): pup_reff=1.6; pdn_reff=1.33333
* __sf (state-holding): pup_reff=1.6; pdn_reff=1.33333
* d_at (combinational)
* d_af (combinational)
* s_at (combinational)
* s_af (combinational)
*
* --- end node flags ---
*
M0_ Vdd a_at #8 Vdd pmos W=0.1625U L=0.065U
M1_ Vdd a_at #14 Vdd pmos W=0.1625U L=0.065U
M2_ Vdd a_at #20 Vdd pmos W=0.1625U L=0.065U
M3_ Vdd a_at #26 Vdd pmos W=0.1625U L=0.065U
M4_ Vdd __dt d_at Vdd pmos W=0.1625U L=0.065U
M5_ Vdd __df d_af Vdd pmos W=0.1625U L=0.065U
M6_ Vdd __st s_at Vdd pmos W=0.1625U L=0.065U
M7_ Vdd __sf s_af Vdd pmos W=0.1625U L=0.065U
M8_ Vdd __dt #fb31# Vdd pmos W=0.1625U L=0.13U
M9_ Vdd __df #fb34# Vdd pmos W=0.1625U L=0.13U
M10_keeper Vdd GND #32 Vdd pmos W=0.0975U L=0.585U
M11_ Vdd __st #fb37# Vdd pmos W=0.1625U L=0.13U
M12_keeper Vdd GND #35 Vdd pmos W=0.0975U L=0.26U
M13_ Vdd __sf #fb40# Vdd pmos W=0.1625U L=0.13U
M14_keeper Vdd GND #38 Vdd pmos W=0.0975U L=0.585U
M15_keeper Vdd GND #41 Vdd pmos W=0.0975U L=0.585U
M16_ GND a_at #3 GND nmos W=0.0975U L=0.065U
M17_ GND a_af __df GND nmos W=0.0975U L=0.065U
M18_ GND b_af __df GND nmos W=0.0975U L=0.065U
M19_ GND a_at #16 GND nmos W=0.0975U L=0.065U
M20_ GND a_af #17 GND nmos W=0.0975U L=0.065U
M21_ GND a_at #22 GND nmos W=0.0975U L=0.065U
M22_ GND a_af #23 GND nmos W=0.0975U L=0.065U
M23_ GND __dt d_at GND nmos W=0.0975U L=0.065U
M24_ GND __df d_af GND nmos W=0.0975U L=0.065U
M25_ GND __st s_at GND nmos W=0.0975U L=0.065U
M26_ GND __sf s_af GND nmos W=0.0975U L=0.065U
M27_ GND __dt #fb31# GND nmos W=0.0975U L=0.13U
M28_ GND __df #fb34# GND nmos W=0.0975U L=0.13U
M29_keeper GND Vdd #33 GND nmos W=0.0975U L=3.055U
M30_ GND __st #fb37# GND nmos W=0.0975U L=0.13U
M31_keeper GND Vdd #36 GND nmos W=0.0975U L=3.055U
M32_ GND __sf #fb40# GND nmos W=0.0975U L=0.13U
M33_keeper GND Vdd #39 GND nmos W=0.0975U L=3.055U
M34_keeper GND Vdd #42 GND nmos W=0.0975U L=3.055U
M35_ #3 b_at __dt GND nmos W=0.0975U L=0.065U
M36_ #6 b_af __dt Vdd pmos W=0.1625U L=0.065U
M37_keeper #32 #fb31# __dt Vdd pmos W=0.0975U L=0.065U
M38_keeper #33 #fb31# __dt GND nmos W=0.0975U L=0.065U
M39_ #7 b_at #6 Vdd pmos W=0.1625U L=0.065U
M40_ #8 a_af #7 Vdd pmos W=0.1625U L=0.065U
M41_ #12 b_af __df Vdd pmos W=0.1625U L=0.065U
M42_keeper #35 #fb34# __df Vdd pmos W=0.0975U L=0.065U
M43_keeper #36 #fb34# __df GND nmos W=0.0975U L=0.065U
M44_ #13 b_at #12 Vdd pmos W=0.1625U L=0.065U
M45_ #14 a_af #13 Vdd pmos W=0.1625U L=0.065U
M46_ #16 b_af __st GND nmos W=0.0975U L=0.065U
M47_ #17 b_at __st GND nmos W=0.0975U L=0.065U
M48_ #18 b_af __st Vdd pmos W=0.1625U L=0.065U
M49_keeper #38 #fb37# __st Vdd pmos W=0.0975U L=0.065U
M50_keeper #39 #fb37# __st GND nmos W=0.0975U L=0.065U
M51_ #19 b_at #18 Vdd pmos W=0.1625U L=0.065U
M52_ #20 a_af #19 Vdd pmos W=0.1625U L=0.065U
M53_ #22 b_at __sf GND nmos W=0.0975U L=0.065U
M54_ #23 b_af __sf GND nmos W=0.0975U L=0.065U
M55_ #24 b_af __sf Vdd pmos W=0.1625U L=0.065U
M56_keeper #41 #fb40# __sf Vdd pmos W=0.0975U L=0.065U
M57_keeper #42 #fb40# __sf GND nmos W=0.0975U L=0.065U
M58_ #25 b_at #24 Vdd pmos W=0.1625U L=0.065U
M59_ #26 a_af #25 Vdd pmos W=0.1625U L=0.065U
.ends
*---- end of process: HalfAdder<> -----
*
*---- act defproc: CounterInc<> -----
* raw ports:  reset Sa.t[0] Sa.t[1] Sa.t[2] Sa.t[3] Sa.f[0] Sa.f[1] Sa.f[2] Sa.f[3] Sb.t[0] Sb.t[1] Sb.t[2] Sb.t[3] Sb.t[4] Sb.t[5] Sb.t[6] Sb.t[7] Sb.f[0] Sb.f[1] Sb.f[2] Sb.f[3] Sb.f[4] Sb.f[5] Sb.f[6] Sb.f[7] So.t[0] So.t[1] So.t[2] So.t[3] So.t[4] So.t[5] So.t[6] So.t[7] So.f[0] So.f[1] So.f[2] So.f[3] So.f[4] So.f[5] So.f[6] So.f[7]
*
.subckt CounterInc reset Sa_at_50_6 Sa_at_51_6 Sa_at_52_6 Sa_at_53_6 Sa_af_50_6 Sa_af_51_6 Sa_af_52_6 Sa_af_53_6 Sb_at_50_6 Sb_at_51_6 Sb_at_52_6 Sb_at_53_6 Sb_at_54_6 Sb_at_55_6 Sb_at_56_6 Sb_at_57_6 Sb_af_50_6 Sb_af_51_6 Sb_af_52_6 Sb_af_53_6 Sb_af_54_6 Sb_af_55_6 Sb_af_56_6 Sb_af_57_6 So_at_50_6 So_at_51_6 So_at_52_6 So_at_53_6 So_at_54_6 So_at_55_6 So_at_56_6 So_at_57_6 So_af_50_6 So_af_51_6 So_af_52_6 So_af_53_6 So_af_54_6 So_af_55_6 So_af_56_6 So_af_57_6
*.PININFO reset:I Sa_at_50_6:I Sa_at_51_6:I Sa_at_52_6:I Sa_at_53_6:I Sa_af_50_6:I Sa_af_51_6:I Sa_af_52_6:I Sa_af_53_6:I Sb_at_50_6:I Sb_at_51_6:I Sb_at_52_6:I Sb_at_53_6:I Sb_at_54_6:I Sb_at_55_6:I Sb_at_56_6:I Sb_at_57_6:I Sb_af_50_6:I Sb_af_51_6:I Sb_af_52_6:I Sb_af_53_6:I Sb_af_54_6:I Sb_af_55_6:I Sb_af_56_6:I Sb_af_57_6:I So_at_50_6:O So_at_51_6:O So_at_52_6:O So_at_53_6:O So_at_54_6:O So_at_55_6:O So_at_56_6:O So_at_57_6:O So_af_50_6:O So_af_51_6:O So_af_52_6:O So_af_53_6:O So_af_54_6:O So_af_55_6:O So_af_56_6:O So_af_57_6:O
*.POWER VDD Vdd
*.POWER GND GND
*.POWER NSUB GND
*.POWER PSUB Vdd
*
* --- node flags ---
*
* __jt_52_6 (combinational)
* acc2_aa_at (combinational)
* __jf_52_6 (combinational)
* acc2_aa_af (combinational)
* __jt_51_6 (combinational)
* acc1_aa_at (combinational)
* __jf_51_6 (combinational)
* acc1_aa_af (combinational)
* __jt_50_6 (combinational)
* acc0_aa_at (combinational)
* __jf_50_6 (combinational)
* acc0_aa_af (combinational)
* acc0_ac_at (combinational)
* acc0_ac_af (state-holding): pup_reff=1.6; pdn_reff=4
* acc3_aa_at (combinational)
* acc3_aa_af (state-holding): pup_reff=1.6; pdn_reff=4
* acc4_aa_at (combinational)
* acc4_aa_af (state-holding): pup_reff=1.6; pdn_reff=4
* acc5_aa_at (combinational)
* acc5_aa_af (state-holding): pup_reff=1.6; pdn_reff=4
* acc6_aa_at (combinational)
* acc6_aa_af (state-holding): pup_reff=1.6; pdn_reff=4
* acc7_aa_at (combinational)
* acc7_aa_af (state-holding): pup_reff=1.6; pdn_reff=4
*
* --- end node flags ---
*
M0_ Vdd acc2_aa_at __jt_52_6 Vdd pmos W=0.1625U L=0.065U
M1_ Vdd acc2_aa_af __jf_52_6 Vdd pmos W=0.1625U L=0.065U
M2_ Vdd acc1_aa_at __jt_51_6 Vdd pmos W=0.1625U L=0.065U
M3_ Vdd acc1_aa_af __jf_51_6 Vdd pmos W=0.1625U L=0.065U
M4_ Vdd acc0_aa_at __jt_50_6 Vdd pmos W=0.1625U L=0.065U
M5_ Vdd acc0_aa_af __jf_50_6 Vdd pmos W=0.1625U L=0.065U
M6_ Vdd __jt_52_6 #18 Vdd pmos W=0.1625U L=0.065U
M7_ Vdd __jf_52_6 #18 Vdd pmos W=0.1625U L=0.065U
M8_ Vdd __jt_52_6 #29 Vdd pmos W=0.1625U L=0.065U
M9_ Vdd __jf_52_6 #29 Vdd pmos W=0.1625U L=0.065U
M10_ Vdd __jt_52_6 #39 Vdd pmos W=0.1625U L=0.065U
M11_ Vdd __jf_52_6 #39 Vdd pmos W=0.1625U L=0.065U
M12_ Vdd __jt_52_6 #49 Vdd pmos W=0.1625U L=0.065U
M13_ Vdd __jf_52_6 #49 Vdd pmos W=0.1625U L=0.065U
M14_ Vdd __jt_52_6 #59 Vdd pmos W=0.1625U L=0.065U
M15_ Vdd __jf_52_6 #59 Vdd pmos W=0.1625U L=0.065U
M16_ Vdd __jt_52_6 #69 Vdd pmos W=0.1625U L=0.065U
M17_ Vdd __jf_52_6 #69 Vdd pmos W=0.1625U L=0.065U
M18_ Vdd acc0_ac_af #fb75# Vdd pmos W=0.1625U L=0.13U
M19_ Vdd acc3_aa_af #fb78# Vdd pmos W=0.1625U L=0.13U
M20_keeper Vdd GND #76 Vdd pmos W=0.0975U L=1.885U
M21_ Vdd acc4_aa_af #fb81# Vdd pmos W=0.1625U L=0.13U
M22_keeper Vdd GND #79 Vdd pmos W=0.0975U L=1.885U
M23_ Vdd acc5_aa_af #fb84# Vdd pmos W=0.1625U L=0.13U
M24_keeper Vdd GND #82 Vdd pmos W=0.0975U L=1.885U
M25_ Vdd acc6_aa_af #fb87# Vdd pmos W=0.1625U L=0.13U
M26_keeper Vdd GND #85 Vdd pmos W=0.0975U L=1.885U
M27_ Vdd acc7_aa_af #fb90# Vdd pmos W=0.1625U L=0.13U
M28_keeper Vdd GND #88 Vdd pmos W=0.0975U L=1.885U
M29_keeper Vdd GND #91 Vdd pmos W=0.0975U L=1.885U
M30_ GND acc2_aa_at __jt_52_6 GND nmos W=0.0975U L=0.065U
M31_ GND acc2_aa_af __jf_52_6 GND nmos W=0.0975U L=0.065U
M32_ GND acc1_aa_at __jt_51_6 GND nmos W=0.0975U L=0.065U
M33_ GND acc1_aa_af __jf_51_6 GND nmos W=0.0975U L=0.065U
M34_ GND acc0_aa_at __jt_50_6 GND nmos W=0.0975U L=0.065U
M35_ GND acc0_aa_af __jf_50_6 GND nmos W=0.0975U L=0.065U
M36_ GND Vdd acc0_ac_at GND nmos W=0.0975U L=0.065U
M37_ GND __jt_52_6 #24 GND nmos W=0.0975U L=0.065U
M38_ GND reset acc0_ac_af GND nmos W=0.0975U L=0.065U
M39_ GND Vdd acc3_aa_at GND nmos W=0.0975U L=0.065U
M40_ GND __jt_52_6 #34 GND nmos W=0.0975U L=0.065U
M41_ GND reset acc3_aa_af GND nmos W=0.0975U L=0.065U
M42_ GND Vdd acc4_aa_at GND nmos W=0.0975U L=0.065U
M43_ GND __jt_52_6 #44 GND nmos W=0.0975U L=0.065U
M44_ GND reset acc4_aa_af GND nmos W=0.0975U L=0.065U
M45_ GND Vdd acc5_aa_at GND nmos W=0.0975U L=0.065U
M46_ GND __jt_52_6 #54 GND nmos W=0.0975U L=0.065U
M47_ GND reset acc5_aa_af GND nmos W=0.0975U L=0.065U
M48_ GND Vdd acc6_aa_at GND nmos W=0.0975U L=0.065U
M49_ GND __jt_52_6 #64 GND nmos W=0.0975U L=0.065U
M50_ GND reset acc6_aa_af GND nmos W=0.0975U L=0.065U
M51_ GND Vdd acc7_aa_at GND nmos W=0.0975U L=0.065U
M52_ GND __jt_52_6 #74 GND nmos W=0.0975U L=0.065U
M53_ GND reset acc7_aa_af GND nmos W=0.0975U L=0.065U
M54_ GND acc0_ac_af #fb75# GND nmos W=0.0975U L=0.13U
M55_ GND acc3_aa_af #fb78# GND nmos W=0.0975U L=0.13U
M56_keeper GND Vdd #77 GND nmos W=0.0975U L=3.055U
M57_ GND acc4_aa_af #fb81# GND nmos W=0.0975U L=0.13U
M58_keeper GND Vdd #80 GND nmos W=0.0975U L=3.055U
M59_ GND acc5_aa_af #fb84# GND nmos W=0.0975U L=0.13U
M60_keeper GND Vdd #83 GND nmos W=0.0975U L=3.055U
M61_ GND acc6_aa_af #fb87# GND nmos W=0.0975U L=0.13U
M62_keeper GND Vdd #86 GND nmos W=0.0975U L=3.055U
M63_ GND acc7_aa_af #fb90# GND nmos W=0.0975U L=0.13U
M64_keeper GND Vdd #89 GND nmos W=0.0975U L=3.055U
M65_keeper GND Vdd #92 GND nmos W=0.0975U L=3.055U
M66_ #16 reset acc0_ac_af Vdd pmos W=0.1625U L=0.065U
M67_ #20 __jf_50_6 acc0_ac_af GND nmos W=0.0975U L=0.065U
M68_keeper #76 #fb75# acc0_ac_af Vdd pmos W=0.0975U L=0.065U
M69_keeper #77 #fb75# acc0_ac_af GND nmos W=0.0975U L=0.065U
M70_ #17 __jt_50_6 #16 Vdd pmos W=0.1625U L=0.065U
M71_ #17 __jf_50_6 #16 Vdd pmos W=0.1625U L=0.065U
M72_ #18 __jt_51_6 #17 Vdd pmos W=0.1625U L=0.065U
M73_ #18 __jf_51_6 #17 Vdd pmos W=0.1625U L=0.065U
M74_ #21 __jt_50_6 #20 GND nmos W=0.0975U L=0.065U
M75_ #22 __jf_51_6 #21 GND nmos W=0.0975U L=0.065U
M76_ #23 __jt_51_6 #22 GND nmos W=0.0975U L=0.065U
M77_ #24 __jf_52_6 #23 GND nmos W=0.0975U L=0.065U
M78_ #27 reset acc3_aa_af Vdd pmos W=0.1625U L=0.065U
M79_ #30 __jf_50_6 acc3_aa_af GND nmos W=0.0975U L=0.065U
M80_keeper #79 #fb78# acc3_aa_af Vdd pmos W=0.0975U L=0.065U
M81_keeper #80 #fb78# acc3_aa_af GND nmos W=0.0975U L=0.065U
M82_ #28 __jt_50_6 #27 Vdd pmos W=0.1625U L=0.065U
M83_ #28 __jf_50_6 #27 Vdd pmos W=0.1625U L=0.065U
M84_ #29 __jt_51_6 #28 Vdd pmos W=0.1625U L=0.065U
M85_ #29 __jf_51_6 #28 Vdd pmos W=0.1625U L=0.065U
M86_ #31 __jt_50_6 #30 GND nmos W=0.0975U L=0.065U
M87_ #32 __jf_51_6 #31 GND nmos W=0.0975U L=0.065U
M88_ #33 __jt_51_6 #32 GND nmos W=0.0975U L=0.065U
M89_ #34 __jf_52_6 #33 GND nmos W=0.0975U L=0.065U
M90_ #37 reset acc4_aa_af Vdd pmos W=0.1625U L=0.065U
M91_ #40 __jf_50_6 acc4_aa_af GND nmos W=0.0975U L=0.065U
M92_keeper #82 #fb81# acc4_aa_af Vdd pmos W=0.0975U L=0.065U
M93_keeper #83 #fb81# acc4_aa_af GND nmos W=0.0975U L=0.065U
M94_ #38 __jt_50_6 #37 Vdd pmos W=0.1625U L=0.065U
M95_ #38 __jf_50_6 #37 Vdd pmos W=0.1625U L=0.065U
M96_ #39 __jt_51_6 #38 Vdd pmos W=0.1625U L=0.065U
M97_ #39 __jf_51_6 #38 Vdd pmos W=0.1625U L=0.065U
M98_ #41 __jt_50_6 #40 GND nmos W=0.0975U L=0.065U
M99_ #42 __jf_51_6 #41 GND nmos W=0.0975U L=0.065U
M100_ #43 __jt_51_6 #42 GND nmos W=0.0975U L=0.065U
M101_ #44 __jf_52_6 #43 GND nmos W=0.0975U L=0.065U
M102_ #47 reset acc5_aa_af Vdd pmos W=0.1625U L=0.065U
M103_ #50 __jf_50_6 acc5_aa_af GND nmos W=0.0975U L=0.065U
M104_keeper #85 #fb84# acc5_aa_af Vdd pmos W=0.0975U L=0.065U
M105_keeper #86 #fb84# acc5_aa_af GND nmos W=0.0975U L=0.065U
M106_ #48 __jt_50_6 #47 Vdd pmos W=0.1625U L=0.065U
M107_ #48 __jf_50_6 #47 Vdd pmos W=0.1625U L=0.065U
M108_ #49 __jt_51_6 #48 Vdd pmos W=0.1625U L=0.065U
M109_ #49 __jf_51_6 #48 Vdd pmos W=0.1625U L=0.065U
M110_ #51 __jt_50_6 #50 GND nmos W=0.0975U L=0.065U
M111_ #52 __jf_51_6 #51 GND nmos W=0.0975U L=0.065U
M112_ #53 __jt_51_6 #52 GND nmos W=0.0975U L=0.065U
M113_ #54 __jf_52_6 #53 GND nmos W=0.0975U L=0.065U
M114_ #57 reset acc6_aa_af Vdd pmos W=0.1625U L=0.065U
M115_ #60 __jf_50_6 acc6_aa_af GND nmos W=0.0975U L=0.065U
M116_keeper #88 #fb87# acc6_aa_af Vdd pmos W=0.0975U L=0.065U
M117_keeper #89 #fb87# acc6_aa_af GND nmos W=0.0975U L=0.065U
M118_ #58 __jt_50_6 #57 Vdd pmos W=0.1625U L=0.065U
M119_ #58 __jf_50_6 #57 Vdd pmos W=0.1625U L=0.065U
M120_ #59 __jt_51_6 #58 Vdd pmos W=0.1625U L=0.065U
M121_ #59 __jf_51_6 #58 Vdd pmos W=0.1625U L=0.065U
M122_ #61 __jt_50_6 #60 GND nmos W=0.0975U L=0.065U
M123_ #62 __jf_51_6 #61 GND nmos W=0.0975U L=0.065U
M124_ #63 __jt_51_6 #62 GND nmos W=0.0975U L=0.065U
M125_ #64 __jf_52_6 #63 GND nmos W=0.0975U L=0.065U
M126_ #67 reset acc7_aa_af Vdd pmos W=0.1625U L=0.065U
M127_ #70 __jf_50_6 acc7_aa_af GND nmos W=0.0975U L=0.065U
M128_keeper #91 #fb90# acc7_aa_af Vdd pmos W=0.0975U L=0.065U
M129_keeper #92 #fb90# acc7_aa_af GND nmos W=0.0975U L=0.065U
M130_ #68 __jt_50_6 #67 Vdd pmos W=0.1625U L=0.065U
M131_ #68 __jf_50_6 #67 Vdd pmos W=0.1625U L=0.065U
M132_ #69 __jt_51_6 #68 Vdd pmos W=0.1625U L=0.065U
M133_ #69 __jf_51_6 #68 Vdd pmos W=0.1625U L=0.065U
M134_ #71 __jt_50_6 #70 GND nmos W=0.0975U L=0.065U
M135_ #72 __jf_51_6 #71 GND nmos W=0.0975U L=0.065U
M136_ #73 __jt_51_6 #72 GND nmos W=0.0975U L=0.065U
M137_ #74 __jf_52_6 #73 GND nmos W=0.0975U L=0.065U
xacc1 acc1_aa_at acc1_aa_af Sb_at_51_6 Sb_af_51_6 acc0_ad_at acc0_ad_af acc1_ad_at acc1_ad_af So_at_51_6 So_af_51_6 FullAdder
xacc7 acc7_aa_at acc7_aa_af Sb_at_57_6 Sb_af_57_6 acc6_ad_at acc6_ad_af acc7_ad_at acc7_ad_af So_at_57_6 So_af_57_6 FullAdder
xha23 Sa_at_52_6 Sa_af_52_6 Sa_at_53_6 Sa_af_53_6 ha23_ad_at ha23_ad_af ha23_as_at ha23_as_af HalfAdder
xha01 Sa_at_50_6 Sa_af_50_6 Sa_at_51_6 Sa_af_51_6 ha01_ad_at ha01_ad_af ha01_as_at ha01_as_af HalfAdder
xacc2 acc2_aa_at acc2_aa_af Sb_at_52_6 Sb_af_52_6 acc1_ad_at acc1_ad_af acc2_ad_at acc2_ad_af So_at_52_6 So_af_52_6 FullAdder
xacc3 acc3_aa_at acc3_aa_af Sb_at_53_6 Sb_af_53_6 acc2_ad_at acc2_ad_af acc3_ad_at acc3_ad_af So_at_53_6 So_af_53_6 FullAdder
xacc4 acc4_aa_at acc4_aa_af Sb_at_54_6 Sb_af_54_6 acc3_ad_at acc3_ad_af acc4_ad_at acc4_ad_af So_at_54_6 So_af_54_6 FullAdder
xacc6 acc6_aa_at acc6_aa_af Sb_at_56_6 Sb_af_56_6 acc5_ad_at acc5_ad_af acc6_ad_at acc6_ad_af So_at_56_6 So_af_56_6 FullAdder
xfa__high ha01_ad_at ha01_ad_af ha23_ad_at ha23_ad_af ha__sum_ad_at ha__sum_ad_af acc2_aa_at acc2_aa_af acc1_aa_at acc1_aa_af FullAdder
xha__sum ha01_as_at ha01_as_af ha23_as_at ha23_as_af ha__sum_ad_at ha__sum_ad_af acc0_aa_at acc0_aa_af HalfAdder
xacc5 acc5_aa_at acc5_aa_af Sb_at_55_6 Sb_af_55_6 acc4_ad_at acc4_ad_af acc5_ad_at acc5_ad_af So_at_55_6 So_af_55_6 FullAdder
xacc0 acc0_aa_at acc0_aa_af Sb_at_50_6 Sb_af_50_6 acc0_ac_at acc0_ac_af acc0_ad_at acc0_ad_af So_at_50_6 So_af_50_6 FullAdder
.ends
*---- end of process: CounterInc<> -----
*
*---- act defproc: CounterLogic<> -----
* raw ports:  reset I.t[0] I.t[1] I.t[2] I.t[3] I.f[0] I.f[1] I.f[2] I.f[3] I.a Cnt.req Cnt.t[0] Cnt.t[1] Cnt.t[2] Cnt.t[3] Cnt.t[4] Cnt.t[5] Cnt.t[6] Cnt.t[7] Cnt.f[0] Cnt.f[1] Cnt.f[2] Cnt.f[3] Cnt.f[4] Cnt.f[5] Cnt.f[6] Cnt.f[7] P.t[0] P.t[1] P.t[2] P.t[3] P.t[4] P.t[5] P.t[6] P.t[7] P.f[0] P.f[1] P.f[2] P.f[3] P.f[4] P.f[5] P.f[6] P.f[7] P.a Q.req Q.t[0] Q.t[1] Q.t[2] Q.t[3] Q.t[4] Q.t[5] Q.t[6] Q.t[7] Q.f[0] Q.f[1] Q.f[2] Q.f[3] Q.f[4] Q.f[5] Q.f[6] Q.f[7] Sa.t[0] Sa.t[1] Sa.t[2] Sa.t[3] Sa.f[0] Sa.f[1] Sa.f[2] Sa.f[3] Sb.t[0] Sb.t[1] Sb.t[2] Sb.t[3] Sb.t[4] Sb.t[5] Sb.t[6] Sb.t[7] Sb.f[0] Sb.f[1] Sb.f[2] Sb.f[3] Sb.f[4] Sb.f[5] Sb.f[6] Sb.f[7] So.t[0] So.t[1] So.t[2] So.t[3] So.t[4] So.t[5] So.t[6] So.t[7] So.f[0] So.f[1] So.f[2] So.f[3] So.f[4] So.f[5] So.f[6] So.f[7]
*
.subckt CounterLogic reset I_at_50_6 I_at_51_6 I_at_52_6 I_at_53_6 I_af_50_6 I_af_51_6 I_af_52_6 I_af_53_6 I_aa Cnt_areq Cnt_at_50_6 Cnt_at_51_6 Cnt_at_52_6 Cnt_at_53_6 Cnt_at_54_6 Cnt_at_55_6 Cnt_at_56_6 Cnt_at_57_6 Cnt_af_50_6 Cnt_af_51_6 Cnt_af_52_6 Cnt_af_53_6 Cnt_af_54_6 Cnt_af_55_6 Cnt_af_56_6 Cnt_af_57_6 P_at_50_6 P_at_51_6 P_at_52_6 P_at_53_6 P_at_54_6 P_at_55_6 P_at_56_6 P_at_57_6 P_af_50_6 P_af_51_6 P_af_52_6 P_af_53_6 P_af_54_6 P_af_55_6 P_af_56_6 P_af_57_6 P_aa Q_areq Q_at_50_6 Q_at_51_6 Q_at_52_6 Q_at_53_6 Q_at_54_6 Q_at_55_6 Q_at_56_6 Q_at_57_6 Q_af_50_6 Q_af_51_6 Q_af_52_6 Q_af_53_6 Q_af_54_6 Q_af_55_6 Q_af_56_6 Q_af_57_6 Sa_at_50_6 Sa_at_51_6 Sa_at_52_6 Sa_at_53_6 Sa_af_50_6 Sa_af_51_6 Sa_af_52_6 Sa_af_53_6 Sb_at_50_6 Sb_at_51_6 Sb_at_52_6 Sb_at_53_6 Sb_at_54_6 Sb_at_55_6 Sb_at_56_6 Sb_at_57_6 Sb_af_50_6 Sb_af_51_6 Sb_af_52_6 Sb_af_53_6 Sb_af_54_6 Sb_af_55_6 Sb_af_56_6 Sb_af_57_6 So_at_50_6 So_at_51_6 So_at_52_6 So_at_53_6 So_at_54_6 So_at_55_6 So_at_56_6 So_at_57_6 So_af_50_6 So_af_51_6 So_af_52_6 So_af_53_6 So_af_54_6 So_af_55_6 So_af_56_6 So_af_57_6
*.PININFO reset:I I_at_50_6:I I_at_51_6:I I_at_52_6:I I_at_53_6:I I_af_50_6:I I_af_51_6:I I_af_52_6:I I_af_53_6:I I_aa:O Cnt_areq:I Cnt_at_50_6:O Cnt_at_51_6:O Cnt_at_52_6:O Cnt_at_53_6:O Cnt_at_54_6:O Cnt_at_55_6:O Cnt_at_56_6:O Cnt_at_57_6:O Cnt_af_50_6:O Cnt_af_51_6:O Cnt_af_52_6:O Cnt_af_53_6:O Cnt_af_54_6:O Cnt_af_55_6:O Cnt_af_56_6:O Cnt_af_57_6:O P_at_50_6:O P_at_51_6:O P_at_52_6:O P_at_53_6:O P_at_54_6:O P_at_55_6:O P_at_56_6:O P_at_57_6:O P_af_50_6:O P_af_51_6:O P_af_52_6:O P_af_53_6:O P_af_54_6:O P_af_55_6:O P_af_56_6:O P_af_57_6:O P_aa:I Q_areq:O Q_at_50_6:I Q_at_51_6:I Q_at_52_6:I Q_at_53_6:I Q_at_54_6:I Q_at_55_6:I Q_at_56_6:I Q_at_57_6:I Q_af_50_6:I Q_af_51_6:I Q_af_52_6:I Q_af_53_6:I Q_af_54_6:I Q_af_55_6:I Q_af_56_6:I Q_af_57_6:I Sa_at_50_6:O Sa_at_51_6:O Sa_at_52_6:O Sa_at_53_6:O Sa_af_50_6:O Sa_af_51_6:O Sa_af_52_6:O Sa_af_53_6:O Sb_at_50_6:O Sb_at_51_6:O Sb_at_52_6:O Sb_at_53_6:O Sb_at_54_6:O Sb_at_55_6:O Sb_at_56_6:O Sb_at_57_6:O Sb_af_50_6:O Sb_af_51_6:O Sb_af_52_6:O Sb_af_53_6:O Sb_af_54_6:O Sb_af_55_6:O Sb_af_56_6:O Sb_af_57_6:O So_at_50_6:I So_at_51_6:I So_at_52_6:I So_at_53_6:I So_at_54_6:I So_at_55_6:I So_at_56_6:I So_at_57_6:I So_af_50_6:I So_af_51_6:I So_af_52_6:I So_af_53_6:I So_af_54_6:I So_af_55_6:I So_af_56_6:I So_af_57_6:I
*.POWER VDD Vdd
*.POWER GND GND
*.POWER NSUB GND
*.POWER PSUB Vdd
*
* --- node flags ---
*
* __qr (state-holding): pup_reff=3.2; pdn_reff=2.66667
* v (state-holding): pup_reff=0.4; pdn_reff=0.666667
* __ia (state-holding): pup_reff=0.4; pdn_reff=1.33333
* __sbt_57_6 (combinational)
* __sbf_57_6 (combinational)
* k (combinational)
* __v (combinational)
* __sbt_56_6 (combinational)
* __sbf_56_6 (combinational)
* __sbt_55_6 (combinational)
* __sbf_55_6 (combinational)
* __sbt_54_6 (combinational)
* __sbf_54_6 (combinational)
* __sbt_53_6 (combinational)
* __sbf_53_6 (combinational)
* __sbt_52_6 (combinational)
* __sbf_52_6 (combinational)
* __sbt_51_6 (combinational)
* __sbf_51_6 (combinational)
* __sbt_50_6 (combinational)
* __sbf_50_6 (combinational)
* __r (combinational)
* Sa_at_53_6 (state-holding): pup_reff=0.8; pdn_reff=0.666667
* Sa_af_53_6 (state-holding): pup_reff=0.8; pdn_reff=0.666667
* __k (state-holding): pup_reff=0.8; pdn_reff=2
* __pa (combinational)
* __cr (combinational)
* w (state-holding): pup_reff=7.2; pdn_reff=0.666667
* Cnt_at_57_6 (state-holding): pup_reff=0.8; pdn_reff=0.666667
* Cnt_af_57_6 (state-holding): pup_reff=0.8; pdn_reff=0.666667
* Cnt_at_56_6 (state-holding): pup_reff=0.8; pdn_reff=0.666667
* Cnt_af_56_6 (state-holding): pup_reff=0.8; pdn_reff=0.666667
* Cnt_at_55_6 (state-holding): pup_reff=0.8; pdn_reff=0.666667
* Cnt_af_55_6 (state-holding): pup_reff=0.8; pdn_reff=0.666667
* Cnt_at_54_6 (state-holding): pup_reff=0.8; pdn_reff=0.666667
* Cnt_af_54_6 (state-holding): pup_reff=0.8; pdn_reff=0.666667
* Cnt_at_53_6 (state-holding): pup_reff=0.8; pdn_reff=0.666667
* Cnt_af_53_6 (state-holding): pup_reff=0.8; pdn_reff=0.666667
* Cnt_at_52_6 (state-holding): pup_reff=0.8; pdn_reff=0.666667
* Cnt_af_52_6 (state-holding): pup_reff=0.8; pdn_reff=0.666667
* Cnt_at_51_6 (state-holding): pup_reff=0.8; pdn_reff=0.666667
* Cnt_af_51_6 (state-holding): pup_reff=0.8; pdn_reff=0.666667
* Cnt_at_50_6 (state-holding): pup_reff=0.8; pdn_reff=0.666667
* Cnt_af_50_6 (state-holding): pup_reff=0.8; pdn_reff=0.666667
* Sa_at_50_6 (state-holding): pup_reff=0.8; pdn_reff=0.666667
* __it_50_6 (combinational)
* Sa_af_50_6 (state-holding): pup_reff=0.8; pdn_reff=0.666667
* __if_50_6 (combinational)
* Sa_at_51_6 (state-holding): pup_reff=0.8; pdn_reff=0.666667
* __it_51_6 (combinational)
* Sa_af_51_6 (state-holding): pup_reff=0.8; pdn_reff=0.666667
* __if_51_6 (combinational)
* Sa_at_52_6 (state-holding): pup_reff=0.8; pdn_reff=0.666667
* __it_52_6 (combinational)
* Sa_af_52_6 (state-holding): pup_reff=0.8; pdn_reff=0.666667
* __if_52_6 (combinational)
* __it_53_6 (combinational)
* __if_53_6 (combinational)
* Sb_at_50_6 (state-holding): pup_reff=0.8; pdn_reff=1.33333
* __qt_50_6 (combinational)
* I_aa (combinational)
* Sb_af_50_6 (state-holding): pup_reff=0.8; pdn_reff=1.33333
* __qf_50_6 (combinational)
* __pt_50_6 (state-holding): pup_reff=0.4; pdn_reff=1.33333
* __pf_50_6 (state-holding): pup_reff=0.8; pdn_reff=1.33333
* Sb_at_51_6 (state-holding): pup_reff=0.8; pdn_reff=1.33333
* __qt_51_6 (combinational)
* Sb_af_51_6 (state-holding): pup_reff=0.8; pdn_reff=1.33333
* __qf_51_6 (combinational)
* __pt_51_6 (state-holding): pup_reff=0.4; pdn_reff=1.33333
* __pf_51_6 (state-holding): pup_reff=0.8; pdn_reff=1.33333
* Sb_at_52_6 (state-holding): pup_reff=0.8; pdn_reff=1.33333
* __qt_52_6 (combinational)
* Sb_af_52_6 (state-holding): pup_reff=0.8; pdn_reff=1.33333
* __qf_52_6 (combinational)
* __pt_52_6 (state-holding): pup_reff=0.4; pdn_reff=1.33333
* __pf_52_6 (state-holding): pup_reff=0.8; pdn_reff=1.33333
* Sb_at_53_6 (state-holding): pup_reff=0.8; pdn_reff=1.33333
* __qt_53_6 (combinational)
* Sb_af_53_6 (state-holding): pup_reff=0.8; pdn_reff=1.33333
* __qf_53_6 (combinational)
* __pt_53_6 (state-holding): pup_reff=0.4; pdn_reff=1.33333
* __pf_53_6 (state-holding): pup_reff=0.8; pdn_reff=1.33333
* Sb_at_54_6 (state-holding): pup_reff=0.8; pdn_reff=1.33333
* __qt_54_6 (combinational)
* Sb_af_54_6 (state-holding): pup_reff=0.8; pdn_reff=1.33333
* __qf_54_6 (combinational)
* __pt_54_6 (state-holding): pup_reff=0.4; pdn_reff=1.33333
* __pf_54_6 (state-holding): pup_reff=0.8; pdn_reff=1.33333
* Sb_at_55_6 (state-holding): pup_reff=0.8; pdn_reff=1.33333
* __qt_55_6 (combinational)
* Sb_af_55_6 (state-holding): pup_reff=0.8; pdn_reff=1.33333
* __qf_55_6 (combinational)
* __pt_55_6 (state-holding): pup_reff=0.4; pdn_reff=1.33333
* __pf_55_6 (state-holding): pup_reff=0.8; pdn_reff=1.33333
* Sb_at_56_6 (state-holding): pup_reff=0.8; pdn_reff=1.33333
* __qt_56_6 (combinational)
* Sb_af_56_6 (state-holding): pup_reff=0.8; pdn_reff=1.33333
* __qf_56_6 (combinational)
* __pt_56_6 (state-holding): pup_reff=0.4; pdn_reff=1.33333
* __pf_56_6 (state-holding): pup_reff=0.8; pdn_reff=1.33333
* Sb_at_57_6 (state-holding): pup_reff=0.8; pdn_reff=1.33333
* __qt_57_6 (combinational)
* Sb_af_57_6 (state-holding): pup_reff=0.8; pdn_reff=1.33333
* __qf_57_6 (combinational)
* __pt_57_6 (state-holding): pup_reff=0.4; pdn_reff=1.33333
* __pf_57_6 (state-holding): pup_reff=0.8; pdn_reff=1.33333
* Q_areq (combinational)
* P_at_50_6 (combinational)
* P_af_50_6 (combinational)
* P_at_51_6 (combinational)
* P_af_51_6 (combinational)
* P_at_52_6 (combinational)
* P_af_52_6 (combinational)
* P_at_53_6 (combinational)
* P_af_53_6 (combinational)
* P_at_54_6 (combinational)
* P_af_54_6 (combinational)
* P_at_55_6 (combinational)
* P_af_55_6 (combinational)
* P_at_56_6 (combinational)
* P_af_56_6 (combinational)
* P_at_57_6 (combinational)
* P_af_57_6 (combinational)
*
* --- end node flags ---
*
M0_ Vdd __v #13 Vdd pmos W=0.1625U L=0.065U
M1_ Vdd __sbt_57_6 #21 Vdd pmos W=0.1625U L=0.065U
M2_ Vdd __sbf_57_6 #21 Vdd pmos W=0.1625U L=0.065U
M3_ Vdd __r __qr Vdd pmos W=0.1625U L=0.065U
M4_ Vdd k __ia Vdd pmos W=0.1625U L=0.065U
M5_ Vdd __r __ia Vdd pmos W=0.1625U L=0.065U
M6_ Vdd P_aa #47 Vdd pmos W=0.1625U L=0.065U
M7_ Vdd __r __k Vdd pmos W=0.1625U L=0.065U
M8_ Vdd __cr v Vdd pmos W=0.1625U L=0.065U
M9_ Vdd __v #52 Vdd pmos W=0.1625U L=0.065U
M10_ Vdd __it_50_6 #85 Vdd pmos W=0.1625U L=0.065U
M11_ Vdd __if_50_6 #88 Vdd pmos W=0.1625U L=0.065U
M12_ Vdd __it_51_6 #91 Vdd pmos W=0.1625U L=0.065U
M13_ Vdd __if_51_6 #94 Vdd pmos W=0.1625U L=0.065U
M14_ Vdd __it_52_6 #97 Vdd pmos W=0.1625U L=0.065U
M15_ Vdd __if_52_6 #100 Vdd pmos W=0.1625U L=0.065U
M16_ Vdd __it_53_6 #102 Vdd pmos W=0.1625U L=0.065U
M17_ Vdd __if_53_6 #104 Vdd pmos W=0.1625U L=0.065U
M18_ Vdd __qt_50_6 #107 Vdd pmos W=0.1625U L=0.065U
M19_ Vdd __qf_50_6 #112 Vdd pmos W=0.1625U L=0.065U
M20_ Vdd So_at_50_6 __pt_50_6 Vdd pmos W=0.1625U L=0.065U
M21_ Vdd So_af_50_6 #121 Vdd pmos W=0.1625U L=0.065U
M22_ Vdd __cr #122 Vdd pmos W=0.1625U L=0.065U
M23_ Vdd __cr #123 Vdd pmos W=0.1625U L=0.065U
M24_ Vdd __qt_51_6 #125 Vdd pmos W=0.1625U L=0.065U
M25_ Vdd __qf_51_6 #129 Vdd pmos W=0.1625U L=0.065U
M26_ Vdd So_at_51_6 __pt_51_6 Vdd pmos W=0.1625U L=0.065U
M27_ Vdd So_af_51_6 #138 Vdd pmos W=0.1625U L=0.065U
M28_ Vdd __cr #139 Vdd pmos W=0.1625U L=0.065U
M29_ Vdd __cr #140 Vdd pmos W=0.1625U L=0.065U
M30_ Vdd __qt_52_6 #142 Vdd pmos W=0.1625U L=0.065U
M31_ Vdd __qf_52_6 #146 Vdd pmos W=0.1625U L=0.065U
M32_ Vdd So_at_52_6 __pt_52_6 Vdd pmos W=0.1625U L=0.065U
M33_ Vdd So_af_52_6 #155 Vdd pmos W=0.1625U L=0.065U
M34_ Vdd __cr #156 Vdd pmos W=0.1625U L=0.065U
M35_ Vdd __cr #157 Vdd pmos W=0.1625U L=0.065U
M36_ Vdd __qt_53_6 #159 Vdd pmos W=0.1625U L=0.065U
M37_ Vdd __qf_53_6 #163 Vdd pmos W=0.1625U L=0.065U
M38_ Vdd So_at_53_6 __pt_53_6 Vdd pmos W=0.1625U L=0.065U
M39_ Vdd So_af_53_6 #172 Vdd pmos W=0.1625U L=0.065U
M40_ Vdd __cr #173 Vdd pmos W=0.1625U L=0.065U
M41_ Vdd __cr #174 Vdd pmos W=0.1625U L=0.065U
M42_ Vdd __qt_54_6 #176 Vdd pmos W=0.1625U L=0.065U
M43_ Vdd __qf_54_6 #180 Vdd pmos W=0.1625U L=0.065U
M44_ Vdd So_at_54_6 __pt_54_6 Vdd pmos W=0.1625U L=0.065U
M45_ Vdd So_af_54_6 #189 Vdd pmos W=0.1625U L=0.065U
M46_ Vdd __cr #190 Vdd pmos W=0.1625U L=0.065U
M47_ Vdd __cr #191 Vdd pmos W=0.1625U L=0.065U
M48_ Vdd __qt_55_6 #193 Vdd pmos W=0.1625U L=0.065U
M49_ Vdd __qf_55_6 #197 Vdd pmos W=0.1625U L=0.065U
M50_ Vdd So_at_55_6 __pt_55_6 Vdd pmos W=0.1625U L=0.065U
M51_ Vdd So_af_55_6 #206 Vdd pmos W=0.1625U L=0.065U
M52_ Vdd __cr #207 Vdd pmos W=0.1625U L=0.065U
M53_ Vdd __cr #208 Vdd pmos W=0.1625U L=0.065U
M54_ Vdd __qt_56_6 #210 Vdd pmos W=0.1625U L=0.065U
M55_ Vdd __qf_56_6 #214 Vdd pmos W=0.1625U L=0.065U
M56_ Vdd So_at_56_6 __pt_56_6 Vdd pmos W=0.1625U L=0.065U
M57_ Vdd So_af_56_6 #223 Vdd pmos W=0.1625U L=0.065U
M58_ Vdd __cr #224 Vdd pmos W=0.1625U L=0.065U
M59_ Vdd __cr #225 Vdd pmos W=0.1625U L=0.065U
M60_ Vdd __qt_57_6 #227 Vdd pmos W=0.1625U L=0.065U
M61_ Vdd __qf_57_6 #231 Vdd pmos W=0.1625U L=0.065U
M62_ Vdd So_at_57_6 __pt_57_6 Vdd pmos W=0.1625U L=0.065U
M63_ Vdd So_af_57_6 #240 Vdd pmos W=0.1625U L=0.065U
M64_ Vdd __cr #241 Vdd pmos W=0.1625U L=0.065U
M65_ Vdd __cr #242 Vdd pmos W=0.1625U L=0.065U
M66_ Vdd v __v Vdd pmos W=0.1625U L=0.065U
M67_ Vdd P_aa __pa Vdd pmos W=0.1625U L=0.065U
M68_ Vdd Cnt_areq __cr Vdd pmos W=0.1625U L=0.065U
M69_ Vdd reset __r Vdd pmos W=0.1625U L=0.065U
M70_ Vdd __k k Vdd pmos W=0.1625U L=0.065U
M71_ Vdd __ia I_aa Vdd pmos W=0.1625U L=0.065U
M72_ Vdd __qr Q_areq Vdd pmos W=0.1625U L=0.065U
M73_ Vdd I_at_50_6 __it_50_6 Vdd pmos W=0.1625U L=0.065U
M74_ Vdd I_af_50_6 __if_50_6 Vdd pmos W=0.1625U L=0.065U
M75_ Vdd I_at_51_6 __it_51_6 Vdd pmos W=0.1625U L=0.065U
M76_ Vdd I_af_51_6 __if_51_6 Vdd pmos W=0.1625U L=0.065U
M77_ Vdd I_at_52_6 __it_52_6 Vdd pmos W=0.1625U L=0.065U
M78_ Vdd I_af_52_6 __if_52_6 Vdd pmos W=0.1625U L=0.065U
M79_ Vdd I_at_53_6 __it_53_6 Vdd pmos W=0.1625U L=0.065U
M80_ Vdd I_af_53_6 __if_53_6 Vdd pmos W=0.1625U L=0.065U
M81_ Vdd Q_at_50_6 __qt_50_6 Vdd pmos W=0.1625U L=0.065U
M82_ Vdd Q_af_50_6 __qf_50_6 Vdd pmos W=0.1625U L=0.065U
M83_ Vdd Sb_at_50_6 __sbt_50_6 Vdd pmos W=0.1625U L=0.065U
M84_ Vdd Sb_af_50_6 __sbf_50_6 Vdd pmos W=0.1625U L=0.065U
M85_ Vdd __pt_50_6 P_at_50_6 Vdd pmos W=0.1625U L=0.065U
M86_ Vdd __pf_50_6 P_af_50_6 Vdd pmos W=0.1625U L=0.065U
M87_ Vdd Q_at_51_6 __qt_51_6 Vdd pmos W=0.1625U L=0.065U
M88_ Vdd Q_af_51_6 __qf_51_6 Vdd pmos W=0.1625U L=0.065U
M89_ Vdd Sb_at_51_6 __sbt_51_6 Vdd pmos W=0.1625U L=0.065U
M90_ Vdd Sb_af_51_6 __sbf_51_6 Vdd pmos W=0.1625U L=0.065U
M91_ Vdd __pt_51_6 P_at_51_6 Vdd pmos W=0.1625U L=0.065U
M92_ Vdd __pf_51_6 P_af_51_6 Vdd pmos W=0.1625U L=0.065U
M93_ Vdd Q_at_52_6 __qt_52_6 Vdd pmos W=0.1625U L=0.065U
M94_ Vdd Q_af_52_6 __qf_52_6 Vdd pmos W=0.1625U L=0.065U
M95_ Vdd Sb_at_52_6 __sbt_52_6 Vdd pmos W=0.1625U L=0.065U
M96_ Vdd Sb_af_52_6 __sbf_52_6 Vdd pmos W=0.1625U L=0.065U
M97_ Vdd __pt_52_6 P_at_52_6 Vdd pmos W=0.1625U L=0.065U
M98_ Vdd __pf_52_6 P_af_52_6 Vdd pmos W=0.1625U L=0.065U
M99_ Vdd Q_at_53_6 __qt_53_6 Vdd pmos W=0.1625U L=0.065U
M100_ Vdd Q_af_53_6 __qf_53_6 Vdd pmos W=0.1625U L=0.065U
M101_ Vdd Sb_at_53_6 __sbt_53_6 Vdd pmos W=0.1625U L=0.065U
M102_ Vdd Sb_af_53_6 __sbf_53_6 Vdd pmos W=0.1625U L=0.065U
M103_ Vdd __pt_53_6 P_at_53_6 Vdd pmos W=0.1625U L=0.065U
M104_ Vdd __pf_53_6 P_af_53_6 Vdd pmos W=0.1625U L=0.065U
M105_ Vdd Q_at_54_6 __qt_54_6 Vdd pmos W=0.1625U L=0.065U
M106_ Vdd Q_af_54_6 __qf_54_6 Vdd pmos W=0.1625U L=0.065U
M107_ Vdd Sb_at_54_6 __sbt_54_6 Vdd pmos W=0.1625U L=0.065U
M108_ Vdd Sb_af_54_6 __sbf_54_6 Vdd pmos W=0.1625U L=0.065U
M109_ Vdd __pt_54_6 P_at_54_6 Vdd pmos W=0.1625U L=0.065U
M110_ Vdd __pf_54_6 P_af_54_6 Vdd pmos W=0.1625U L=0.065U
M111_ Vdd Q_at_55_6 __qt_55_6 Vdd pmos W=0.1625U L=0.065U
M112_ Vdd Q_af_55_6 __qf_55_6 Vdd pmos W=0.1625U L=0.065U
M113_ Vdd Sb_at_55_6 __sbt_55_6 Vdd pmos W=0.1625U L=0.065U
M114_ Vdd Sb_af_55_6 __sbf_55_6 Vdd pmos W=0.1625U L=0.065U
M115_ Vdd __pt_55_6 P_at_55_6 Vdd pmos W=0.1625U L=0.065U
M116_ Vdd __pf_55_6 P_af_55_6 Vdd pmos W=0.1625U L=0.065U
M117_ Vdd Q_at_56_6 __qt_56_6 Vdd pmos W=0.1625U L=0.065U
M118_ Vdd Q_af_56_6 __qf_56_6 Vdd pmos W=0.1625U L=0.065U
M119_ Vdd Sb_at_56_6 __sbt_56_6 Vdd pmos W=0.1625U L=0.065U
M120_ Vdd Sb_af_56_6 __sbf_56_6 Vdd pmos W=0.1625U L=0.065U
M121_ Vdd __pt_56_6 P_at_56_6 Vdd pmos W=0.1625U L=0.065U
M122_ Vdd __pf_56_6 P_af_56_6 Vdd pmos W=0.1625U L=0.065U
M123_ Vdd Q_at_57_6 __qt_57_6 Vdd pmos W=0.1625U L=0.065U
M124_ Vdd Q_af_57_6 __qf_57_6 Vdd pmos W=0.1625U L=0.065U
M125_ Vdd Sb_at_57_6 __sbt_57_6 Vdd pmos W=0.1625U L=0.065U
M126_ Vdd Sb_af_57_6 __sbf_57_6 Vdd pmos W=0.1625U L=0.065U
M127_ Vdd __pt_57_6 P_at_57_6 Vdd pmos W=0.1625U L=0.065U
M128_ Vdd __pf_57_6 P_af_57_6 Vdd pmos W=0.1625U L=0.065U
M129_ Vdd __qr #fb282# Vdd pmos W=0.1625U L=0.13U
M130_ Vdd v #fb285# Vdd pmos W=0.1625U L=0.13U
M131_keeper Vdd GND #283 Vdd pmos W=0.0975U L=1.235U
M132_ Vdd __ia #fb288# Vdd pmos W=0.1625U L=0.13U
M133_keeper Vdd GND #286 Vdd pmos W=0.0975U L=0.26U
M134_ Vdd Sa_at_53_6 #fb291# Vdd pmos W=0.1625U L=0.13U
M135_keeper Vdd GND #289 Vdd pmos W=0.0975U L=0.585U
M136_ Vdd Sa_af_53_6 #fb294# Vdd pmos W=0.1625U L=0.13U
M137_keeper Vdd GND #292 Vdd pmos W=0.0975U L=0.26U
M138_ Vdd __k #fb297# Vdd pmos W=0.1625U L=0.13U
M139_keeper Vdd GND #295 Vdd pmos W=0.0975U L=0.26U
M140_ Vdd w #fb300# Vdd pmos W=0.1625U L=0.13U
M141_keeper Vdd GND #298 Vdd pmos W=0.0975U L=0.91U
M142_ Vdd Cnt_at_57_6 #fb303# Vdd pmos W=0.1625U L=0.13U
M143_keeper Vdd GND #301 Vdd pmos W=0.0975U L=0.26U
M144_ Vdd Cnt_af_57_6 #fb306# Vdd pmos W=0.1625U L=0.13U
M145_keeper Vdd GND #304 Vdd pmos W=0.0975U L=0.26U
M146_ Vdd Cnt_at_56_6 #fb309# Vdd pmos W=0.1625U L=0.13U
M147_keeper Vdd GND #307 Vdd pmos W=0.0975U L=0.26U
M148_ Vdd Cnt_af_56_6 #fb312# Vdd pmos W=0.1625U L=0.13U
M149_keeper Vdd GND #310 Vdd pmos W=0.0975U L=0.26U
M150_ Vdd Cnt_at_55_6 #fb315# Vdd pmos W=0.1625U L=0.13U
M151_keeper Vdd GND #313 Vdd pmos W=0.0975U L=0.26U
M152_ Vdd Cnt_af_55_6 #fb318# Vdd pmos W=0.1625U L=0.13U
M153_keeper Vdd GND #316 Vdd pmos W=0.0975U L=0.26U
M154_ Vdd Cnt_at_54_6 #fb321# Vdd pmos W=0.1625U L=0.13U
M155_keeper Vdd GND #319 Vdd pmos W=0.0975U L=0.26U
M156_ Vdd Cnt_af_54_6 #fb324# Vdd pmos W=0.1625U L=0.13U
M157_keeper Vdd GND #322 Vdd pmos W=0.0975U L=0.26U
M158_ Vdd Cnt_at_53_6 #fb327# Vdd pmos W=0.1625U L=0.13U
M159_keeper Vdd GND #325 Vdd pmos W=0.0975U L=0.26U
M160_ Vdd Cnt_af_53_6 #fb330# Vdd pmos W=0.1625U L=0.13U
M161_keeper Vdd GND #328 Vdd pmos W=0.0975U L=0.26U
M162_ Vdd Cnt_at_52_6 #fb333# Vdd pmos W=0.1625U L=0.13U
M163_keeper Vdd GND #331 Vdd pmos W=0.0975U L=0.26U
M164_ Vdd Cnt_af_52_6 #fb336# Vdd pmos W=0.1625U L=0.13U
M165_keeper Vdd GND #334 Vdd pmos W=0.0975U L=0.26U
M166_ Vdd Cnt_at_51_6 #fb339# Vdd pmos W=0.1625U L=0.13U
M167_keeper Vdd GND #337 Vdd pmos W=0.0975U L=0.26U
M168_ Vdd Cnt_af_51_6 #fb342# Vdd pmos W=0.1625U L=0.13U
M169_keeper Vdd GND #340 Vdd pmos W=0.0975U L=0.26U
M170_ Vdd Cnt_at_50_6 #fb345# Vdd pmos W=0.1625U L=0.13U
M171_keeper Vdd GND #343 Vdd pmos W=0.0975U L=0.26U
M172_ Vdd Cnt_af_50_6 #fb348# Vdd pmos W=0.1625U L=0.13U
M173_keeper Vdd GND #346 Vdd pmos W=0.0975U L=0.26U
M174_ Vdd Sa_at_50_6 #fb351# Vdd pmos W=0.1625U L=0.13U
M175_keeper Vdd GND #349 Vdd pmos W=0.0975U L=0.26U
M176_ Vdd Sa_af_50_6 #fb354# Vdd pmos W=0.1625U L=0.13U
M177_keeper Vdd GND #352 Vdd pmos W=0.0975U L=0.26U
M178_ Vdd Sa_at_51_6 #fb357# Vdd pmos W=0.1625U L=0.13U
M179_keeper Vdd GND #355 Vdd pmos W=0.0975U L=0.26U
M180_ Vdd Sa_af_51_6 #fb360# Vdd pmos W=0.1625U L=0.13U
M181_keeper Vdd GND #358 Vdd pmos W=0.0975U L=0.26U
M182_ Vdd Sa_at_52_6 #fb363# Vdd pmos W=0.1625U L=0.13U
M183_keeper Vdd GND #361 Vdd pmos W=0.0975U L=0.26U
M184_ Vdd Sa_af_52_6 #fb366# Vdd pmos W=0.1625U L=0.13U
M185_keeper Vdd GND #364 Vdd pmos W=0.0975U L=0.26U
M186_ Vdd Sb_at_50_6 #fb369# Vdd pmos W=0.1625U L=0.13U
M187_keeper Vdd GND #367 Vdd pmos W=0.0975U L=0.26U
M188_ Vdd Sb_af_50_6 #fb372# Vdd pmos W=0.1625U L=0.13U
M189_keeper Vdd GND #370 Vdd pmos W=0.0975U L=0.585U
M190_ Vdd __pt_50_6 #fb375# Vdd pmos W=0.1625U L=0.13U
M191_keeper Vdd GND #373 Vdd pmos W=0.0975U L=0.585U
M192_ Vdd __pf_50_6 #fb378# Vdd pmos W=0.1625U L=0.13U
M193_keeper Vdd GND #376 Vdd pmos W=0.0975U L=0.585U
M194_ Vdd Sb_at_51_6 #fb381# Vdd pmos W=0.1625U L=0.13U
M195_keeper Vdd GND #379 Vdd pmos W=0.0975U L=0.585U
M196_ Vdd Sb_af_51_6 #fb384# Vdd pmos W=0.1625U L=0.13U
M197_keeper Vdd GND #382 Vdd pmos W=0.0975U L=0.585U
M198_ Vdd __pt_51_6 #fb387# Vdd pmos W=0.1625U L=0.13U
M199_keeper Vdd GND #385 Vdd pmos W=0.0975U L=0.585U
M200_ Vdd __pf_51_6 #fb390# Vdd pmos W=0.1625U L=0.13U
M201_keeper Vdd GND #388 Vdd pmos W=0.0975U L=0.585U
M202_ Vdd Sb_at_52_6 #fb393# Vdd pmos W=0.1625U L=0.13U
M203_keeper Vdd GND #391 Vdd pmos W=0.0975U L=0.585U
M204_ Vdd Sb_af_52_6 #fb396# Vdd pmos W=0.1625U L=0.13U
M205_keeper Vdd GND #394 Vdd pmos W=0.0975U L=0.585U
M206_ Vdd __pt_52_6 #fb399# Vdd pmos W=0.1625U L=0.13U
M207_keeper Vdd GND #397 Vdd pmos W=0.0975U L=0.585U
M208_ Vdd __pf_52_6 #fb402# Vdd pmos W=0.1625U L=0.13U
M209_keeper Vdd GND #400 Vdd pmos W=0.0975U L=0.585U
M210_ Vdd Sb_at_53_6 #fb405# Vdd pmos W=0.1625U L=0.13U
M211_keeper Vdd GND #403 Vdd pmos W=0.0975U L=0.585U
M212_ Vdd Sb_af_53_6 #fb408# Vdd pmos W=0.1625U L=0.13U
M213_keeper Vdd GND #406 Vdd pmos W=0.0975U L=0.585U
M214_ Vdd __pt_53_6 #fb411# Vdd pmos W=0.1625U L=0.13U
M215_keeper Vdd GND #409 Vdd pmos W=0.0975U L=0.585U
M216_ Vdd __pf_53_6 #fb414# Vdd pmos W=0.1625U L=0.13U
M217_keeper Vdd GND #412 Vdd pmos W=0.0975U L=0.585U
M218_ Vdd Sb_at_54_6 #fb417# Vdd pmos W=0.1625U L=0.13U
M219_keeper Vdd GND #415 Vdd pmos W=0.0975U L=0.585U
M220_ Vdd Sb_af_54_6 #fb420# Vdd pmos W=0.1625U L=0.13U
M221_keeper Vdd GND #418 Vdd pmos W=0.0975U L=0.585U
M222_ Vdd __pt_54_6 #fb423# Vdd pmos W=0.1625U L=0.13U
M223_keeper Vdd GND #421 Vdd pmos W=0.0975U L=0.585U
M224_ Vdd __pf_54_6 #fb426# Vdd pmos W=0.1625U L=0.13U
M225_keeper Vdd GND #424 Vdd pmos W=0.0975U L=0.585U
M226_ Vdd Sb_at_55_6 #fb429# Vdd pmos W=0.1625U L=0.13U
M227_keeper Vdd GND #427 Vdd pmos W=0.0975U L=0.585U
M228_ Vdd Sb_af_55_6 #fb432# Vdd pmos W=0.1625U L=0.13U
M229_keeper Vdd GND #430 Vdd pmos W=0.0975U L=0.585U
M230_ Vdd __pt_55_6 #fb435# Vdd pmos W=0.1625U L=0.13U
M231_keeper Vdd GND #433 Vdd pmos W=0.0975U L=0.585U
M232_ Vdd __pf_55_6 #fb438# Vdd pmos W=0.1625U L=0.13U
M233_keeper Vdd GND #436 Vdd pmos W=0.0975U L=0.585U
M234_ Vdd Sb_at_56_6 #fb441# Vdd pmos W=0.1625U L=0.13U
M235_keeper Vdd GND #439 Vdd pmos W=0.0975U L=0.585U
M236_ Vdd Sb_af_56_6 #fb444# Vdd pmos W=0.1625U L=0.13U
M237_keeper Vdd GND #442 Vdd pmos W=0.0975U L=0.585U
M238_ Vdd __pt_56_6 #fb447# Vdd pmos W=0.1625U L=0.13U
M239_keeper Vdd GND #445 Vdd pmos W=0.0975U L=0.585U
M240_ Vdd __pf_56_6 #fb450# Vdd pmos W=0.1625U L=0.13U
M241_keeper Vdd GND #448 Vdd pmos W=0.0975U L=0.585U
M242_ Vdd Sb_at_57_6 #fb453# Vdd pmos W=0.1625U L=0.13U
M243_keeper Vdd GND #451 Vdd pmos W=0.0975U L=0.585U
M244_ Vdd Sb_af_57_6 #fb456# Vdd pmos W=0.1625U L=0.13U
M245_keeper Vdd GND #454 Vdd pmos W=0.0975U L=0.585U
M246_ Vdd __pt_57_6 #fb459# Vdd pmos W=0.1625U L=0.13U
M247_keeper Vdd GND #457 Vdd pmos W=0.0975U L=0.585U
M248_ Vdd __pf_57_6 #fb462# Vdd pmos W=0.1625U L=0.13U
M249_keeper Vdd GND #460 Vdd pmos W=0.0975U L=0.585U
M250_keeper Vdd GND #463 Vdd pmos W=0.0975U L=0.585U
M251_ GND v #3 GND nmos W=0.0975U L=0.065U
M252_ GND __ia #8 GND nmos W=0.0975U L=0.065U
M253_ GND Sa_at_53_6 #37 GND nmos W=0.0975U L=0.065U
M254_ GND Sa_af_53_6 #37 GND nmos W=0.0975U L=0.065U
M255_ GND I_at_53_6 #42 GND nmos W=0.0975U L=0.065U
M256_ GND I_af_53_6 #42 GND nmos W=0.0975U L=0.065U
M257_ GND P_aa v GND nmos W=0.0975U L=0.065U
M258_ GND reset v GND nmos W=0.0975U L=0.065U
M259_ GND __v w GND nmos W=0.0975U L=0.065U
M260_ GND __it_50_6 Sa_at_50_6 GND nmos W=0.0975U L=0.065U
M261_ GND __if_50_6 Sa_af_50_6 GND nmos W=0.0975U L=0.065U
M262_ GND __it_51_6 Sa_at_51_6 GND nmos W=0.0975U L=0.065U
M263_ GND __if_51_6 Sa_af_51_6 GND nmos W=0.0975U L=0.065U
M264_ GND __it_52_6 Sa_at_52_6 GND nmos W=0.0975U L=0.065U
M265_ GND __if_52_6 Sa_af_52_6 GND nmos W=0.0975U L=0.065U
M266_ GND __it_53_6 Sa_at_53_6 GND nmos W=0.0975U L=0.065U
M267_ GND __if_53_6 Sa_af_53_6 GND nmos W=0.0975U L=0.065U
M268_ GND __qt_50_6 #109 GND nmos W=0.0975U L=0.065U
M269_ GND reset Sb_at_50_6 GND nmos W=0.0975U L=0.065U
M270_ GND __qf_50_6 #114 GND nmos W=0.0975U L=0.065U
M271_ GND reset Sb_af_50_6 GND nmos W=0.0975U L=0.065U
M272_ GND So_at_50_6 #116 GND nmos W=0.0975U L=0.065U
M273_ GND So_af_50_6 #119 GND nmos W=0.0975U L=0.065U
M274_ GND w __pf_50_6 GND nmos W=0.0975U L=0.065U
M275_ GND __qt_50_6 Cnt_at_50_6 GND nmos W=0.0975U L=0.065U
M276_ GND __qf_50_6 Cnt_af_50_6 GND nmos W=0.0975U L=0.065U
M277_ GND __qt_51_6 #127 GND nmos W=0.0975U L=0.065U
M278_ GND reset Sb_at_51_6 GND nmos W=0.0975U L=0.065U
M279_ GND __qf_51_6 #131 GND nmos W=0.0975U L=0.065U
M280_ GND reset Sb_af_51_6 GND nmos W=0.0975U L=0.065U
M281_ GND So_at_51_6 #133 GND nmos W=0.0975U L=0.065U
M282_ GND So_af_51_6 #136 GND nmos W=0.0975U L=0.065U
M283_ GND w __pf_51_6 GND nmos W=0.0975U L=0.065U
M284_ GND __qt_51_6 Cnt_at_51_6 GND nmos W=0.0975U L=0.065U
M285_ GND __qf_51_6 Cnt_af_51_6 GND nmos W=0.0975U L=0.065U
M286_ GND __qt_52_6 #144 GND nmos W=0.0975U L=0.065U
M287_ GND reset Sb_at_52_6 GND nmos W=0.0975U L=0.065U
M288_ GND __qf_52_6 #148 GND nmos W=0.0975U L=0.065U
M289_ GND reset Sb_af_52_6 GND nmos W=0.0975U L=0.065U
M290_ GND So_at_52_6 #150 GND nmos W=0.0975U L=0.065U
M291_ GND So_af_52_6 #153 GND nmos W=0.0975U L=0.065U
M292_ GND w __pf_52_6 GND nmos W=0.0975U L=0.065U
M293_ GND __qt_52_6 Cnt_at_52_6 GND nmos W=0.0975U L=0.065U
M294_ GND __qf_52_6 Cnt_af_52_6 GND nmos W=0.0975U L=0.065U
M295_ GND __qt_53_6 #161 GND nmos W=0.0975U L=0.065U
M296_ GND reset Sb_at_53_6 GND nmos W=0.0975U L=0.065U
M297_ GND __qf_53_6 #165 GND nmos W=0.0975U L=0.065U
M298_ GND reset Sb_af_53_6 GND nmos W=0.0975U L=0.065U
M299_ GND So_at_53_6 #167 GND nmos W=0.0975U L=0.065U
M300_ GND So_af_53_6 #170 GND nmos W=0.0975U L=0.065U
M301_ GND w __pf_53_6 GND nmos W=0.0975U L=0.065U
M302_ GND __qt_53_6 Cnt_at_53_6 GND nmos W=0.0975U L=0.065U
M303_ GND __qf_53_6 Cnt_af_53_6 GND nmos W=0.0975U L=0.065U
M304_ GND __qt_54_6 #178 GND nmos W=0.0975U L=0.065U
M305_ GND reset Sb_at_54_6 GND nmos W=0.0975U L=0.065U
M306_ GND __qf_54_6 #182 GND nmos W=0.0975U L=0.065U
M307_ GND reset Sb_af_54_6 GND nmos W=0.0975U L=0.065U
M308_ GND So_at_54_6 #184 GND nmos W=0.0975U L=0.065U
M309_ GND So_af_54_6 #187 GND nmos W=0.0975U L=0.065U
M310_ GND w __pf_54_6 GND nmos W=0.0975U L=0.065U
M311_ GND __qt_54_6 Cnt_at_54_6 GND nmos W=0.0975U L=0.065U
M312_ GND __qf_54_6 Cnt_af_54_6 GND nmos W=0.0975U L=0.065U
M313_ GND __qt_55_6 #195 GND nmos W=0.0975U L=0.065U
M314_ GND reset Sb_at_55_6 GND nmos W=0.0975U L=0.065U
M315_ GND __qf_55_6 #199 GND nmos W=0.0975U L=0.065U
M316_ GND reset Sb_af_55_6 GND nmos W=0.0975U L=0.065U
M317_ GND So_at_55_6 #201 GND nmos W=0.0975U L=0.065U
M318_ GND So_af_55_6 #204 GND nmos W=0.0975U L=0.065U
M319_ GND w __pf_55_6 GND nmos W=0.0975U L=0.065U
M320_ GND __qt_55_6 Cnt_at_55_6 GND nmos W=0.0975U L=0.065U
M321_ GND __qf_55_6 Cnt_af_55_6 GND nmos W=0.0975U L=0.065U
M322_ GND __qt_56_6 #212 GND nmos W=0.0975U L=0.065U
M323_ GND reset Sb_at_56_6 GND nmos W=0.0975U L=0.065U
M324_ GND __qf_56_6 #216 GND nmos W=0.0975U L=0.065U
M325_ GND reset Sb_af_56_6 GND nmos W=0.0975U L=0.065U
M326_ GND So_at_56_6 #218 GND nmos W=0.0975U L=0.065U
M327_ GND So_af_56_6 #221 GND nmos W=0.0975U L=0.065U
M328_ GND w __pf_56_6 GND nmos W=0.0975U L=0.065U
M329_ GND __qt_56_6 Cnt_at_56_6 GND nmos W=0.0975U L=0.065U
M330_ GND __qf_56_6 Cnt_af_56_6 GND nmos W=0.0975U L=0.065U
M331_ GND __qt_57_6 #229 GND nmos W=0.0975U L=0.065U
M332_ GND reset Sb_at_57_6 GND nmos W=0.0975U L=0.065U
M333_ GND __qf_57_6 #233 GND nmos W=0.0975U L=0.065U
M334_ GND reset Sb_af_57_6 GND nmos W=0.0975U L=0.065U
M335_ GND So_at_57_6 #235 GND nmos W=0.0975U L=0.065U
M336_ GND So_af_57_6 #238 GND nmos W=0.0975U L=0.065U
M337_ GND w __pf_57_6 GND nmos W=0.0975U L=0.065U
M338_ GND __qt_57_6 Cnt_at_57_6 GND nmos W=0.0975U L=0.065U
M339_ GND __qf_57_6 Cnt_af_57_6 GND nmos W=0.0975U L=0.065U
M340_ GND v __v GND nmos W=0.0975U L=0.065U
M341_ GND P_aa __pa GND nmos W=0.0975U L=0.065U
M342_ GND Cnt_areq __cr GND nmos W=0.0975U L=0.065U
M343_ GND reset __r GND nmos W=0.0975U L=0.065U
M344_ GND __k k GND nmos W=0.0975U L=0.065U
M345_ GND __ia I_aa GND nmos W=0.0975U L=0.065U
M346_ GND __qr Q_areq GND nmos W=0.0975U L=0.065U
M347_ GND I_at_50_6 __it_50_6 GND nmos W=0.0975U L=0.065U
M348_ GND I_af_50_6 __if_50_6 GND nmos W=0.0975U L=0.065U
M349_ GND I_at_51_6 __it_51_6 GND nmos W=0.0975U L=0.065U
M350_ GND I_af_51_6 __if_51_6 GND nmos W=0.0975U L=0.065U
M351_ GND I_at_52_6 __it_52_6 GND nmos W=0.0975U L=0.065U
M352_ GND I_af_52_6 __if_52_6 GND nmos W=0.0975U L=0.065U
M353_ GND I_at_53_6 __it_53_6 GND nmos W=0.0975U L=0.065U
M354_ GND I_af_53_6 __if_53_6 GND nmos W=0.0975U L=0.065U
M355_ GND Q_at_50_6 __qt_50_6 GND nmos W=0.0975U L=0.065U
M356_ GND Q_af_50_6 __qf_50_6 GND nmos W=0.0975U L=0.065U
M357_ GND Sb_at_50_6 __sbt_50_6 GND nmos W=0.0975U L=0.065U
M358_ GND Sb_af_50_6 __sbf_50_6 GND nmos W=0.0975U L=0.065U
M359_ GND __pt_50_6 P_at_50_6 GND nmos W=0.0975U L=0.065U
M360_ GND __pf_50_6 P_af_50_6 GND nmos W=0.0975U L=0.065U
M361_ GND Q_at_51_6 __qt_51_6 GND nmos W=0.0975U L=0.065U
M362_ GND Q_af_51_6 __qf_51_6 GND nmos W=0.0975U L=0.065U
M363_ GND Sb_at_51_6 __sbt_51_6 GND nmos W=0.0975U L=0.065U
M364_ GND Sb_af_51_6 __sbf_51_6 GND nmos W=0.0975U L=0.065U
M365_ GND __pt_51_6 P_at_51_6 GND nmos W=0.0975U L=0.065U
M366_ GND __pf_51_6 P_af_51_6 GND nmos W=0.0975U L=0.065U
M367_ GND Q_at_52_6 __qt_52_6 GND nmos W=0.0975U L=0.065U
M368_ GND Q_af_52_6 __qf_52_6 GND nmos W=0.0975U L=0.065U
M369_ GND Sb_at_52_6 __sbt_52_6 GND nmos W=0.0975U L=0.065U
M370_ GND Sb_af_52_6 __sbf_52_6 GND nmos W=0.0975U L=0.065U
M371_ GND __pt_52_6 P_at_52_6 GND nmos W=0.0975U L=0.065U
M372_ GND __pf_52_6 P_af_52_6 GND nmos W=0.0975U L=0.065U
M373_ GND Q_at_53_6 __qt_53_6 GND nmos W=0.0975U L=0.065U
M374_ GND Q_af_53_6 __qf_53_6 GND nmos W=0.0975U L=0.065U
M375_ GND Sb_at_53_6 __sbt_53_6 GND nmos W=0.0975U L=0.065U
M376_ GND Sb_af_53_6 __sbf_53_6 GND nmos W=0.0975U L=0.065U
M377_ GND __pt_53_6 P_at_53_6 GND nmos W=0.0975U L=0.065U
M378_ GND __pf_53_6 P_af_53_6 GND nmos W=0.0975U L=0.065U
M379_ GND Q_at_54_6 __qt_54_6 GND nmos W=0.0975U L=0.065U
M380_ GND Q_af_54_6 __qf_54_6 GND nmos W=0.0975U L=0.065U
M381_ GND Sb_at_54_6 __sbt_54_6 GND nmos W=0.0975U L=0.065U
M382_ GND Sb_af_54_6 __sbf_54_6 GND nmos W=0.0975U L=0.065U
M383_ GND __pt_54_6 P_at_54_6 GND nmos W=0.0975U L=0.065U
M384_ GND __pf_54_6 P_af_54_6 GND nmos W=0.0975U L=0.065U
M385_ GND Q_at_55_6 __qt_55_6 GND nmos W=0.0975U L=0.065U
M386_ GND Q_af_55_6 __qf_55_6 GND nmos W=0.0975U L=0.065U
M387_ GND Sb_at_55_6 __sbt_55_6 GND nmos W=0.0975U L=0.065U
M388_ GND Sb_af_55_6 __sbf_55_6 GND nmos W=0.0975U L=0.065U
M389_ GND __pt_55_6 P_at_55_6 GND nmos W=0.0975U L=0.065U
M390_ GND __pf_55_6 P_af_55_6 GND nmos W=0.0975U L=0.065U
M391_ GND Q_at_56_6 __qt_56_6 GND nmos W=0.0975U L=0.065U
M392_ GND Q_af_56_6 __qf_56_6 GND nmos W=0.0975U L=0.065U
M393_ GND Sb_at_56_6 __sbt_56_6 GND nmos W=0.0975U L=0.065U
M394_ GND Sb_af_56_6 __sbf_56_6 GND nmos W=0.0975U L=0.065U
M395_ GND __pt_56_6 P_at_56_6 GND nmos W=0.0975U L=0.065U
M396_ GND __pf_56_6 P_af_56_6 GND nmos W=0.0975U L=0.065U
M397_ GND Q_at_57_6 __qt_57_6 GND nmos W=0.0975U L=0.065U
M398_ GND Q_af_57_6 __qf_57_6 GND nmos W=0.0975U L=0.065U
M399_ GND Sb_at_57_6 __sbt_57_6 GND nmos W=0.0975U L=0.065U
M400_ GND Sb_af_57_6 __sbf_57_6 GND nmos W=0.0975U L=0.065U
M401_ GND __pt_57_6 P_at_57_6 GND nmos W=0.0975U L=0.065U
M402_ GND __pf_57_6 P_af_57_6 GND nmos W=0.0975U L=0.065U
M403_ GND __qr #fb282# GND nmos W=0.0975U L=0.13U
M404_ GND v #fb285# GND nmos W=0.0975U L=0.13U
M405_keeper GND Vdd #284 GND nmos W=0.0975U L=6.175U
M406_ GND __ia #fb288# GND nmos W=0.0975U L=0.13U
M407_keeper GND Vdd #287 GND nmos W=0.0975U L=0.715U
M408_ GND Sa_at_53_6 #fb291# GND nmos W=0.0975U L=0.13U
M409_keeper GND Vdd #290 GND nmos W=0.0975U L=0.715U
M410_ GND Sa_af_53_6 #fb294# GND nmos W=0.0975U L=0.13U
M411_keeper GND Vdd #293 GND nmos W=0.0975U L=1.495U
M412_ GND __k #fb297# GND nmos W=0.0975U L=0.13U
M413_keeper GND Vdd #296 GND nmos W=0.0975U L=1.495U
M414_ GND w #fb300# GND nmos W=0.0975U L=0.13U
M415_keeper GND Vdd #299 GND nmos W=0.0975U L=1.495U
M416_ GND Cnt_at_57_6 #fb303# GND nmos W=0.0975U L=0.13U
M417_keeper GND Vdd #302 GND nmos W=0.0975U L=13.975U
M418_ GND Cnt_af_57_6 #fb306# GND nmos W=0.0975U L=0.13U
M419_keeper GND Vdd #305 GND nmos W=0.0975U L=1.495U
M420_ GND Cnt_at_56_6 #fb309# GND nmos W=0.0975U L=0.13U
M421_keeper GND Vdd #308 GND nmos W=0.0975U L=1.495U
M422_ GND Cnt_af_56_6 #fb312# GND nmos W=0.0975U L=0.13U
M423_keeper GND Vdd #311 GND nmos W=0.0975U L=1.495U
M424_ GND Cnt_at_55_6 #fb315# GND nmos W=0.0975U L=0.13U
M425_keeper GND Vdd #314 GND nmos W=0.0975U L=1.495U
M426_ GND Cnt_af_55_6 #fb318# GND nmos W=0.0975U L=0.13U
M427_keeper GND Vdd #317 GND nmos W=0.0975U L=1.495U
M428_ GND Cnt_at_54_6 #fb321# GND nmos W=0.0975U L=0.13U
M429_keeper GND Vdd #320 GND nmos W=0.0975U L=1.495U
M430_ GND Cnt_af_54_6 #fb324# GND nmos W=0.0975U L=0.13U
M431_keeper GND Vdd #323 GND nmos W=0.0975U L=1.495U
M432_ GND Cnt_at_53_6 #fb327# GND nmos W=0.0975U L=0.13U
M433_keeper GND Vdd #326 GND nmos W=0.0975U L=1.495U
M434_ GND Cnt_af_53_6 #fb330# GND nmos W=0.0975U L=0.13U
M435_keeper GND Vdd #329 GND nmos W=0.0975U L=1.495U
M436_ GND Cnt_at_52_6 #fb333# GND nmos W=0.0975U L=0.13U
M437_keeper GND Vdd #332 GND nmos W=0.0975U L=1.495U
M438_ GND Cnt_af_52_6 #fb336# GND nmos W=0.0975U L=0.13U
M439_keeper GND Vdd #335 GND nmos W=0.0975U L=1.495U
M440_ GND Cnt_at_51_6 #fb339# GND nmos W=0.0975U L=0.13U
M441_keeper GND Vdd #338 GND nmos W=0.0975U L=1.495U
M442_ GND Cnt_af_51_6 #fb342# GND nmos W=0.0975U L=0.13U
M443_keeper GND Vdd #341 GND nmos W=0.0975U L=1.495U
M444_ GND Cnt_at_50_6 #fb345# GND nmos W=0.0975U L=0.13U
M445_keeper GND Vdd #344 GND nmos W=0.0975U L=1.495U
M446_ GND Cnt_af_50_6 #fb348# GND nmos W=0.0975U L=0.13U
M447_keeper GND Vdd #347 GND nmos W=0.0975U L=1.495U
M448_ GND Sa_at_50_6 #fb351# GND nmos W=0.0975U L=0.13U
M449_keeper GND Vdd #350 GND nmos W=0.0975U L=1.495U
M450_ GND Sa_af_50_6 #fb354# GND nmos W=0.0975U L=0.13U
M451_keeper GND Vdd #353 GND nmos W=0.0975U L=1.495U
M452_ GND Sa_at_51_6 #fb357# GND nmos W=0.0975U L=0.13U
M453_keeper GND Vdd #356 GND nmos W=0.0975U L=1.495U
M454_ GND Sa_af_51_6 #fb360# GND nmos W=0.0975U L=0.13U
M455_keeper GND Vdd #359 GND nmos W=0.0975U L=1.495U
M456_ GND Sa_at_52_6 #fb363# GND nmos W=0.0975U L=0.13U
M457_keeper GND Vdd #362 GND nmos W=0.0975U L=1.495U
M458_ GND Sa_af_52_6 #fb366# GND nmos W=0.0975U L=0.13U
M459_keeper GND Vdd #365 GND nmos W=0.0975U L=1.495U
M460_ GND Sb_at_50_6 #fb369# GND nmos W=0.0975U L=0.13U
M461_keeper GND Vdd #368 GND nmos W=0.0975U L=1.495U
M462_ GND Sb_af_50_6 #fb372# GND nmos W=0.0975U L=0.13U
M463_keeper GND Vdd #371 GND nmos W=0.0975U L=1.495U
M464_ GND __pt_50_6 #fb375# GND nmos W=0.0975U L=0.13U
M465_keeper GND Vdd #374 GND nmos W=0.0975U L=1.495U
M466_ GND __pf_50_6 #fb378# GND nmos W=0.0975U L=0.13U
M467_keeper GND Vdd #377 GND nmos W=0.0975U L=0.715U
M468_ GND Sb_at_51_6 #fb381# GND nmos W=0.0975U L=0.13U
M469_keeper GND Vdd #380 GND nmos W=0.0975U L=1.495U
M470_ GND Sb_af_51_6 #fb384# GND nmos W=0.0975U L=0.13U
M471_keeper GND Vdd #383 GND nmos W=0.0975U L=1.495U
M472_ GND __pt_51_6 #fb387# GND nmos W=0.0975U L=0.13U
M473_keeper GND Vdd #386 GND nmos W=0.0975U L=1.495U
M474_ GND __pf_51_6 #fb390# GND nmos W=0.0975U L=0.13U
M475_keeper GND Vdd #389 GND nmos W=0.0975U L=0.715U
M476_ GND Sb_at_52_6 #fb393# GND nmos W=0.0975U L=0.13U
M477_keeper GND Vdd #392 GND nmos W=0.0975U L=1.495U
M478_ GND Sb_af_52_6 #fb396# GND nmos W=0.0975U L=0.13U
M479_keeper GND Vdd #395 GND nmos W=0.0975U L=1.495U
M480_ GND __pt_52_6 #fb399# GND nmos W=0.0975U L=0.13U
M481_keeper GND Vdd #398 GND nmos W=0.0975U L=1.495U
M482_ GND __pf_52_6 #fb402# GND nmos W=0.0975U L=0.13U
M483_keeper GND Vdd #401 GND nmos W=0.0975U L=0.715U
M484_ GND Sb_at_53_6 #fb405# GND nmos W=0.0975U L=0.13U
M485_keeper GND Vdd #404 GND nmos W=0.0975U L=1.495U
M486_ GND Sb_af_53_6 #fb408# GND nmos W=0.0975U L=0.13U
M487_keeper GND Vdd #407 GND nmos W=0.0975U L=1.495U
M488_ GND __pt_53_6 #fb411# GND nmos W=0.0975U L=0.13U
M489_keeper GND Vdd #410 GND nmos W=0.0975U L=1.495U
M490_ GND __pf_53_6 #fb414# GND nmos W=0.0975U L=0.13U
M491_keeper GND Vdd #413 GND nmos W=0.0975U L=0.715U
M492_ GND Sb_at_54_6 #fb417# GND nmos W=0.0975U L=0.13U
M493_keeper GND Vdd #416 GND nmos W=0.0975U L=1.495U
M494_ GND Sb_af_54_6 #fb420# GND nmos W=0.0975U L=0.13U
M495_keeper GND Vdd #419 GND nmos W=0.0975U L=1.495U
M496_ GND __pt_54_6 #fb423# GND nmos W=0.0975U L=0.13U
M497_keeper GND Vdd #422 GND nmos W=0.0975U L=1.495U
M498_ GND __pf_54_6 #fb426# GND nmos W=0.0975U L=0.13U
M499_keeper GND Vdd #425 GND nmos W=0.0975U L=0.715U
M500_ GND Sb_at_55_6 #fb429# GND nmos W=0.0975U L=0.13U
M501_keeper GND Vdd #428 GND nmos W=0.0975U L=1.495U
M502_ GND Sb_af_55_6 #fb432# GND nmos W=0.0975U L=0.13U
M503_keeper GND Vdd #431 GND nmos W=0.0975U L=1.495U
M504_ GND __pt_55_6 #fb435# GND nmos W=0.0975U L=0.13U
M505_keeper GND Vdd #434 GND nmos W=0.0975U L=1.495U
M506_ GND __pf_55_6 #fb438# GND nmos W=0.0975U L=0.13U
M507_keeper GND Vdd #437 GND nmos W=0.0975U L=0.715U
M508_ GND Sb_at_56_6 #fb441# GND nmos W=0.0975U L=0.13U
M509_keeper GND Vdd #440 GND nmos W=0.0975U L=1.495U
M510_ GND Sb_af_56_6 #fb444# GND nmos W=0.0975U L=0.13U
M511_keeper GND Vdd #443 GND nmos W=0.0975U L=1.495U
M512_ GND __pt_56_6 #fb447# GND nmos W=0.0975U L=0.13U
M513_keeper GND Vdd #446 GND nmos W=0.0975U L=1.495U
M514_ GND __pf_56_6 #fb450# GND nmos W=0.0975U L=0.13U
M515_keeper GND Vdd #449 GND nmos W=0.0975U L=0.715U
M516_ GND Sb_at_57_6 #fb453# GND nmos W=0.0975U L=0.13U
M517_keeper GND Vdd #452 GND nmos W=0.0975U L=1.495U
M518_ GND Sb_af_57_6 #fb456# GND nmos W=0.0975U L=0.13U
M519_keeper GND Vdd #455 GND nmos W=0.0975U L=1.495U
M520_ GND __pt_57_6 #fb459# GND nmos W=0.0975U L=0.13U
M521_keeper GND Vdd #458 GND nmos W=0.0975U L=1.495U
M522_ GND __pf_57_6 #fb462# GND nmos W=0.0975U L=0.13U
M523_keeper GND Vdd #461 GND nmos W=0.0975U L=0.715U
M524_keeper GND Vdd #464 GND nmos W=0.0975U L=1.495U
M525_ #3 Cnt_areq __qr GND nmos W=0.0975U L=0.065U
M526_ #6 k __qr GND nmos W=0.0975U L=0.065U
M527_ #13 Cnt_areq __qr Vdd pmos W=0.1625U L=0.065U
M528_ #15 __sbt_50_6 __qr Vdd pmos W=0.1625U L=0.065U
M529_ #15 __sbf_50_6 __qr Vdd pmos W=0.1625U L=0.065U
M530_keeper #283 #fb282# __qr Vdd pmos W=0.0975U L=0.065U
M531_keeper #284 #fb282# __qr GND nmos W=0.0975U L=0.065U
M532_keeper #286 #fb285# v Vdd pmos W=0.0975U L=0.065U
M533_keeper #287 #fb285# v GND nmos W=0.0975U L=0.065U
M534_ #7 __sbf_57_6 #6 GND nmos W=0.0975U L=0.065U
M535_ #8 __sbt_57_6 #7 GND nmos W=0.0975U L=0.065U
M536_ #37 P_aa __ia GND nmos W=0.0975U L=0.065U
M537_keeper #289 #fb288# __ia Vdd pmos W=0.0975U L=0.065U
M538_keeper #290 #fb288# __ia GND nmos W=0.0975U L=0.065U
M539_ #16 __sbt_51_6 #15 Vdd pmos W=0.1625U L=0.065U
M540_ #16 __sbf_51_6 #15 Vdd pmos W=0.1625U L=0.065U
M541_ #17 __sbt_52_6 #16 Vdd pmos W=0.1625U L=0.065U
M542_ #17 __sbf_52_6 #16 Vdd pmos W=0.1625U L=0.065U
M543_ #18 __sbt_53_6 #17 Vdd pmos W=0.1625U L=0.065U
M544_ #18 __sbf_53_6 #17 Vdd pmos W=0.1625U L=0.065U
M545_ #19 __sbt_54_6 #18 Vdd pmos W=0.1625U L=0.065U
M546_ #19 __sbf_54_6 #18 Vdd pmos W=0.1625U L=0.065U
M547_ #20 __sbt_55_6 #19 Vdd pmos W=0.1625U L=0.065U
M548_ #20 __sbf_55_6 #19 Vdd pmos W=0.1625U L=0.065U
M549_ #21 __sbt_56_6 #20 Vdd pmos W=0.1625U L=0.065U
M550_ #21 __sbf_56_6 #20 Vdd pmos W=0.1625U L=0.065U
M551_ #102 __k Sa_at_53_6 Vdd pmos W=0.1625U L=0.065U
M552_keeper #292 #fb291# Sa_at_53_6 Vdd pmos W=0.0975U L=0.065U
M553_keeper #293 #fb291# Sa_at_53_6 GND nmos W=0.0975U L=0.065U
M554_ #104 __k Sa_af_53_6 Vdd pmos W=0.1625U L=0.065U
M555_keeper #295 #fb294# Sa_af_53_6 Vdd pmos W=0.0975U L=0.065U
M556_keeper #296 #fb294# Sa_af_53_6 GND nmos W=0.0975U L=0.065U
M557_ #45 __v __k GND nmos W=0.0975U L=0.065U
M558_ #47 __ia __k Vdd pmos W=0.1625U L=0.065U
M559_keeper #298 #fb297# __k Vdd pmos W=0.0975U L=0.065U
M560_keeper #299 #fb297# __k GND nmos W=0.0975U L=0.065U
M561_ #42 __pa #45 GND nmos W=0.0975U L=0.065U
M562_ #81 Cnt_af_50_6 w Vdd pmos W=0.1625U L=0.065U
M563_keeper #301 #fb300# w Vdd pmos W=0.0975U L=0.065U
M564_keeper #302 #fb300# w GND nmos W=0.0975U L=0.065U
M565_ #52 Cnt_areq #51 Vdd pmos W=0.1625U L=0.065U
M566_ #51 Cnt_at_57_6 #60 Vdd pmos W=0.1625U L=0.065U
M567_ #78 Cnt_af_51_6 #53 Vdd pmos W=0.1625U L=0.065U
M568_ #53 Cnt_at_50_6 #81 Vdd pmos W=0.1625U L=0.065U
M569_ #75 Cnt_af_52_6 #54 Vdd pmos W=0.1625U L=0.065U
M570_ #54 Cnt_at_51_6 #78 Vdd pmos W=0.1625U L=0.065U
M571_ #72 Cnt_af_53_6 #55 Vdd pmos W=0.1625U L=0.065U
M572_ #55 Cnt_at_52_6 #75 Vdd pmos W=0.1625U L=0.065U
M573_ #69 Cnt_af_54_6 #56 Vdd pmos W=0.1625U L=0.065U
M574_ #56 Cnt_at_53_6 #72 Vdd pmos W=0.1625U L=0.065U
M575_ #66 Cnt_af_55_6 #57 Vdd pmos W=0.1625U L=0.065U
M576_ #57 Cnt_at_54_6 #69 Vdd pmos W=0.1625U L=0.065U
M577_ #63 Cnt_af_56_6 #58 Vdd pmos W=0.1625U L=0.065U
M578_ #58 Cnt_at_55_6 #66 Vdd pmos W=0.1625U L=0.065U
M579_ #60 Cnt_af_57_6 #59 Vdd pmos W=0.1625U L=0.065U
M580_ #59 Cnt_at_56_6 #63 Vdd pmos W=0.1625U L=0.065U
M581_ #241 __qt_57_6 Cnt_at_57_6 Vdd pmos W=0.1625U L=0.065U
M582_keeper #304 #fb303# Cnt_at_57_6 Vdd pmos W=0.0975U L=0.065U
M583_keeper #305 #fb303# Cnt_at_57_6 GND nmos W=0.0975U L=0.065U
M584_ #242 __qf_57_6 Cnt_af_57_6 Vdd pmos W=0.1625U L=0.065U
M585_keeper #307 #fb306# Cnt_af_57_6 Vdd pmos W=0.0975U L=0.065U
M586_keeper #308 #fb306# Cnt_af_57_6 GND nmos W=0.0975U L=0.065U
M587_ #224 __qt_56_6 Cnt_at_56_6 Vdd pmos W=0.1625U L=0.065U
M588_keeper #310 #fb309# Cnt_at_56_6 Vdd pmos W=0.0975U L=0.065U
M589_keeper #311 #fb309# Cnt_at_56_6 GND nmos W=0.0975U L=0.065U
M590_ #225 __qf_56_6 Cnt_af_56_6 Vdd pmos W=0.1625U L=0.065U
M591_keeper #313 #fb312# Cnt_af_56_6 Vdd pmos W=0.0975U L=0.065U
M592_keeper #314 #fb312# Cnt_af_56_6 GND nmos W=0.0975U L=0.065U
M593_ #207 __qt_55_6 Cnt_at_55_6 Vdd pmos W=0.1625U L=0.065U
M594_keeper #316 #fb315# Cnt_at_55_6 Vdd pmos W=0.0975U L=0.065U
M595_keeper #317 #fb315# Cnt_at_55_6 GND nmos W=0.0975U L=0.065U
M596_ #208 __qf_55_6 Cnt_af_55_6 Vdd pmos W=0.1625U L=0.065U
M597_keeper #319 #fb318# Cnt_af_55_6 Vdd pmos W=0.0975U L=0.065U
M598_keeper #320 #fb318# Cnt_af_55_6 GND nmos W=0.0975U L=0.065U
M599_ #190 __qt_54_6 Cnt_at_54_6 Vdd pmos W=0.1625U L=0.065U
M600_keeper #322 #fb321# Cnt_at_54_6 Vdd pmos W=0.0975U L=0.065U
M601_keeper #323 #fb321# Cnt_at_54_6 GND nmos W=0.0975U L=0.065U
M602_ #191 __qf_54_6 Cnt_af_54_6 Vdd pmos W=0.1625U L=0.065U
M603_keeper #325 #fb324# Cnt_af_54_6 Vdd pmos W=0.0975U L=0.065U
M604_keeper #326 #fb324# Cnt_af_54_6 GND nmos W=0.0975U L=0.065U
M605_ #173 __qt_53_6 Cnt_at_53_6 Vdd pmos W=0.1625U L=0.065U
M606_keeper #328 #fb327# Cnt_at_53_6 Vdd pmos W=0.0975U L=0.065U
M607_keeper #329 #fb327# Cnt_at_53_6 GND nmos W=0.0975U L=0.065U
M608_ #174 __qf_53_6 Cnt_af_53_6 Vdd pmos W=0.1625U L=0.065U
M609_keeper #331 #fb330# Cnt_af_53_6 Vdd pmos W=0.0975U L=0.065U
M610_keeper #332 #fb330# Cnt_af_53_6 GND nmos W=0.0975U L=0.065U
M611_ #156 __qt_52_6 Cnt_at_52_6 Vdd pmos W=0.1625U L=0.065U
M612_keeper #334 #fb333# Cnt_at_52_6 Vdd pmos W=0.0975U L=0.065U
M613_keeper #335 #fb333# Cnt_at_52_6 GND nmos W=0.0975U L=0.065U
M614_ #157 __qf_52_6 Cnt_af_52_6 Vdd pmos W=0.1625U L=0.065U
M615_keeper #337 #fb336# Cnt_af_52_6 Vdd pmos W=0.0975U L=0.065U
M616_keeper #338 #fb336# Cnt_af_52_6 GND nmos W=0.0975U L=0.065U
M617_ #139 __qt_51_6 Cnt_at_51_6 Vdd pmos W=0.1625U L=0.065U
M618_keeper #340 #fb339# Cnt_at_51_6 Vdd pmos W=0.0975U L=0.065U
M619_keeper #341 #fb339# Cnt_at_51_6 GND nmos W=0.0975U L=0.065U
M620_ #140 __qf_51_6 Cnt_af_51_6 Vdd pmos W=0.1625U L=0.065U
M621_keeper #343 #fb342# Cnt_af_51_6 Vdd pmos W=0.0975U L=0.065U
M622_keeper #344 #fb342# Cnt_af_51_6 GND nmos W=0.0975U L=0.065U
M623_ #122 __qt_50_6 Cnt_at_50_6 Vdd pmos W=0.1625U L=0.065U
M624_keeper #346 #fb345# Cnt_at_50_6 Vdd pmos W=0.0975U L=0.065U
M625_keeper #347 #fb345# Cnt_at_50_6 GND nmos W=0.0975U L=0.065U
M626_ #123 __qf_50_6 Cnt_af_50_6 Vdd pmos W=0.1625U L=0.065U
M627_keeper #349 #fb348# Cnt_af_50_6 Vdd pmos W=0.0975U L=0.065U
M628_keeper #350 #fb348# Cnt_af_50_6 GND nmos W=0.0975U L=0.065U
M629_ #85 __k Sa_at_50_6 Vdd pmos W=0.1625U L=0.065U
M630_keeper #352 #fb351# Sa_at_50_6 Vdd pmos W=0.0975U L=0.065U
M631_keeper #353 #fb351# Sa_at_50_6 GND nmos W=0.0975U L=0.065U
M632_ #88 __k Sa_af_50_6 Vdd pmos W=0.1625U L=0.065U
M633_keeper #355 #fb354# Sa_af_50_6 Vdd pmos W=0.0975U L=0.065U
M634_keeper #356 #fb354# Sa_af_50_6 GND nmos W=0.0975U L=0.065U
M635_ #91 __k Sa_at_51_6 Vdd pmos W=0.1625U L=0.065U
M636_keeper #358 #fb357# Sa_at_51_6 Vdd pmos W=0.0975U L=0.065U
M637_keeper #359 #fb357# Sa_at_51_6 GND nmos W=0.0975U L=0.065U
M638_ #94 __k Sa_af_51_6 Vdd pmos W=0.1625U L=0.065U
M639_keeper #361 #fb360# Sa_af_51_6 Vdd pmos W=0.0975U L=0.065U
M640_keeper #362 #fb360# Sa_af_51_6 GND nmos W=0.0975U L=0.065U
M641_ #97 __k Sa_at_52_6 Vdd pmos W=0.1625U L=0.065U
M642_keeper #364 #fb363# Sa_at_52_6 Vdd pmos W=0.0975U L=0.065U
M643_keeper #365 #fb363# Sa_at_52_6 GND nmos W=0.0975U L=0.065U
M644_ #100 __k Sa_af_52_6 Vdd pmos W=0.1625U L=0.065U
M645_keeper #367 #fb366# Sa_af_52_6 Vdd pmos W=0.0975U L=0.065U
M646_keeper #368 #fb366# Sa_af_52_6 GND nmos W=0.0975U L=0.065U
M647_ #107 __k Sb_at_50_6 Vdd pmos W=0.1625U L=0.065U
M648_ #109 I_aa Sb_at_50_6 GND nmos W=0.0975U L=0.065U
M649_keeper #370 #fb369# Sb_at_50_6 Vdd pmos W=0.0975U L=0.065U
M650_keeper #371 #fb369# Sb_at_50_6 GND nmos W=0.0975U L=0.065U
M651_ #112 __k Sb_af_50_6 Vdd pmos W=0.1625U L=0.065U
M652_ #114 I_aa Sb_af_50_6 GND nmos W=0.0975U L=0.065U
M653_keeper #373 #fb372# Sb_af_50_6 Vdd pmos W=0.0975U L=0.065U
M654_keeper #374 #fb372# Sb_af_50_6 GND nmos W=0.0975U L=0.065U
M655_ #116 __qr __pt_50_6 GND nmos W=0.0975U L=0.065U
M656_keeper #376 #fb375# __pt_50_6 Vdd pmos W=0.0975U L=0.065U
M657_keeper #377 #fb375# __pt_50_6 GND nmos W=0.0975U L=0.065U
M658_ #119 __qr __pf_50_6 GND nmos W=0.0975U L=0.065U
M659_ #121 w __pf_50_6 Vdd pmos W=0.1625U L=0.065U
M660_keeper #379 #fb378# __pf_50_6 Vdd pmos W=0.0975U L=0.065U
M661_keeper #380 #fb378# __pf_50_6 GND nmos W=0.0975U L=0.065U
M662_ #125 __k Sb_at_51_6 Vdd pmos W=0.1625U L=0.065U
M663_ #127 I_aa Sb_at_51_6 GND nmos W=0.0975U L=0.065U
M664_keeper #382 #fb381# Sb_at_51_6 Vdd pmos W=0.0975U L=0.065U
M665_keeper #383 #fb381# Sb_at_51_6 GND nmos W=0.0975U L=0.065U
M666_ #129 __k Sb_af_51_6 Vdd pmos W=0.1625U L=0.065U
M667_ #131 I_aa Sb_af_51_6 GND nmos W=0.0975U L=0.065U
M668_keeper #385 #fb384# Sb_af_51_6 Vdd pmos W=0.0975U L=0.065U
M669_keeper #386 #fb384# Sb_af_51_6 GND nmos W=0.0975U L=0.065U
M670_ #133 __qr __pt_51_6 GND nmos W=0.0975U L=0.065U
M671_keeper #388 #fb387# __pt_51_6 Vdd pmos W=0.0975U L=0.065U
M672_keeper #389 #fb387# __pt_51_6 GND nmos W=0.0975U L=0.065U
M673_ #136 __qr __pf_51_6 GND nmos W=0.0975U L=0.065U
M674_ #138 w __pf_51_6 Vdd pmos W=0.1625U L=0.065U
M675_keeper #391 #fb390# __pf_51_6 Vdd pmos W=0.0975U L=0.065U
M676_keeper #392 #fb390# __pf_51_6 GND nmos W=0.0975U L=0.065U
M677_ #142 __k Sb_at_52_6 Vdd pmos W=0.1625U L=0.065U
M678_ #144 I_aa Sb_at_52_6 GND nmos W=0.0975U L=0.065U
M679_keeper #394 #fb393# Sb_at_52_6 Vdd pmos W=0.0975U L=0.065U
M680_keeper #395 #fb393# Sb_at_52_6 GND nmos W=0.0975U L=0.065U
M681_ #146 __k Sb_af_52_6 Vdd pmos W=0.1625U L=0.065U
M682_ #148 I_aa Sb_af_52_6 GND nmos W=0.0975U L=0.065U
M683_keeper #397 #fb396# Sb_af_52_6 Vdd pmos W=0.0975U L=0.065U
M684_keeper #398 #fb396# Sb_af_52_6 GND nmos W=0.0975U L=0.065U
M685_ #150 __qr __pt_52_6 GND nmos W=0.0975U L=0.065U
M686_keeper #400 #fb399# __pt_52_6 Vdd pmos W=0.0975U L=0.065U
M687_keeper #401 #fb399# __pt_52_6 GND nmos W=0.0975U L=0.065U
M688_ #153 __qr __pf_52_6 GND nmos W=0.0975U L=0.065U
M689_ #155 w __pf_52_6 Vdd pmos W=0.1625U L=0.065U
M690_keeper #403 #fb402# __pf_52_6 Vdd pmos W=0.0975U L=0.065U
M691_keeper #404 #fb402# __pf_52_6 GND nmos W=0.0975U L=0.065U
M692_ #159 __k Sb_at_53_6 Vdd pmos W=0.1625U L=0.065U
M693_ #161 I_aa Sb_at_53_6 GND nmos W=0.0975U L=0.065U
M694_keeper #406 #fb405# Sb_at_53_6 Vdd pmos W=0.0975U L=0.065U
M695_keeper #407 #fb405# Sb_at_53_6 GND nmos W=0.0975U L=0.065U
M696_ #163 __k Sb_af_53_6 Vdd pmos W=0.1625U L=0.065U
M697_ #165 I_aa Sb_af_53_6 GND nmos W=0.0975U L=0.065U
M698_keeper #409 #fb408# Sb_af_53_6 Vdd pmos W=0.0975U L=0.065U
M699_keeper #410 #fb408# Sb_af_53_6 GND nmos W=0.0975U L=0.065U
M700_ #167 __qr __pt_53_6 GND nmos W=0.0975U L=0.065U
M701_keeper #412 #fb411# __pt_53_6 Vdd pmos W=0.0975U L=0.065U
M702_keeper #413 #fb411# __pt_53_6 GND nmos W=0.0975U L=0.065U
M703_ #170 __qr __pf_53_6 GND nmos W=0.0975U L=0.065U
M704_ #172 w __pf_53_6 Vdd pmos W=0.1625U L=0.065U
M705_keeper #415 #fb414# __pf_53_6 Vdd pmos W=0.0975U L=0.065U
M706_keeper #416 #fb414# __pf_53_6 GND nmos W=0.0975U L=0.065U
M707_ #176 __k Sb_at_54_6 Vdd pmos W=0.1625U L=0.065U
M708_ #178 I_aa Sb_at_54_6 GND nmos W=0.0975U L=0.065U
M709_keeper #418 #fb417# Sb_at_54_6 Vdd pmos W=0.0975U L=0.065U
M710_keeper #419 #fb417# Sb_at_54_6 GND nmos W=0.0975U L=0.065U
M711_ #180 __k Sb_af_54_6 Vdd pmos W=0.1625U L=0.065U
M712_ #182 I_aa Sb_af_54_6 GND nmos W=0.0975U L=0.065U
M713_keeper #421 #fb420# Sb_af_54_6 Vdd pmos W=0.0975U L=0.065U
M714_keeper #422 #fb420# Sb_af_54_6 GND nmos W=0.0975U L=0.065U
M715_ #184 __qr __pt_54_6 GND nmos W=0.0975U L=0.065U
M716_keeper #424 #fb423# __pt_54_6 Vdd pmos W=0.0975U L=0.065U
M717_keeper #425 #fb423# __pt_54_6 GND nmos W=0.0975U L=0.065U
M718_ #187 __qr __pf_54_6 GND nmos W=0.0975U L=0.065U
M719_ #189 w __pf_54_6 Vdd pmos W=0.1625U L=0.065U
M720_keeper #427 #fb426# __pf_54_6 Vdd pmos W=0.0975U L=0.065U
M721_keeper #428 #fb426# __pf_54_6 GND nmos W=0.0975U L=0.065U
M722_ #193 __k Sb_at_55_6 Vdd pmos W=0.1625U L=0.065U
M723_ #195 I_aa Sb_at_55_6 GND nmos W=0.0975U L=0.065U
M724_keeper #430 #fb429# Sb_at_55_6 Vdd pmos W=0.0975U L=0.065U
M725_keeper #431 #fb429# Sb_at_55_6 GND nmos W=0.0975U L=0.065U
M726_ #197 __k Sb_af_55_6 Vdd pmos W=0.1625U L=0.065U
M727_ #199 I_aa Sb_af_55_6 GND nmos W=0.0975U L=0.065U
M728_keeper #433 #fb432# Sb_af_55_6 Vdd pmos W=0.0975U L=0.065U
M729_keeper #434 #fb432# Sb_af_55_6 GND nmos W=0.0975U L=0.065U
M730_ #201 __qr __pt_55_6 GND nmos W=0.0975U L=0.065U
M731_keeper #436 #fb435# __pt_55_6 Vdd pmos W=0.0975U L=0.065U
M732_keeper #437 #fb435# __pt_55_6 GND nmos W=0.0975U L=0.065U
M733_ #204 __qr __pf_55_6 GND nmos W=0.0975U L=0.065U
M734_ #206 w __pf_55_6 Vdd pmos W=0.1625U L=0.065U
M735_keeper #439 #fb438# __pf_55_6 Vdd pmos W=0.0975U L=0.065U
M736_keeper #440 #fb438# __pf_55_6 GND nmos W=0.0975U L=0.065U
M737_ #210 __k Sb_at_56_6 Vdd pmos W=0.1625U L=0.065U
M738_ #212 I_aa Sb_at_56_6 GND nmos W=0.0975U L=0.065U
M739_keeper #442 #fb441# Sb_at_56_6 Vdd pmos W=0.0975U L=0.065U
M740_keeper #443 #fb441# Sb_at_56_6 GND nmos W=0.0975U L=0.065U
M741_ #214 __k Sb_af_56_6 Vdd pmos W=0.1625U L=0.065U
M742_ #216 I_aa Sb_af_56_6 GND nmos W=0.0975U L=0.065U
M743_keeper #445 #fb444# Sb_af_56_6 Vdd pmos W=0.0975U L=0.065U
M744_keeper #446 #fb444# Sb_af_56_6 GND nmos W=0.0975U L=0.065U
M745_ #218 __qr __pt_56_6 GND nmos W=0.0975U L=0.065U
M746_keeper #448 #fb447# __pt_56_6 Vdd pmos W=0.0975U L=0.065U
M747_keeper #449 #fb447# __pt_56_6 GND nmos W=0.0975U L=0.065U
M748_ #221 __qr __pf_56_6 GND nmos W=0.0975U L=0.065U
M749_ #223 w __pf_56_6 Vdd pmos W=0.1625U L=0.065U
M750_keeper #451 #fb450# __pf_56_6 Vdd pmos W=0.0975U L=0.065U
M751_keeper #452 #fb450# __pf_56_6 GND nmos W=0.0975U L=0.065U
M752_ #227 __k Sb_at_57_6 Vdd pmos W=0.1625U L=0.065U
M753_ #229 I_aa Sb_at_57_6 GND nmos W=0.0975U L=0.065U
M754_keeper #454 #fb453# Sb_at_57_6 Vdd pmos W=0.0975U L=0.065U
M755_keeper #455 #fb453# Sb_at_57_6 GND nmos W=0.0975U L=0.065U
M756_ #231 __k Sb_af_57_6 Vdd pmos W=0.1625U L=0.065U
M757_ #233 I_aa Sb_af_57_6 GND nmos W=0.0975U L=0.065U
M758_keeper #457 #fb456# Sb_af_57_6 Vdd pmos W=0.0975U L=0.065U
M759_keeper #458 #fb456# Sb_af_57_6 GND nmos W=0.0975U L=0.065U
M760_ #235 __qr __pt_57_6 GND nmos W=0.0975U L=0.065U
M761_keeper #460 #fb459# __pt_57_6 Vdd pmos W=0.0975U L=0.065U
M762_keeper #461 #fb459# __pt_57_6 GND nmos W=0.0975U L=0.065U
M763_ #238 __qr __pf_57_6 GND nmos W=0.0975U L=0.065U
M764_ #240 w __pf_57_6 Vdd pmos W=0.1625U L=0.065U
M765_keeper #463 #fb462# __pf_57_6 Vdd pmos W=0.0975U L=0.065U
M766_keeper #464 #fb462# __pf_57_6 GND nmos W=0.0975U L=0.065U
.ends
*---- end of process: CounterLogic<> -----
*
*---- act defproc: Counter<> -----
* raw ports:  reset I.t[0] I.t[1] I.t[2] I.t[3] I.f[0] I.f[1] I.f[2] I.f[3] I.a Cnt.req Cnt.t[0] Cnt.t[1] Cnt.t[2] Cnt.t[3] Cnt.t[4] Cnt.t[5] Cnt.t[6] Cnt.t[7] Cnt.f[0] Cnt.f[1] Cnt.f[2] Cnt.f[3] Cnt.f[4] Cnt.f[5] Cnt.f[6] Cnt.f[7]
*
.subckt Counter reset I_at_50_6 I_at_51_6 I_at_52_6 I_at_53_6 I_af_50_6 I_af_51_6 I_af_52_6 I_af_53_6 I_aa Cnt_areq Cnt_at_50_6 Cnt_at_51_6 Cnt_at_52_6 Cnt_at_53_6 Cnt_at_54_6 Cnt_at_55_6 Cnt_at_56_6 Cnt_at_57_6 Cnt_af_50_6 Cnt_af_51_6 Cnt_af_52_6 Cnt_af_53_6 Cnt_af_54_6 Cnt_af_55_6 Cnt_af_56_6 Cnt_af_57_6
*.PININFO reset:I I_at_50_6:I I_at_51_6:I I_at_52_6:I I_at_53_6:I I_af_50_6:I I_af_51_6:I I_af_52_6:I I_af_53_6:I I_aa:O Cnt_areq:I Cnt_at_50_6:O Cnt_at_51_6:O Cnt_at_52_6:O Cnt_at_53_6:O Cnt_at_54_6:O Cnt_at_55_6:O Cnt_at_56_6:O Cnt_at_57_6:O Cnt_af_50_6:O Cnt_af_51_6:O Cnt_af_52_6:O Cnt_af_53_6:O Cnt_af_54_6:O Cnt_af_55_6:O Cnt_af_56_6:O Cnt_af_57_6:O
*.POWER VDD Vdd
*.POWER GND GND
*.POWER NSUB GND
*.POWER PSUB Vdd
xreg reset reg_aW_at_50_6 reg_aW_at_51_6 reg_aW_at_52_6 reg_aW_at_53_6 reg_aW_at_54_6 reg_aW_at_55_6 reg_aW_at_56_6 reg_aW_at_57_6 reg_aW_af_50_6 reg_aW_af_51_6 reg_aW_af_52_6 reg_aW_af_53_6 reg_aW_af_54_6 reg_aW_af_55_6 reg_aW_af_56_6 reg_aW_af_57_6 reg_aW_aa reg_aR_areq reg_aR_at_50_6 reg_aR_at_51_6 reg_aR_at_52_6 reg_aR_at_53_6 reg_aR_at_54_6 reg_aR_at_55_6 reg_aR_at_56_6 reg_aR_at_57_6 reg_aR_af_50_6 reg_aR_af_51_6 reg_aR_af_52_6 reg_aR_af_53_6 reg_aR_af_54_6 reg_aR_af_55_6 reg_aR_af_56_6 reg_aR_af_57_6 Reg8
xinc reset inc_aSa_at_50_6 inc_aSa_at_51_6 inc_aSa_at_52_6 inc_aSa_at_53_6 inc_aSa_af_50_6 inc_aSa_af_51_6 inc_aSa_af_52_6 inc_aSa_af_53_6 inc_aSb_at_50_6 inc_aSb_at_51_6 inc_aSb_at_52_6 inc_aSb_at_53_6 inc_aSb_at_54_6 inc_aSb_at_55_6 inc_aSb_at_56_6 inc_aSb_at_57_6 inc_aSb_af_50_6 inc_aSb_af_51_6 inc_aSb_af_52_6 inc_aSb_af_53_6 inc_aSb_af_54_6 inc_aSb_af_55_6 inc_aSb_af_56_6 inc_aSb_af_57_6 inc_aSo_at_50_6 inc_aSo_at_51_6 inc_aSo_at_52_6 inc_aSo_at_53_6 inc_aSo_at_54_6 inc_aSo_at_55_6 inc_aSo_at_56_6 inc_aSo_at_57_6 inc_aSo_af_50_6 inc_aSo_af_51_6 inc_aSo_af_52_6 inc_aSo_af_53_6 inc_aSo_af_54_6 inc_aSo_af_55_6 inc_aSo_af_56_6 inc_aSo_af_57_6 CounterInc
xlogic reset I_at_50_6 I_at_51_6 I_at_52_6 I_at_53_6 I_af_50_6 I_af_51_6 I_af_52_6 I_af_53_6 I_aa Cnt_areq Cnt_at_50_6 Cnt_at_51_6 Cnt_at_52_6 Cnt_at_53_6 Cnt_at_54_6 Cnt_at_55_6 Cnt_at_56_6 Cnt_at_57_6 Cnt_af_50_6 Cnt_af_51_6 Cnt_af_52_6 Cnt_af_53_6 Cnt_af_54_6 Cnt_af_55_6 Cnt_af_56_6 Cnt_af_57_6 reg_aW_at_50_6 reg_aW_at_51_6 reg_aW_at_52_6 reg_aW_at_53_6 reg_aW_at_54_6 reg_aW_at_55_6 reg_aW_at_56_6 reg_aW_at_57_6 reg_aW_af_50_6 reg_aW_af_51_6 reg_aW_af_52_6 reg_aW_af_53_6 reg_aW_af_54_6 reg_aW_af_55_6 reg_aW_af_56_6 reg_aW_af_57_6 reg_aW_aa reg_aR_areq reg_aR_at_50_6 reg_aR_at_51_6 reg_aR_at_52_6 reg_aR_at_53_6 reg_aR_at_54_6 reg_aR_at_55_6 reg_aR_at_56_6 reg_aR_at_57_6 reg_aR_af_50_6 reg_aR_af_51_6 reg_aR_af_52_6 reg_aR_af_53_6 reg_aR_af_54_6 reg_aR_af_55_6 reg_aR_af_56_6 reg_aR_af_57_6 inc_aSa_at_50_6 inc_aSa_at_51_6 inc_aSa_at_52_6 inc_aSa_at_53_6 inc_aSa_af_50_6 inc_aSa_af_51_6 inc_aSa_af_52_6 inc_aSa_af_53_6 inc_aSb_at_50_6 inc_aSb_at_51_6 inc_aSb_at_52_6 inc_aSb_at_53_6 inc_aSb_at_54_6 inc_aSb_at_55_6 inc_aSb_at_56_6 inc_aSb_at_57_6 inc_aSb_af_50_6 inc_aSb_af_51_6 inc_aSb_af_52_6 inc_aSb_af_53_6 inc_aSb_af_54_6 inc_aSb_af_55_6 inc_aSb_af_56_6 inc_aSb_af_57_6 inc_aSo_at_50_6 inc_aSo_at_51_6 inc_aSo_at_52_6 inc_aSo_at_53_6 inc_aSo_at_54_6 inc_aSo_at_55_6 inc_aSo_at_56_6 inc_aSo_at_57_6 inc_aSo_af_50_6 inc_aSo_af_51_6 inc_aSo_af_52_6 inc_aSo_af_53_6 inc_aSo_af_54_6 inc_aSo_af_55_6 inc_aSo_af_56_6 inc_aSo_af_57_6 CounterLogic
.ends
*---- end of process: Counter<> -----
*
*---- act defproc: QSlicer<> -----
* raw ports:  I.t[0] I.t[1] I.t[2] I.t[3] I.f[0] I.f[1] I.f[2] I.f[3] A.req O.t[0] O.t[1] O.t[2] O.t[3] O.f[0] O.f[1] O.f[2] O.f[3]
*
.subckt QSlicer I_at_50_6 I_at_51_6 I_at_52_6 I_at_53_6 I_af_50_6 I_af_51_6 I_af_52_6 I_af_53_6 A_areq O_at_50_6 O_at_51_6 O_at_52_6 O_at_53_6 O_af_50_6 O_af_51_6 O_af_52_6 O_af_53_6
*.PININFO I_at_50_6:I I_at_51_6:I I_at_52_6:I I_at_53_6:I I_af_50_6:I I_af_51_6:I I_af_52_6:I I_af_53_6:I A_areq:I O_at_50_6:O O_at_51_6:O O_at_52_6:O O_at_53_6:O O_af_50_6:O O_af_51_6:O O_af_52_6:O O_af_53_6:O
*.POWER VDD Vdd
*.POWER GND GND
*.POWER NSUB GND
*.POWER PSUB Vdd
*
* --- node flags ---
*
* __o__t_50_6 (state-holding): pup_reff=0.4; pdn_reff=1.33333
* __o__f_50_6 (state-holding): pup_reff=0.4; pdn_reff=1.33333
* O_at_50_6 (combinational)
* O_af_50_6 (combinational)
* __o__t_51_6 (state-holding): pup_reff=0.4; pdn_reff=1.33333
* __o__f_51_6 (state-holding): pup_reff=0.4; pdn_reff=1.33333
* O_at_51_6 (combinational)
* O_af_51_6 (combinational)
* __o__t_52_6 (state-holding): pup_reff=0.4; pdn_reff=1.33333
* __o__f_52_6 (state-holding): pup_reff=0.4; pdn_reff=1.33333
* O_at_52_6 (combinational)
* O_af_52_6 (combinational)
* __o__t_53_6 (state-holding): pup_reff=0.4; pdn_reff=1.33333
* __o__f_53_6 (state-holding): pup_reff=0.4; pdn_reff=1.33333
* O_at_53_6 (combinational)
* O_af_53_6 (combinational)
*
* --- end node flags ---
*
M0_ Vdd I_at_50_6 __o__t_50_6 Vdd pmos W=0.1625U L=0.065U
M1_ Vdd I_af_50_6 __o__f_50_6 Vdd pmos W=0.1625U L=0.065U
M2_ Vdd __o__t_50_6 O_at_50_6 Vdd pmos W=0.1625U L=0.065U
M3_ Vdd __o__f_50_6 O_af_50_6 Vdd pmos W=0.1625U L=0.065U
M4_ Vdd I_at_51_6 __o__t_51_6 Vdd pmos W=0.1625U L=0.065U
M5_ Vdd I_af_51_6 __o__f_51_6 Vdd pmos W=0.1625U L=0.065U
M6_ Vdd __o__t_51_6 O_at_51_6 Vdd pmos W=0.1625U L=0.065U
M7_ Vdd __o__f_51_6 O_af_51_6 Vdd pmos W=0.1625U L=0.065U
M8_ Vdd I_at_52_6 __o__t_52_6 Vdd pmos W=0.1625U L=0.065U
M9_ Vdd I_af_52_6 __o__f_52_6 Vdd pmos W=0.1625U L=0.065U
M10_ Vdd __o__t_52_6 O_at_52_6 Vdd pmos W=0.1625U L=0.065U
M11_ Vdd __o__f_52_6 O_af_52_6 Vdd pmos W=0.1625U L=0.065U
M12_ Vdd I_at_53_6 __o__t_53_6 Vdd pmos W=0.1625U L=0.065U
M13_ Vdd I_af_53_6 __o__f_53_6 Vdd pmos W=0.1625U L=0.065U
M14_ Vdd __o__t_53_6 O_at_53_6 Vdd pmos W=0.1625U L=0.065U
M15_ Vdd __o__f_53_6 O_af_53_6 Vdd pmos W=0.1625U L=0.065U
M16_ Vdd __o__t_50_6 #fb35# Vdd pmos W=0.1625U L=0.13U
M17_ Vdd __o__f_50_6 #fb38# Vdd pmos W=0.1625U L=0.13U
M18_keeper Vdd GND #36 Vdd pmos W=0.0975U L=0.585U
M19_ Vdd __o__t_51_6 #fb41# Vdd pmos W=0.1625U L=0.13U
M20_keeper Vdd GND #39 Vdd pmos W=0.0975U L=0.585U
M21_ Vdd __o__f_51_6 #fb44# Vdd pmos W=0.1625U L=0.13U
M22_keeper Vdd GND #42 Vdd pmos W=0.0975U L=0.585U
M23_ Vdd __o__t_52_6 #fb47# Vdd pmos W=0.1625U L=0.13U
M24_keeper Vdd GND #45 Vdd pmos W=0.0975U L=0.585U
M25_ Vdd __o__f_52_6 #fb50# Vdd pmos W=0.1625U L=0.13U
M26_keeper Vdd GND #48 Vdd pmos W=0.0975U L=0.585U
M27_ Vdd __o__t_53_6 #fb53# Vdd pmos W=0.1625U L=0.13U
M28_keeper Vdd GND #51 Vdd pmos W=0.0975U L=0.585U
M29_ Vdd __o__f_53_6 #fb56# Vdd pmos W=0.1625U L=0.13U
M30_keeper Vdd GND #54 Vdd pmos W=0.0975U L=0.585U
M31_keeper Vdd GND #57 Vdd pmos W=0.0975U L=0.585U
M32_ GND I_at_50_6 #3 GND nmos W=0.0975U L=0.065U
M33_ GND I_af_50_6 #7 GND nmos W=0.0975U L=0.065U
M34_ GND __o__t_50_6 O_at_50_6 GND nmos W=0.0975U L=0.065U
M35_ GND __o__f_50_6 O_af_50_6 GND nmos W=0.0975U L=0.065U
M36_ GND I_at_51_6 #12 GND nmos W=0.0975U L=0.065U
M37_ GND I_af_51_6 #15 GND nmos W=0.0975U L=0.065U
M38_ GND __o__t_51_6 O_at_51_6 GND nmos W=0.0975U L=0.065U
M39_ GND __o__f_51_6 O_af_51_6 GND nmos W=0.0975U L=0.065U
M40_ GND I_at_52_6 #20 GND nmos W=0.0975U L=0.065U
M41_ GND I_af_52_6 #23 GND nmos W=0.0975U L=0.065U
M42_ GND __o__t_52_6 O_at_52_6 GND nmos W=0.0975U L=0.065U
M43_ GND __o__f_52_6 O_af_52_6 GND nmos W=0.0975U L=0.065U
M44_ GND I_at_53_6 #28 GND nmos W=0.0975U L=0.065U
M45_ GND I_af_53_6 #31 GND nmos W=0.0975U L=0.065U
M46_ GND __o__t_53_6 O_at_53_6 GND nmos W=0.0975U L=0.065U
M47_ GND __o__f_53_6 O_af_53_6 GND nmos W=0.0975U L=0.065U
M48_ GND __o__t_50_6 #fb35# GND nmos W=0.0975U L=0.13U
M49_ GND __o__f_50_6 #fb38# GND nmos W=0.0975U L=0.13U
M50_keeper GND Vdd #37 GND nmos W=0.0975U L=0.715U
M51_ GND __o__t_51_6 #fb41# GND nmos W=0.0975U L=0.13U
M52_keeper GND Vdd #40 GND nmos W=0.0975U L=0.715U
M53_ GND __o__f_51_6 #fb44# GND nmos W=0.0975U L=0.13U
M54_keeper GND Vdd #43 GND nmos W=0.0975U L=0.715U
M55_ GND __o__t_52_6 #fb47# GND nmos W=0.0975U L=0.13U
M56_keeper GND Vdd #46 GND nmos W=0.0975U L=0.715U
M57_ GND __o__f_52_6 #fb50# GND nmos W=0.0975U L=0.13U
M58_keeper GND Vdd #49 GND nmos W=0.0975U L=0.715U
M59_ GND __o__t_53_6 #fb53# GND nmos W=0.0975U L=0.13U
M60_keeper GND Vdd #52 GND nmos W=0.0975U L=0.715U
M61_ GND __o__f_53_6 #fb56# GND nmos W=0.0975U L=0.13U
M62_keeper GND Vdd #55 GND nmos W=0.0975U L=0.715U
M63_keeper GND Vdd #58 GND nmos W=0.0975U L=0.715U
M64_ #3 A_areq __o__t_50_6 GND nmos W=0.0975U L=0.065U
M65_keeper #36 #fb35# __o__t_50_6 Vdd pmos W=0.0975U L=0.065U
M66_keeper #37 #fb35# __o__t_50_6 GND nmos W=0.0975U L=0.065U
M67_ #7 A_areq __o__f_50_6 GND nmos W=0.0975U L=0.065U
M68_keeper #39 #fb38# __o__f_50_6 Vdd pmos W=0.0975U L=0.065U
M69_keeper #40 #fb38# __o__f_50_6 GND nmos W=0.0975U L=0.065U
M70_ #12 A_areq __o__t_51_6 GND nmos W=0.0975U L=0.065U
M71_keeper #42 #fb41# __o__t_51_6 Vdd pmos W=0.0975U L=0.065U
M72_keeper #43 #fb41# __o__t_51_6 GND nmos W=0.0975U L=0.065U
M73_ #15 A_areq __o__f_51_6 GND nmos W=0.0975U L=0.065U
M74_keeper #45 #fb44# __o__f_51_6 Vdd pmos W=0.0975U L=0.065U
M75_keeper #46 #fb44# __o__f_51_6 GND nmos W=0.0975U L=0.065U
M76_ #20 A_areq __o__t_52_6 GND nmos W=0.0975U L=0.065U
M77_keeper #48 #fb47# __o__t_52_6 Vdd pmos W=0.0975U L=0.065U
M78_keeper #49 #fb47# __o__t_52_6 GND nmos W=0.0975U L=0.065U
M79_ #23 A_areq __o__f_52_6 GND nmos W=0.0975U L=0.065U
M80_keeper #51 #fb50# __o__f_52_6 Vdd pmos W=0.0975U L=0.065U
M81_keeper #52 #fb50# __o__f_52_6 GND nmos W=0.0975U L=0.065U
M82_ #28 A_areq __o__t_53_6 GND nmos W=0.0975U L=0.065U
M83_keeper #54 #fb53# __o__t_53_6 Vdd pmos W=0.0975U L=0.065U
M84_keeper #55 #fb53# __o__t_53_6 GND nmos W=0.0975U L=0.065U
M85_ #31 A_areq __o__f_53_6 GND nmos W=0.0975U L=0.065U
M86_keeper #57 #fb56# __o__f_53_6 Vdd pmos W=0.0975U L=0.065U
M87_keeper #58 #fb56# __o__f_53_6 GND nmos W=0.0975U L=0.065U
.ends
*---- end of process: QSlicer<> -----
*
*---- act defproc: Seq7<> -----
* raw ports:  reset A0.req A0.a A1.req A1.a A2.req A2.a A3.req A3.a A4.req A4.a A5.req A5.a A6.req A6.a
*
.subckt Seq7 reset A0_areq A0_aa A1_areq A1_aa A2_areq A2_aa A3_areq A3_aa A4_areq A4_aa A5_areq A5_aa A6_areq A6_aa
*.PININFO reset:I A0_areq:O A0_aa:I A1_areq:O A1_aa:I A2_areq:O A2_aa:I A3_areq:O A3_aa:I A4_areq:O A4_aa:I A5_areq:O A5_aa:I A6_areq:O A6_aa:I
*.POWER VDD Vdd
*.POWER GND GND
*.POWER NSUB GND
*.POWER PSUB Vdd
*
* --- node flags ---
*
* q7 (state-holding): pup_reff=0.8; pdn_reff=1.33333
* __r (combinational)
* __a_56_6 (combinational)
* q6 (state-holding): pup_reff=0.8; pdn_reff=1.33333
* __a_50_6 (combinational)
* q5 (state-holding): pup_reff=0.8; pdn_reff=1.33333
* __a_51_6 (combinational)
* q4 (state-holding): pup_reff=0.8; pdn_reff=1.33333
* __a_52_6 (combinational)
* q3 (state-holding): pup_reff=0.8; pdn_reff=1.33333
* __a_53_6 (combinational)
* q2 (state-holding): pup_reff=0.8; pdn_reff=1.33333
* __a_54_6 (combinational)
* q1 (state-holding): pup_reff=0.8; pdn_reff=1.33333
* __a_55_6 (combinational)
* A0_areq (state-holding): pup_reff=0.8; pdn_reff=0.666667
* __q7 (combinational)
* A1_areq (state-holding): pup_reff=0.8; pdn_reff=0.666667
* __q6 (combinational)
* A2_areq (state-holding): pup_reff=0.8; pdn_reff=0.666667
* __q5 (combinational)
* A3_areq (state-holding): pup_reff=0.8; pdn_reff=0.666667
* __q4 (combinational)
* A4_areq (state-holding): pup_reff=0.8; pdn_reff=0.666667
* __q3 (combinational)
* A5_areq (state-holding): pup_reff=0.8; pdn_reff=0.666667
* __q2 (combinational)
* A6_areq (state-holding): pup_reff=0.8; pdn_reff=0.666667
* __q1 (combinational)
*
* --- end node flags ---
*
M0_ Vdd __r q7 Vdd pmos W=0.1625U L=0.065U
M1_ Vdd __a_56_6 #4 Vdd pmos W=0.1625U L=0.065U
M2_ Vdd __a_50_6 #8 Vdd pmos W=0.1625U L=0.065U
M3_ Vdd __a_51_6 #13 Vdd pmos W=0.1625U L=0.065U
M4_ Vdd __a_52_6 #17 Vdd pmos W=0.1625U L=0.065U
M5_ Vdd __a_53_6 #21 Vdd pmos W=0.1625U L=0.065U
M6_ Vdd __a_54_6 #25 Vdd pmos W=0.1625U L=0.065U
M7_ Vdd __a_55_6 #29 Vdd pmos W=0.1625U L=0.065U
M8_ Vdd __q7 #33 Vdd pmos W=0.1625U L=0.065U
M9_ Vdd __q6 #37 Vdd pmos W=0.1625U L=0.065U
M10_ Vdd __q5 #41 Vdd pmos W=0.1625U L=0.065U
M11_ Vdd __q4 #45 Vdd pmos W=0.1625U L=0.065U
M12_ Vdd __q3 #49 Vdd pmos W=0.1625U L=0.065U
M13_ Vdd __q2 #53 Vdd pmos W=0.1625U L=0.065U
M14_ Vdd __q1 #57 Vdd pmos W=0.1625U L=0.065U
M15_ Vdd reset __r Vdd pmos W=0.1625U L=0.065U
M16_ Vdd A0_aa __a_50_6 Vdd pmos W=0.1625U L=0.065U
M17_ Vdd A1_aa __a_51_6 Vdd pmos W=0.1625U L=0.065U
M18_ Vdd A2_aa __a_52_6 Vdd pmos W=0.1625U L=0.065U
M19_ Vdd A3_aa __a_53_6 Vdd pmos W=0.1625U L=0.065U
M20_ Vdd A4_aa __a_54_6 Vdd pmos W=0.1625U L=0.065U
M21_ Vdd A5_aa __a_55_6 Vdd pmos W=0.1625U L=0.065U
M22_ Vdd A6_aa __a_56_6 Vdd pmos W=0.1625U L=0.065U
M23_ Vdd q7 __q7 Vdd pmos W=0.1625U L=0.065U
M24_ Vdd q6 __q6 Vdd pmos W=0.1625U L=0.065U
M25_ Vdd q5 __q5 Vdd pmos W=0.1625U L=0.065U
M26_ Vdd q4 __q4 Vdd pmos W=0.1625U L=0.065U
M27_ Vdd q3 __q3 Vdd pmos W=0.1625U L=0.065U
M28_ Vdd q2 __q2 Vdd pmos W=0.1625U L=0.065U
M29_ Vdd q1 __q1 Vdd pmos W=0.1625U L=0.065U
M30_ Vdd q7 #fb60# Vdd pmos W=0.1625U L=0.13U
M31_ Vdd q6 #fb63# Vdd pmos W=0.1625U L=0.13U
M32_keeper Vdd GND #61 Vdd pmos W=0.0975U L=0.585U
M33_ Vdd q5 #fb66# Vdd pmos W=0.1625U L=0.13U
M34_keeper Vdd GND #64 Vdd pmos W=0.0975U L=0.585U
M35_ Vdd q4 #fb69# Vdd pmos W=0.1625U L=0.13U
M36_keeper Vdd GND #67 Vdd pmos W=0.0975U L=0.585U
M37_ Vdd q3 #fb72# Vdd pmos W=0.1625U L=0.13U
M38_keeper Vdd GND #70 Vdd pmos W=0.0975U L=0.585U
M39_ Vdd q2 #fb75# Vdd pmos W=0.1625U L=0.13U
M40_keeper Vdd GND #73 Vdd pmos W=0.0975U L=0.585U
M41_ Vdd q1 #fb78# Vdd pmos W=0.1625U L=0.13U
M42_keeper Vdd GND #76 Vdd pmos W=0.0975U L=0.585U
M43_ Vdd A0_areq #fb81# Vdd pmos W=0.1625U L=0.13U
M44_keeper Vdd GND #79 Vdd pmos W=0.0975U L=0.585U
M45_ Vdd A1_areq #fb84# Vdd pmos W=0.1625U L=0.13U
M46_keeper Vdd GND #82 Vdd pmos W=0.0975U L=0.26U
M47_ Vdd A2_areq #fb87# Vdd pmos W=0.1625U L=0.13U
M48_keeper Vdd GND #85 Vdd pmos W=0.0975U L=0.26U
M49_ Vdd A3_areq #fb90# Vdd pmos W=0.1625U L=0.13U
M50_keeper Vdd GND #88 Vdd pmos W=0.0975U L=0.26U
M51_ Vdd A4_areq #fb93# Vdd pmos W=0.1625U L=0.13U
M52_keeper Vdd GND #91 Vdd pmos W=0.0975U L=0.26U
M53_ Vdd A5_areq #fb96# Vdd pmos W=0.1625U L=0.13U
M54_keeper Vdd GND #94 Vdd pmos W=0.0975U L=0.26U
M55_ Vdd A6_areq #fb99# Vdd pmos W=0.1625U L=0.13U
M56_keeper Vdd GND #97 Vdd pmos W=0.0975U L=0.26U
M57_keeper Vdd GND #100 Vdd pmos W=0.0975U L=0.26U
M58_ GND __a_56_6 #7 GND nmos W=0.0975U L=0.065U
M59_ GND reset q6 GND nmos W=0.0975U L=0.065U
M60_ GND __a_50_6 #12 GND nmos W=0.0975U L=0.065U
M61_ GND reset q5 GND nmos W=0.0975U L=0.065U
M62_ GND __a_51_6 #16 GND nmos W=0.0975U L=0.065U
M63_ GND reset q4 GND nmos W=0.0975U L=0.065U
M64_ GND __a_52_6 #20 GND nmos W=0.0975U L=0.065U
M65_ GND reset q3 GND nmos W=0.0975U L=0.065U
M66_ GND __a_53_6 #24 GND nmos W=0.0975U L=0.065U
M67_ GND reset q2 GND nmos W=0.0975U L=0.065U
M68_ GND __a_54_6 #28 GND nmos W=0.0975U L=0.065U
M69_ GND reset q1 GND nmos W=0.0975U L=0.065U
M70_ GND __a_55_6 #31 GND nmos W=0.0975U L=0.065U
M71_ GND __q7 A0_areq GND nmos W=0.0975U L=0.065U
M72_ GND __q6 A1_areq GND nmos W=0.0975U L=0.065U
M73_ GND __q5 A2_areq GND nmos W=0.0975U L=0.065U
M74_ GND __q4 A3_areq GND nmos W=0.0975U L=0.065U
M75_ GND __q3 A4_areq GND nmos W=0.0975U L=0.065U
M76_ GND __q2 A5_areq GND nmos W=0.0975U L=0.065U
M77_ GND __q1 A6_areq GND nmos W=0.0975U L=0.065U
M78_ GND reset __r GND nmos W=0.0975U L=0.065U
M79_ GND A0_aa __a_50_6 GND nmos W=0.0975U L=0.065U
M80_ GND A1_aa __a_51_6 GND nmos W=0.0975U L=0.065U
M81_ GND A2_aa __a_52_6 GND nmos W=0.0975U L=0.065U
M82_ GND A3_aa __a_53_6 GND nmos W=0.0975U L=0.065U
M83_ GND A4_aa __a_54_6 GND nmos W=0.0975U L=0.065U
M84_ GND A5_aa __a_55_6 GND nmos W=0.0975U L=0.065U
M85_ GND A6_aa __a_56_6 GND nmos W=0.0975U L=0.065U
M86_ GND q7 __q7 GND nmos W=0.0975U L=0.065U
M87_ GND q6 __q6 GND nmos W=0.0975U L=0.065U
M88_ GND q5 __q5 GND nmos W=0.0975U L=0.065U
M89_ GND q4 __q4 GND nmos W=0.0975U L=0.065U
M90_ GND q3 __q3 GND nmos W=0.0975U L=0.065U
M91_ GND q2 __q2 GND nmos W=0.0975U L=0.065U
M92_ GND q1 __q1 GND nmos W=0.0975U L=0.065U
M93_ GND q7 #fb60# GND nmos W=0.0975U L=0.13U
M94_ GND q6 #fb63# GND nmos W=0.0975U L=0.13U
M95_keeper GND Vdd #62 GND nmos W=0.0975U L=1.495U
M96_ GND q5 #fb66# GND nmos W=0.0975U L=0.13U
M97_keeper GND Vdd #65 GND nmos W=0.0975U L=1.495U
M98_ GND q4 #fb69# GND nmos W=0.0975U L=0.13U
M99_keeper GND Vdd #68 GND nmos W=0.0975U L=1.495U
M100_ GND q3 #fb72# GND nmos W=0.0975U L=0.13U
M101_keeper GND Vdd #71 GND nmos W=0.0975U L=1.495U
M102_ GND q2 #fb75# GND nmos W=0.0975U L=0.13U
M103_keeper GND Vdd #74 GND nmos W=0.0975U L=1.495U
M104_ GND q1 #fb78# GND nmos W=0.0975U L=0.13U
M105_keeper GND Vdd #77 GND nmos W=0.0975U L=1.495U
M106_ GND A0_areq #fb81# GND nmos W=0.0975U L=0.13U
M107_keeper GND Vdd #80 GND nmos W=0.0975U L=1.495U
M108_ GND A1_areq #fb84# GND nmos W=0.0975U L=0.13U
M109_keeper GND Vdd #83 GND nmos W=0.0975U L=1.495U
M110_ GND A2_areq #fb87# GND nmos W=0.0975U L=0.13U
M111_keeper GND Vdd #86 GND nmos W=0.0975U L=1.495U
M112_ GND A3_areq #fb90# GND nmos W=0.0975U L=0.13U
M113_keeper GND Vdd #89 GND nmos W=0.0975U L=1.495U
M114_ GND A4_areq #fb93# GND nmos W=0.0975U L=0.13U
M115_keeper GND Vdd #92 GND nmos W=0.0975U L=1.495U
M116_ GND A5_areq #fb96# GND nmos W=0.0975U L=0.13U
M117_keeper GND Vdd #95 GND nmos W=0.0975U L=1.495U
M118_ GND A6_areq #fb99# GND nmos W=0.0975U L=0.13U
M119_keeper GND Vdd #98 GND nmos W=0.0975U L=1.495U
M120_keeper GND Vdd #101 GND nmos W=0.0975U L=1.495U
M121_ #4 q6 q7 Vdd pmos W=0.1625U L=0.065U
M122_ #7 q6 q7 GND nmos W=0.0975U L=0.065U
M123_keeper #61 #fb60# q7 Vdd pmos W=0.0975U L=0.065U
M124_keeper #62 #fb60# q7 GND nmos W=0.0975U L=0.065U
M125_ #8 q5 q6 Vdd pmos W=0.1625U L=0.065U
M126_ #12 q5 q6 GND nmos W=0.0975U L=0.065U
M127_keeper #64 #fb63# q6 Vdd pmos W=0.0975U L=0.065U
M128_keeper #65 #fb63# q6 GND nmos W=0.0975U L=0.065U
M129_ #13 q4 q5 Vdd pmos W=0.1625U L=0.065U
M130_ #16 q4 q5 GND nmos W=0.0975U L=0.065U
M131_keeper #67 #fb66# q5 Vdd pmos W=0.0975U L=0.065U
M132_keeper #68 #fb66# q5 GND nmos W=0.0975U L=0.065U
M133_ #17 q3 q4 Vdd pmos W=0.1625U L=0.065U
M134_ #20 q3 q4 GND nmos W=0.0975U L=0.065U
M135_keeper #70 #fb69# q4 Vdd pmos W=0.0975U L=0.065U
M136_keeper #71 #fb69# q4 GND nmos W=0.0975U L=0.065U
M137_ #21 q2 q3 Vdd pmos W=0.1625U L=0.065U
M138_ #24 q2 q3 GND nmos W=0.0975U L=0.065U
M139_keeper #73 #fb72# q3 Vdd pmos W=0.0975U L=0.065U
M140_keeper #74 #fb72# q3 GND nmos W=0.0975U L=0.065U
M141_ #25 q1 q2 Vdd pmos W=0.1625U L=0.065U
M142_ #28 q1 q2 GND nmos W=0.0975U L=0.065U
M143_keeper #76 #fb75# q2 Vdd pmos W=0.0975U L=0.065U
M144_keeper #77 #fb75# q2 GND nmos W=0.0975U L=0.065U
M145_ #29 q7 q1 Vdd pmos W=0.1625U L=0.065U
M146_ #31 q7 q1 GND nmos W=0.0975U L=0.065U
M147_keeper #79 #fb78# q1 Vdd pmos W=0.0975U L=0.065U
M148_keeper #80 #fb78# q1 GND nmos W=0.0975U L=0.065U
M149_ #33 A6_aa A0_areq Vdd pmos W=0.1625U L=0.065U
M150_keeper #82 #fb81# A0_areq Vdd pmos W=0.0975U L=0.065U
M151_keeper #83 #fb81# A0_areq GND nmos W=0.0975U L=0.065U
M152_ #37 A0_aa A1_areq Vdd pmos W=0.1625U L=0.065U
M153_keeper #85 #fb84# A1_areq Vdd pmos W=0.0975U L=0.065U
M154_keeper #86 #fb84# A1_areq GND nmos W=0.0975U L=0.065U
M155_ #41 A1_aa A2_areq Vdd pmos W=0.1625U L=0.065U
M156_keeper #88 #fb87# A2_areq Vdd pmos W=0.0975U L=0.065U
M157_keeper #89 #fb87# A2_areq GND nmos W=0.0975U L=0.065U
M158_ #45 A2_aa A3_areq Vdd pmos W=0.1625U L=0.065U
M159_keeper #91 #fb90# A3_areq Vdd pmos W=0.0975U L=0.065U
M160_keeper #92 #fb90# A3_areq GND nmos W=0.0975U L=0.065U
M161_ #49 A3_aa A4_areq Vdd pmos W=0.1625U L=0.065U
M162_keeper #94 #fb93# A4_areq Vdd pmos W=0.0975U L=0.065U
M163_keeper #95 #fb93# A4_areq GND nmos W=0.0975U L=0.065U
M164_ #53 A4_aa A5_areq Vdd pmos W=0.1625U L=0.065U
M165_keeper #97 #fb96# A5_areq Vdd pmos W=0.0975U L=0.065U
M166_keeper #98 #fb96# A5_areq GND nmos W=0.0975U L=0.065U
M167_ #57 A5_aa A6_areq Vdd pmos W=0.1625U L=0.065U
M168_keeper #100 #fb99# A6_areq Vdd pmos W=0.0975U L=0.065U
M169_keeper #101 #fb99# A6_areq GND nmos W=0.0975U L=0.065U
.ends
*---- end of process: Seq7<> -----
*
*---- act defproc: WordBuffer<> -----
* raw ports:  reset I.t[0] I.t[1] I.t[2] I.t[3] I.t[4] I.t[5] I.t[6] I.t[7] I.t[8] I.t[9] I.t[10] I.t[11] I.t[12] I.t[13] I.t[14] I.t[15] I.t[16] I.t[17] I.t[18] I.t[19] I.t[20] I.t[21] I.t[22] I.t[23] I.t[24] I.t[25] I.t[26] I.t[27] I.t[28] I.t[29] I.t[30] I.t[31] I.f[0] I.f[1] I.f[2] I.f[3] I.f[4] I.f[5] I.f[6] I.f[7] I.f[8] I.f[9] I.f[10] I.f[11] I.f[12] I.f[13] I.f[14] I.f[15] I.f[16] I.f[17] I.f[18] I.f[19] I.f[20] I.f[21] I.f[22] I.f[23] I.f[24] I.f[25] I.f[26] I.f[27] I.f[28] I.f[29] I.f[30] I.f[31] I.a O1.t[0] O1.t[1] O1.t[2] O1.t[3] O1.f[0] O1.f[1] O1.f[2] O1.f[3] O1.a O2.t[0] O2.t[1] O2.t[2] O2.t[3] O2.f[0] O2.f[1] O2.f[2] O2.f[3] O2.a O3.t[0] O3.t[1] O3.t[2] O3.t[3] O3.f[0] O3.f[1] O3.f[2] O3.f[3] O3.a O4.t[0] O4.t[1] O4.t[2] O4.t[3] O4.f[0] O4.f[1] O4.f[2] O4.f[3] O4.a O5.t[0] O5.t[1] O5.t[2] O5.t[3] O5.f[0] O5.f[1] O5.f[2] O5.f[3] O5.a O6.t[0] O6.t[1] O6.t[2] O6.t[3] O6.f[0] O6.f[1] O6.f[2] O6.f[3] O6.a O7.t[0] O7.t[1] O7.t[2] O7.t[3] O7.f[0] O7.f[1] O7.f[2] O7.f[3] O7.a
*
.subckt WordBuffer reset I_at_50_6 I_at_51_6 I_at_52_6 I_at_53_6 I_at_54_6 I_at_55_6 I_at_56_6 I_at_57_6 I_at_58_6 I_at_59_6 I_at_510_6 I_at_511_6 I_at_512_6 I_at_513_6 I_at_514_6 I_at_515_6 I_at_516_6 I_at_517_6 I_at_518_6 I_at_519_6 I_at_520_6 I_at_521_6 I_at_522_6 I_at_523_6 I_at_524_6 I_at_525_6 I_at_526_6 I_at_527_6 I_at_528_6 I_at_529_6 I_at_530_6 I_at_531_6 I_af_50_6 I_af_51_6 I_af_52_6 I_af_53_6 I_af_54_6 I_af_55_6 I_af_56_6 I_af_57_6 I_af_58_6 I_af_59_6 I_af_510_6 I_af_511_6 I_af_512_6 I_af_513_6 I_af_514_6 I_af_515_6 I_af_516_6 I_af_517_6 I_af_518_6 I_af_519_6 I_af_520_6 I_af_521_6 I_af_522_6 I_af_523_6 I_af_524_6 I_af_525_6 I_af_526_6 I_af_527_6 I_af_528_6 I_af_529_6 I_af_530_6 I_af_531_6 I_aa O1_at_50_6 O1_at_51_6 O1_at_52_6 O1_at_53_6 O1_af_50_6 O1_af_51_6 O1_af_52_6 O1_af_53_6 O1_aa O2_at_50_6 O2_at_51_6 O2_at_52_6 O2_at_53_6 O2_af_50_6 O2_af_51_6 O2_af_52_6 O2_af_53_6 O2_aa O3_at_50_6 O3_at_51_6 O3_at_52_6 O3_at_53_6 O3_af_50_6 O3_af_51_6 O3_af_52_6 O3_af_53_6 O3_aa O4_at_50_6 O4_at_51_6 O4_at_52_6 O4_at_53_6 O4_af_50_6 O4_af_51_6 O4_af_52_6 O4_af_53_6 O4_aa O5_at_50_6 O5_at_51_6 O5_at_52_6 O5_at_53_6 O5_af_50_6 O5_af_51_6 O5_af_52_6 O5_af_53_6 O5_aa O6_at_50_6 O6_at_51_6 O6_at_52_6 O6_at_53_6 O6_af_50_6 O6_af_51_6 O6_af_52_6 O6_af_53_6 O6_aa O7_at_50_6 O7_at_51_6 O7_at_52_6 O7_at_53_6 O7_af_50_6 O7_af_51_6 O7_af_52_6 O7_af_53_6 O7_aa
*.PININFO reset:I I_at_50_6:I I_at_51_6:I I_at_52_6:I I_at_53_6:I I_at_54_6:I I_at_55_6:I I_at_56_6:I I_at_57_6:I I_at_58_6:I I_at_59_6:I I_at_510_6:I I_at_511_6:I I_at_512_6:I I_at_513_6:I I_at_514_6:I I_at_515_6:I I_at_516_6:I I_at_517_6:I I_at_518_6:I I_at_519_6:I I_at_520_6:I I_at_521_6:I I_at_522_6:I I_at_523_6:I I_at_524_6:I I_at_525_6:I I_at_526_6:I I_at_527_6:I I_at_528_6:I I_at_529_6:I I_at_530_6:I I_at_531_6:I I_af_50_6:I I_af_51_6:I I_af_52_6:I I_af_53_6:I I_af_54_6:I I_af_55_6:I I_af_56_6:I I_af_57_6:I I_af_58_6:I I_af_59_6:I I_af_510_6:I I_af_511_6:I I_af_512_6:I I_af_513_6:I I_af_514_6:I I_af_515_6:I I_af_516_6:I I_af_517_6:I I_af_518_6:I I_af_519_6:I I_af_520_6:I I_af_521_6:I I_af_522_6:I I_af_523_6:I I_af_524_6:I I_af_525_6:I I_af_526_6:I I_af_527_6:I I_af_528_6:I I_af_529_6:I I_af_530_6:I I_af_531_6:I I_aa:O O1_at_50_6:O O1_at_51_6:O O1_at_52_6:O O1_at_53_6:O O1_af_50_6:O O1_af_51_6:O O1_af_52_6:O O1_af_53_6:O O1_aa:I O2_at_50_6:O O2_at_51_6:O O2_at_52_6:O O2_at_53_6:O O2_af_50_6:O O2_af_51_6:O O2_af_52_6:O O2_af_53_6:O O2_aa:I O3_at_50_6:O O3_at_51_6:O O3_at_52_6:O O3_at_53_6:O O3_af_50_6:O O3_af_51_6:O O3_af_52_6:O O3_af_53_6:O O3_aa:I O4_at_50_6:O O4_at_51_6:O O4_at_52_6:O O4_at_53_6:O O4_af_50_6:O O4_af_51_6:O O4_af_52_6:O O4_af_53_6:O O4_aa:I O5_at_50_6:O O5_at_51_6:O O5_at_52_6:O O5_at_53_6:O O5_af_50_6:O O5_af_51_6:O O5_af_52_6:O O5_af_53_6:O O5_aa:I O6_at_50_6:O O6_at_51_6:O O6_at_52_6:O O6_at_53_6:O O6_af_50_6:O O6_af_51_6:O O6_af_52_6:O O6_af_53_6:O O6_aa:I O7_at_50_6:O O7_at_51_6:O O7_at_52_6:O O7_at_53_6:O O7_af_50_6:O O7_af_51_6:O O7_af_52_6:O O7_af_53_6:O O7_aa:I
*.POWER VDD Vdd
*.POWER GND GND
*.POWER NSUB GND
*.POWER PSUB Vdd
*
* --- node flags ---
*
* __c_50_6 (state-holding): pup_reff=3.2; pdn_reff=5.33333
* b_53_6 (state-holding): pup_reff=0.8; pdn_reff=1.33333
* __b_53_6 (combinational)
* b_52_6 (state-holding): pup_reff=0.8; pdn_reff=1.33333
* __b_52_6 (combinational)
* b_51_6 (state-holding): pup_reff=0.8; pdn_reff=1.33333
* __b_51_6 (combinational)
* b_50_6 (state-holding): pup_reff=0.8; pdn_reff=1.33333
* __b_50_6 (combinational)
* __c_51_6 (state-holding): pup_reff=3.2; pdn_reff=5.33333
* b_57_6 (state-holding): pup_reff=0.8; pdn_reff=1.33333
* __b_57_6 (combinational)
* b_56_6 (state-holding): pup_reff=0.8; pdn_reff=1.33333
* __b_56_6 (combinational)
* b_55_6 (state-holding): pup_reff=0.8; pdn_reff=1.33333
* __b_55_6 (combinational)
* b_54_6 (state-holding): pup_reff=0.8; pdn_reff=1.33333
* __b_54_6 (combinational)
* __c_52_6 (state-holding): pup_reff=3.2; pdn_reff=5.33333
* b_511_6 (state-holding): pup_reff=0.8; pdn_reff=1.33333
* __b_511_6 (combinational)
* b_510_6 (state-holding): pup_reff=0.8; pdn_reff=1.33333
* __b_510_6 (combinational)
* b_59_6 (state-holding): pup_reff=0.8; pdn_reff=1.33333
* __b_59_6 (combinational)
* b_58_6 (state-holding): pup_reff=0.8; pdn_reff=1.33333
* __b_58_6 (combinational)
* __c_53_6 (state-holding): pup_reff=3.2; pdn_reff=5.33333
* b_515_6 (state-holding): pup_reff=0.8; pdn_reff=1.33333
* __b_515_6 (combinational)
* b_514_6 (state-holding): pup_reff=0.8; pdn_reff=1.33333
* __b_514_6 (combinational)
* b_513_6 (state-holding): pup_reff=0.8; pdn_reff=1.33333
* __b_513_6 (combinational)
* b_512_6 (state-holding): pup_reff=0.8; pdn_reff=1.33333
* __b_512_6 (combinational)
* __c_54_6 (state-holding): pup_reff=3.2; pdn_reff=5.33333
* b_519_6 (state-holding): pup_reff=0.8; pdn_reff=1.33333
* __b_519_6 (combinational)
* b_518_6 (state-holding): pup_reff=0.8; pdn_reff=1.33333
* __b_518_6 (combinational)
* b_517_6 (state-holding): pup_reff=0.8; pdn_reff=1.33333
* __b_517_6 (combinational)
* b_516_6 (state-holding): pup_reff=0.8; pdn_reff=1.33333
* __b_516_6 (combinational)
* __c_55_6 (state-holding): pup_reff=3.2; pdn_reff=5.33333
* b_523_6 (state-holding): pup_reff=0.8; pdn_reff=1.33333
* __b_523_6 (combinational)
* b_522_6 (state-holding): pup_reff=0.8; pdn_reff=1.33333
* __b_522_6 (combinational)
* b_521_6 (state-holding): pup_reff=0.8; pdn_reff=1.33333
* __b_521_6 (combinational)
* b_520_6 (state-holding): pup_reff=0.8; pdn_reff=1.33333
* __b_520_6 (combinational)
* __c_56_6 (state-holding): pup_reff=3.2; pdn_reff=5.33333
* b_527_6 (state-holding): pup_reff=0.8; pdn_reff=1.33333
* __b_527_6 (combinational)
* b_526_6 (state-holding): pup_reff=0.8; pdn_reff=1.33333
* __b_526_6 (combinational)
* b_525_6 (state-holding): pup_reff=0.8; pdn_reff=1.33333
* __b_525_6 (combinational)
* b_524_6 (state-holding): pup_reff=0.8; pdn_reff=1.33333
* __b_524_6 (combinational)
* __c_57_6 (state-holding): pup_reff=3.2; pdn_reff=5.33333
* b_531_6 (state-holding): pup_reff=0.8; pdn_reff=1.33333
* __b_531_6 (combinational)
* b_530_6 (state-holding): pup_reff=0.8; pdn_reff=1.33333
* __b_530_6 (combinational)
* b_529_6 (state-holding): pup_reff=0.8; pdn_reff=1.33333
* __b_529_6 (combinational)
* b_528_6 (state-holding): pup_reff=0.8; pdn_reff=1.33333
* __b_528_6 (combinational)
* d_50_6 (state-holding): pup_reff=0.8; pdn_reff=1.33333
* d_51_6 (state-holding): pup_reff=0.8; pdn_reff=1.33333
* d_52_6 (state-holding): pup_reff=0.8; pdn_reff=1.33333
* d_53_6 (state-holding): pup_reff=0.8; pdn_reff=1.33333
* __e_50_6 (state-holding): pup_reff=0.8; pdn_reff=1.33333
* __e_51_6 (state-holding): pup_reff=0.8; pdn_reff=1.33333
* c (state-holding): pup_reff=0.8; pdn_reff=1.33333
* __v (state-holding): pup_reff=3.2; pdn_reff=0.666667
* u7 (combinational)
* u6 (combinational)
* u5 (combinational)
* u4 (combinational)
* u3 (combinational)
* u2 (combinational)
* u1 (combinational)
* __r (combinational)
* __i__a (state-holding): pup_reff=0.4; pdn_reff=1.33333
* __o1a (combinational)
* v (combinational)
* __i__t_50_6 (combinational)
* __i__t_51_6 (combinational)
* __i__t_52_6 (combinational)
* __i__t_53_6 (combinational)
* __i__t_54_6 (combinational)
* __i__t_55_6 (combinational)
* __i__t_56_6 (combinational)
* __i__t_57_6 (combinational)
* __i__t_58_6 (combinational)
* __i__t_59_6 (combinational)
* __i__t_510_6 (combinational)
* __i__t_511_6 (combinational)
* __i__t_512_6 (combinational)
* __i__t_513_6 (combinational)
* __i__t_514_6 (combinational)
* __i__t_515_6 (combinational)
* __i__t_516_6 (combinational)
* __i__t_517_6 (combinational)
* __i__t_518_6 (combinational)
* __i__t_519_6 (combinational)
* __i__t_520_6 (combinational)
* __i__t_521_6 (combinational)
* __i__t_522_6 (combinational)
* __i__t_523_6 (combinational)
* __i__t_524_6 (combinational)
* __i__t_525_6 (combinational)
* __i__t_526_6 (combinational)
* __i__t_527_6 (combinational)
* __i__t_528_6 (combinational)
* __i__t_529_6 (combinational)
* __i__t_530_6 (combinational)
* __i__t_531_6 (combinational)
* __u1 (state-holding): pup_reff=0.4; pdn_reff=0.666667
* __o1t_50_6 (state-holding): pup_reff=0.4; pdn_reff=2.66667
* O1_af_50_6 (state-holding): pup_reff=1.6; pdn_reff=0.666667
* I_aa (combinational)
* __o1t_51_6 (state-holding): pup_reff=0.4; pdn_reff=2.66667
* O1_af_51_6 (state-holding): pup_reff=1.6; pdn_reff=0.666667
* __o1t_52_6 (state-holding): pup_reff=0.4; pdn_reff=2.66667
* O1_af_52_6 (state-holding): pup_reff=1.6; pdn_reff=0.666667
* __o1t_53_6 (state-holding): pup_reff=0.4; pdn_reff=2.66667
* O1_af_53_6 (state-holding): pup_reff=1.6; pdn_reff=0.666667
* __u2 (state-holding): pup_reff=0.4; pdn_reff=0.666667
* __o2t_50_6 (state-holding): pup_reff=0.4; pdn_reff=2.66667
* O2_af_50_6 (state-holding): pup_reff=1.6; pdn_reff=0.666667
* __o2t_51_6 (state-holding): pup_reff=0.4; pdn_reff=2.66667
* O2_af_51_6 (state-holding): pup_reff=1.6; pdn_reff=0.666667
* __o2t_52_6 (state-holding): pup_reff=0.4; pdn_reff=2.66667
* O2_af_52_6 (state-holding): pup_reff=1.6; pdn_reff=0.666667
* __o2t_53_6 (state-holding): pup_reff=0.4; pdn_reff=2.66667
* O2_af_53_6 (state-holding): pup_reff=1.6; pdn_reff=0.666667
* __u3 (state-holding): pup_reff=0.4; pdn_reff=0.666667
* __o3t_50_6 (state-holding): pup_reff=0.4; pdn_reff=2.66667
* O3_af_50_6 (state-holding): pup_reff=1.6; pdn_reff=0.666667
* __o3t_51_6 (state-holding): pup_reff=0.4; pdn_reff=2.66667
* O3_af_51_6 (state-holding): pup_reff=1.6; pdn_reff=0.666667
* __o3t_52_6 (state-holding): pup_reff=0.4; pdn_reff=2.66667
* O3_af_52_6 (state-holding): pup_reff=1.6; pdn_reff=0.666667
* __o3t_53_6 (state-holding): pup_reff=0.4; pdn_reff=2.66667
* O3_af_53_6 (state-holding): pup_reff=1.6; pdn_reff=0.666667
* __u4 (state-holding): pup_reff=0.4; pdn_reff=0.666667
* __o4t_50_6 (state-holding): pup_reff=0.4; pdn_reff=2.66667
* O4_af_50_6 (state-holding): pup_reff=1.6; pdn_reff=0.666667
* __o4t_51_6 (state-holding): pup_reff=0.4; pdn_reff=2.66667
* O4_af_51_6 (state-holding): pup_reff=1.6; pdn_reff=0.666667
* __o4t_52_6 (state-holding): pup_reff=0.4; pdn_reff=2.66667
* O4_af_52_6 (state-holding): pup_reff=1.6; pdn_reff=0.666667
* __o4t_53_6 (state-holding): pup_reff=0.4; pdn_reff=2.66667
* O4_af_53_6 (state-holding): pup_reff=1.6; pdn_reff=0.666667
* __u5 (state-holding): pup_reff=0.4; pdn_reff=0.666667
* __o5t_50_6 (state-holding): pup_reff=0.4; pdn_reff=2.66667
* O5_af_50_6 (state-holding): pup_reff=1.6; pdn_reff=0.666667
* __o5t_51_6 (state-holding): pup_reff=0.4; pdn_reff=2.66667
* O5_af_51_6 (state-holding): pup_reff=1.6; pdn_reff=0.666667
* __o5t_52_6 (state-holding): pup_reff=0.4; pdn_reff=2.66667
* O5_af_52_6 (state-holding): pup_reff=1.6; pdn_reff=0.666667
* __o5t_53_6 (state-holding): pup_reff=0.4; pdn_reff=2.66667
* O5_af_53_6 (state-holding): pup_reff=1.6; pdn_reff=0.666667
* __u6 (state-holding): pup_reff=0.4; pdn_reff=0.666667
* __o6t_50_6 (state-holding): pup_reff=0.4; pdn_reff=2.66667
* O6_af_50_6 (state-holding): pup_reff=1.6; pdn_reff=0.666667
* __o6t_51_6 (state-holding): pup_reff=0.4; pdn_reff=2.66667
* O6_af_51_6 (state-holding): pup_reff=1.6; pdn_reff=0.666667
* __o6t_52_6 (state-holding): pup_reff=0.4; pdn_reff=2.66667
* O6_af_52_6 (state-holding): pup_reff=1.6; pdn_reff=0.666667
* __o6t_53_6 (state-holding): pup_reff=0.4; pdn_reff=2.66667
* O6_af_53_6 (state-holding): pup_reff=1.6; pdn_reff=0.666667
* __u7 (state-holding): pup_reff=0.4; pdn_reff=0.666667
* __o7t_50_6 (state-holding): pup_reff=0.4; pdn_reff=2.66667
* O7_af_50_6 (state-holding): pup_reff=1.6; pdn_reff=0.666667
* __o7t_51_6 (state-holding): pup_reff=0.4; pdn_reff=2.66667
* O7_af_51_6 (state-holding): pup_reff=1.6; pdn_reff=0.666667
* __o7t_52_6 (state-holding): pup_reff=0.4; pdn_reff=2.66667
* O7_af_52_6 (state-holding): pup_reff=1.6; pdn_reff=0.666667
* __o7t_53_6 (state-holding): pup_reff=0.4; pdn_reff=2.66667
* O7_af_53_6 (state-holding): pup_reff=1.6; pdn_reff=0.666667
* O1_at_50_6 (combinational)
* O1_at_51_6 (combinational)
* O1_at_52_6 (combinational)
* O1_at_53_6 (combinational)
* O2_at_50_6 (combinational)
* O2_at_51_6 (combinational)
* O2_at_52_6 (combinational)
* O2_at_53_6 (combinational)
* O3_at_50_6 (combinational)
* O3_at_51_6 (combinational)
* O3_at_52_6 (combinational)
* O3_at_53_6 (combinational)
* O4_at_50_6 (combinational)
* O4_at_51_6 (combinational)
* O4_at_52_6 (combinational)
* O4_at_53_6 (combinational)
* O5_at_50_6 (combinational)
* O5_at_51_6 (combinational)
* O5_at_52_6 (combinational)
* O5_at_53_6 (combinational)
* O6_at_50_6 (combinational)
* O6_at_51_6 (combinational)
* O6_at_52_6 (combinational)
* O6_at_53_6 (combinational)
* O7_at_50_6 (combinational)
* O7_at_51_6 (combinational)
* O7_at_52_6 (combinational)
* O7_at_53_6 (combinational)
*
* --- end node flags ---
*
M0_ Vdd I_at_53_6 #33 Vdd pmos W=0.1625U L=0.065U
M1_ Vdd I_at_57_6 #68 Vdd pmos W=0.1625U L=0.065U
M2_ Vdd I_at_511_6 #103 Vdd pmos W=0.1625U L=0.065U
M3_ Vdd I_at_515_6 #138 Vdd pmos W=0.1625U L=0.065U
M4_ Vdd I_at_519_6 #173 Vdd pmos W=0.1625U L=0.065U
M5_ Vdd I_at_523_6 #208 Vdd pmos W=0.1625U L=0.065U
M6_ Vdd I_at_527_6 #243 Vdd pmos W=0.1625U L=0.065U
M7_ Vdd I_at_531_6 #278 Vdd pmos W=0.1625U L=0.065U
M8_ Vdd __c_51_6 #283 Vdd pmos W=0.1625U L=0.065U
M9_ Vdd __c_53_6 #286 Vdd pmos W=0.1625U L=0.065U
M10_ Vdd __c_55_6 #289 Vdd pmos W=0.1625U L=0.065U
M11_ Vdd __c_57_6 #292 Vdd pmos W=0.1625U L=0.065U
M12_ Vdd d_51_6 #296 Vdd pmos W=0.1625U L=0.065U
M13_ Vdd d_53_6 #299 Vdd pmos W=0.1625U L=0.065U
M14_ Vdd __e_51_6 #301 Vdd pmos W=0.1625U L=0.065U
M15_ Vdd c #310 Vdd pmos W=0.1625U L=0.065U
M16_ Vdd __r __v Vdd pmos W=0.1625U L=0.065U
M17_ Vdd v __i__a Vdd pmos W=0.1625U L=0.065U
M18_ Vdd v #323 Vdd pmos W=0.1625U L=0.065U
M19_ Vdd v #327 Vdd pmos W=0.1625U L=0.065U
M20_ Vdd v #330 Vdd pmos W=0.1625U L=0.065U
M21_ Vdd v #333 Vdd pmos W=0.1625U L=0.065U
M22_ Vdd v #336 Vdd pmos W=0.1625U L=0.065U
M23_ Vdd v #339 Vdd pmos W=0.1625U L=0.065U
M24_ Vdd v #342 Vdd pmos W=0.1625U L=0.065U
M25_ Vdd v #345 Vdd pmos W=0.1625U L=0.065U
M26_ Vdd v #348 Vdd pmos W=0.1625U L=0.065U
M27_ Vdd v #351 Vdd pmos W=0.1625U L=0.065U
M28_ Vdd v #354 Vdd pmos W=0.1625U L=0.065U
M29_ Vdd v #357 Vdd pmos W=0.1625U L=0.065U
M30_ Vdd v #360 Vdd pmos W=0.1625U L=0.065U
M31_ Vdd v #363 Vdd pmos W=0.1625U L=0.065U
M32_ Vdd v #366 Vdd pmos W=0.1625U L=0.065U
M33_ Vdd v #369 Vdd pmos W=0.1625U L=0.065U
M34_ Vdd v #372 Vdd pmos W=0.1625U L=0.065U
M35_ Vdd v #375 Vdd pmos W=0.1625U L=0.065U
M36_ Vdd v #378 Vdd pmos W=0.1625U L=0.065U
M37_ Vdd v #381 Vdd pmos W=0.1625U L=0.065U
M38_ Vdd v #384 Vdd pmos W=0.1625U L=0.065U
M39_ Vdd v #387 Vdd pmos W=0.1625U L=0.065U
M40_ Vdd v #390 Vdd pmos W=0.1625U L=0.065U
M41_ Vdd v #393 Vdd pmos W=0.1625U L=0.065U
M42_ Vdd v #396 Vdd pmos W=0.1625U L=0.065U
M43_ Vdd v #399 Vdd pmos W=0.1625U L=0.065U
M44_ Vdd v #402 Vdd pmos W=0.1625U L=0.065U
M45_ Vdd v #405 Vdd pmos W=0.1625U L=0.065U
M46_ Vdd v #408 Vdd pmos W=0.1625U L=0.065U
M47_ Vdd v #411 Vdd pmos W=0.1625U L=0.065U
M48_ Vdd v #414 Vdd pmos W=0.1625U L=0.065U
M49_ Vdd v #417 Vdd pmos W=0.1625U L=0.065U
M50_ Vdd __i__a __u1 Vdd pmos W=0.1625U L=0.065U
M51_ Vdd __r __u1 Vdd pmos W=0.1625U L=0.065U
M52_ Vdd __u1 __o1t_50_6 Vdd pmos W=0.1625U L=0.065U
M53_ Vdd __r __o1t_50_6 Vdd pmos W=0.1625U L=0.065U
M54_ Vdd u1 #429 Vdd pmos W=0.1625U L=0.065U
M55_ Vdd __u1 __o1t_51_6 Vdd pmos W=0.1625U L=0.065U
M56_ Vdd __r __o1t_51_6 Vdd pmos W=0.1625U L=0.065U
M57_ Vdd u1 #438 Vdd pmos W=0.1625U L=0.065U
M58_ Vdd __u1 __o1t_52_6 Vdd pmos W=0.1625U L=0.065U
M59_ Vdd __r __o1t_52_6 Vdd pmos W=0.1625U L=0.065U
M60_ Vdd u1 #446 Vdd pmos W=0.1625U L=0.065U
M61_ Vdd __u1 __o1t_53_6 Vdd pmos W=0.1625U L=0.065U
M62_ Vdd __r __o1t_53_6 Vdd pmos W=0.1625U L=0.065U
M63_ Vdd u1 #454 Vdd pmos W=0.1625U L=0.065U
M64_ Vdd __i__a __u2 Vdd pmos W=0.1625U L=0.065U
M65_ Vdd __r __u2 Vdd pmos W=0.1625U L=0.065U
M66_ Vdd __u2 __o2t_50_6 Vdd pmos W=0.1625U L=0.065U
M67_ Vdd __r __o2t_50_6 Vdd pmos W=0.1625U L=0.065U
M68_ Vdd u2 #464 Vdd pmos W=0.1625U L=0.065U
M69_ Vdd __u2 __o2t_51_6 Vdd pmos W=0.1625U L=0.065U
M70_ Vdd __r __o2t_51_6 Vdd pmos W=0.1625U L=0.065U
M71_ Vdd u2 #472 Vdd pmos W=0.1625U L=0.065U
M72_ Vdd __u2 __o2t_52_6 Vdd pmos W=0.1625U L=0.065U
M73_ Vdd __r __o2t_52_6 Vdd pmos W=0.1625U L=0.065U
M74_ Vdd u2 #480 Vdd pmos W=0.1625U L=0.065U
M75_ Vdd __u2 __o2t_53_6 Vdd pmos W=0.1625U L=0.065U
M76_ Vdd __r __o2t_53_6 Vdd pmos W=0.1625U L=0.065U
M77_ Vdd u2 #488 Vdd pmos W=0.1625U L=0.065U
M78_ Vdd __i__a __u3 Vdd pmos W=0.1625U L=0.065U
M79_ Vdd __r __u3 Vdd pmos W=0.1625U L=0.065U
M80_ Vdd __u3 __o3t_50_6 Vdd pmos W=0.1625U L=0.065U
M81_ Vdd __r __o3t_50_6 Vdd pmos W=0.1625U L=0.065U
M82_ Vdd u3 #498 Vdd pmos W=0.1625U L=0.065U
M83_ Vdd __u3 __o3t_51_6 Vdd pmos W=0.1625U L=0.065U
M84_ Vdd __r __o3t_51_6 Vdd pmos W=0.1625U L=0.065U
M85_ Vdd u3 #506 Vdd pmos W=0.1625U L=0.065U
M86_ Vdd __u3 __o3t_52_6 Vdd pmos W=0.1625U L=0.065U
M87_ Vdd __r __o3t_52_6 Vdd pmos W=0.1625U L=0.065U
M88_ Vdd u3 #514 Vdd pmos W=0.1625U L=0.065U
M89_ Vdd __u3 __o3t_53_6 Vdd pmos W=0.1625U L=0.065U
M90_ Vdd __r __o3t_53_6 Vdd pmos W=0.1625U L=0.065U
M91_ Vdd u3 #522 Vdd pmos W=0.1625U L=0.065U
M92_ Vdd __i__a __u4 Vdd pmos W=0.1625U L=0.065U
M93_ Vdd __r __u4 Vdd pmos W=0.1625U L=0.065U
M94_ Vdd __u4 __o4t_50_6 Vdd pmos W=0.1625U L=0.065U
M95_ Vdd __r __o4t_50_6 Vdd pmos W=0.1625U L=0.065U
M96_ Vdd u4 #532 Vdd pmos W=0.1625U L=0.065U
M97_ Vdd __u4 __o4t_51_6 Vdd pmos W=0.1625U L=0.065U
M98_ Vdd __r __o4t_51_6 Vdd pmos W=0.1625U L=0.065U
M99_ Vdd u4 #540 Vdd pmos W=0.1625U L=0.065U
M100_ Vdd __u4 __o4t_52_6 Vdd pmos W=0.1625U L=0.065U
M101_ Vdd __r __o4t_52_6 Vdd pmos W=0.1625U L=0.065U
M102_ Vdd u4 #548 Vdd pmos W=0.1625U L=0.065U
M103_ Vdd __u4 __o4t_53_6 Vdd pmos W=0.1625U L=0.065U
M104_ Vdd __r __o4t_53_6 Vdd pmos W=0.1625U L=0.065U
M105_ Vdd u4 #556 Vdd pmos W=0.1625U L=0.065U
M106_ Vdd __i__a __u5 Vdd pmos W=0.1625U L=0.065U
M107_ Vdd __r __u5 Vdd pmos W=0.1625U L=0.065U
M108_ Vdd __u5 __o5t_50_6 Vdd pmos W=0.1625U L=0.065U
M109_ Vdd __r __o5t_50_6 Vdd pmos W=0.1625U L=0.065U
M110_ Vdd u5 #566 Vdd pmos W=0.1625U L=0.065U
M111_ Vdd __u5 __o5t_51_6 Vdd pmos W=0.1625U L=0.065U
M112_ Vdd __r __o5t_51_6 Vdd pmos W=0.1625U L=0.065U
M113_ Vdd u5 #574 Vdd pmos W=0.1625U L=0.065U
M114_ Vdd __u5 __o5t_52_6 Vdd pmos W=0.1625U L=0.065U
M115_ Vdd __r __o5t_52_6 Vdd pmos W=0.1625U L=0.065U
M116_ Vdd u5 #582 Vdd pmos W=0.1625U L=0.065U
M117_ Vdd __u5 __o5t_53_6 Vdd pmos W=0.1625U L=0.065U
M118_ Vdd __r __o5t_53_6 Vdd pmos W=0.1625U L=0.065U
M119_ Vdd u5 #590 Vdd pmos W=0.1625U L=0.065U
M120_ Vdd __i__a __u6 Vdd pmos W=0.1625U L=0.065U
M121_ Vdd __r __u6 Vdd pmos W=0.1625U L=0.065U
M122_ Vdd __u6 __o6t_50_6 Vdd pmos W=0.1625U L=0.065U
M123_ Vdd __r __o6t_50_6 Vdd pmos W=0.1625U L=0.065U
M124_ Vdd u6 #600 Vdd pmos W=0.1625U L=0.065U
M125_ Vdd __u6 __o6t_51_6 Vdd pmos W=0.1625U L=0.065U
M126_ Vdd __r __o6t_51_6 Vdd pmos W=0.1625U L=0.065U
M127_ Vdd u6 #608 Vdd pmos W=0.1625U L=0.065U
M128_ Vdd __u6 __o6t_52_6 Vdd pmos W=0.1625U L=0.065U
M129_ Vdd __r __o6t_52_6 Vdd pmos W=0.1625U L=0.065U
M130_ Vdd u6 #616 Vdd pmos W=0.1625U L=0.065U
M131_ Vdd __u6 __o6t_53_6 Vdd pmos W=0.1625U L=0.065U
M132_ Vdd __r __o6t_53_6 Vdd pmos W=0.1625U L=0.065U
M133_ Vdd u6 #624 Vdd pmos W=0.1625U L=0.065U
M134_ Vdd __i__a __u7 Vdd pmos W=0.1625U L=0.065U
M135_ Vdd __r __u7 Vdd pmos W=0.1625U L=0.065U
M136_ Vdd __u7 __o7t_50_6 Vdd pmos W=0.1625U L=0.065U
M137_ Vdd __r __o7t_50_6 Vdd pmos W=0.1625U L=0.065U
M138_ Vdd u7 #634 Vdd pmos W=0.1625U L=0.065U
M139_ Vdd __u7 __o7t_51_6 Vdd pmos W=0.1625U L=0.065U
M140_ Vdd __r __o7t_51_6 Vdd pmos W=0.1625U L=0.065U
M141_ Vdd u7 #642 Vdd pmos W=0.1625U L=0.065U
M142_ Vdd __u7 __o7t_52_6 Vdd pmos W=0.1625U L=0.065U
M143_ Vdd __r __o7t_52_6 Vdd pmos W=0.1625U L=0.065U
M144_ Vdd u7 #650 Vdd pmos W=0.1625U L=0.065U
M145_ Vdd __u7 __o7t_53_6 Vdd pmos W=0.1625U L=0.065U
M146_ Vdd __r __o7t_53_6 Vdd pmos W=0.1625U L=0.065U
M147_ Vdd u7 #658 Vdd pmos W=0.1625U L=0.065U
M148_ Vdd reset __r Vdd pmos W=0.1625U L=0.065U
M149_ Vdd __v v Vdd pmos W=0.1625U L=0.065U
M150_ Vdd __i__a I_aa Vdd pmos W=0.1625U L=0.065U
M151_ Vdd O1_aa __o1a Vdd pmos W=0.1625U L=0.065U
M152_ Vdd b_50_6 __b_50_6 Vdd pmos W=0.1625U L=0.065U
M153_ Vdd I_at_50_6 __i__t_50_6 Vdd pmos W=0.1625U L=0.065U
M154_ Vdd b_51_6 __b_51_6 Vdd pmos W=0.1625U L=0.065U
M155_ Vdd I_at_51_6 __i__t_51_6 Vdd pmos W=0.1625U L=0.065U
M156_ Vdd b_52_6 __b_52_6 Vdd pmos W=0.1625U L=0.065U
M157_ Vdd I_at_52_6 __i__t_52_6 Vdd pmos W=0.1625U L=0.065U
M158_ Vdd b_53_6 __b_53_6 Vdd pmos W=0.1625U L=0.065U
M159_ Vdd I_at_53_6 __i__t_53_6 Vdd pmos W=0.1625U L=0.065U
M160_ Vdd b_54_6 __b_54_6 Vdd pmos W=0.1625U L=0.065U
M161_ Vdd I_at_54_6 __i__t_54_6 Vdd pmos W=0.1625U L=0.065U
M162_ Vdd b_55_6 __b_55_6 Vdd pmos W=0.1625U L=0.065U
M163_ Vdd I_at_55_6 __i__t_55_6 Vdd pmos W=0.1625U L=0.065U
M164_ Vdd b_56_6 __b_56_6 Vdd pmos W=0.1625U L=0.065U
M165_ Vdd I_at_56_6 __i__t_56_6 Vdd pmos W=0.1625U L=0.065U
M166_ Vdd b_57_6 __b_57_6 Vdd pmos W=0.1625U L=0.065U
M167_ Vdd I_at_57_6 __i__t_57_6 Vdd pmos W=0.1625U L=0.065U
M168_ Vdd b_58_6 __b_58_6 Vdd pmos W=0.1625U L=0.065U
M169_ Vdd I_at_58_6 __i__t_58_6 Vdd pmos W=0.1625U L=0.065U
M170_ Vdd b_59_6 __b_59_6 Vdd pmos W=0.1625U L=0.065U
M171_ Vdd I_at_59_6 __i__t_59_6 Vdd pmos W=0.1625U L=0.065U
M172_ Vdd b_510_6 __b_510_6 Vdd pmos W=0.1625U L=0.065U
M173_ Vdd I_at_510_6 __i__t_510_6 Vdd pmos W=0.1625U L=0.065U
M174_ Vdd b_511_6 __b_511_6 Vdd pmos W=0.1625U L=0.065U
M175_ Vdd I_at_511_6 __i__t_511_6 Vdd pmos W=0.1625U L=0.065U
M176_ Vdd b_512_6 __b_512_6 Vdd pmos W=0.1625U L=0.065U
M177_ Vdd I_at_512_6 __i__t_512_6 Vdd pmos W=0.1625U L=0.065U
M178_ Vdd b_513_6 __b_513_6 Vdd pmos W=0.1625U L=0.065U
M179_ Vdd I_at_513_6 __i__t_513_6 Vdd pmos W=0.1625U L=0.065U
M180_ Vdd b_514_6 __b_514_6 Vdd pmos W=0.1625U L=0.065U
M181_ Vdd I_at_514_6 __i__t_514_6 Vdd pmos W=0.1625U L=0.065U
M182_ Vdd b_515_6 __b_515_6 Vdd pmos W=0.1625U L=0.065U
M183_ Vdd I_at_515_6 __i__t_515_6 Vdd pmos W=0.1625U L=0.065U
M184_ Vdd b_516_6 __b_516_6 Vdd pmos W=0.1625U L=0.065U
M185_ Vdd I_at_516_6 __i__t_516_6 Vdd pmos W=0.1625U L=0.065U
M186_ Vdd b_517_6 __b_517_6 Vdd pmos W=0.1625U L=0.065U
M187_ Vdd I_at_517_6 __i__t_517_6 Vdd pmos W=0.1625U L=0.065U
M188_ Vdd b_518_6 __b_518_6 Vdd pmos W=0.1625U L=0.065U
M189_ Vdd I_at_518_6 __i__t_518_6 Vdd pmos W=0.1625U L=0.065U
M190_ Vdd b_519_6 __b_519_6 Vdd pmos W=0.1625U L=0.065U
M191_ Vdd I_at_519_6 __i__t_519_6 Vdd pmos W=0.1625U L=0.065U
M192_ Vdd b_520_6 __b_520_6 Vdd pmos W=0.1625U L=0.065U
M193_ Vdd I_at_520_6 __i__t_520_6 Vdd pmos W=0.1625U L=0.065U
M194_ Vdd b_521_6 __b_521_6 Vdd pmos W=0.1625U L=0.065U
M195_ Vdd I_at_521_6 __i__t_521_6 Vdd pmos W=0.1625U L=0.065U
M196_ Vdd b_522_6 __b_522_6 Vdd pmos W=0.1625U L=0.065U
M197_ Vdd I_at_522_6 __i__t_522_6 Vdd pmos W=0.1625U L=0.065U
M198_ Vdd b_523_6 __b_523_6 Vdd pmos W=0.1625U L=0.065U
M199_ Vdd I_at_523_6 __i__t_523_6 Vdd pmos W=0.1625U L=0.065U
M200_ Vdd b_524_6 __b_524_6 Vdd pmos W=0.1625U L=0.065U
M201_ Vdd I_at_524_6 __i__t_524_6 Vdd pmos W=0.1625U L=0.065U
M202_ Vdd b_525_6 __b_525_6 Vdd pmos W=0.1625U L=0.065U
M203_ Vdd I_at_525_6 __i__t_525_6 Vdd pmos W=0.1625U L=0.065U
M204_ Vdd b_526_6 __b_526_6 Vdd pmos W=0.1625U L=0.065U
M205_ Vdd I_at_526_6 __i__t_526_6 Vdd pmos W=0.1625U L=0.065U
M206_ Vdd b_527_6 __b_527_6 Vdd pmos W=0.1625U L=0.065U
M207_ Vdd I_at_527_6 __i__t_527_6 Vdd pmos W=0.1625U L=0.065U
M208_ Vdd b_528_6 __b_528_6 Vdd pmos W=0.1625U L=0.065U
M209_ Vdd I_at_528_6 __i__t_528_6 Vdd pmos W=0.1625U L=0.065U
M210_ Vdd b_529_6 __b_529_6 Vdd pmos W=0.1625U L=0.065U
M211_ Vdd I_at_529_6 __i__t_529_6 Vdd pmos W=0.1625U L=0.065U
M212_ Vdd b_530_6 __b_530_6 Vdd pmos W=0.1625U L=0.065U
M213_ Vdd I_at_530_6 __i__t_530_6 Vdd pmos W=0.1625U L=0.065U
M214_ Vdd b_531_6 __b_531_6 Vdd pmos W=0.1625U L=0.065U
M215_ Vdd I_at_531_6 __i__t_531_6 Vdd pmos W=0.1625U L=0.065U
M216_ Vdd __u1 u1 Vdd pmos W=0.1625U L=0.065U
M217_ Vdd __o1t_50_6 O1_at_50_6 Vdd pmos W=0.1625U L=0.065U
M218_ Vdd __o1t_51_6 O1_at_51_6 Vdd pmos W=0.1625U L=0.065U
M219_ Vdd __o1t_52_6 O1_at_52_6 Vdd pmos W=0.1625U L=0.065U
M220_ Vdd __o1t_53_6 O1_at_53_6 Vdd pmos W=0.1625U L=0.065U
M221_ Vdd __u2 u2 Vdd pmos W=0.1625U L=0.065U
M222_ Vdd __o2t_50_6 O2_at_50_6 Vdd pmos W=0.1625U L=0.065U
M223_ Vdd __o2t_51_6 O2_at_51_6 Vdd pmos W=0.1625U L=0.065U
M224_ Vdd __o2t_52_6 O2_at_52_6 Vdd pmos W=0.1625U L=0.065U
M225_ Vdd __o2t_53_6 O2_at_53_6 Vdd pmos W=0.1625U L=0.065U
M226_ Vdd __u3 u3 Vdd pmos W=0.1625U L=0.065U
M227_ Vdd __o3t_50_6 O3_at_50_6 Vdd pmos W=0.1625U L=0.065U
M228_ Vdd __o3t_51_6 O3_at_51_6 Vdd pmos W=0.1625U L=0.065U
M229_ Vdd __o3t_52_6 O3_at_52_6 Vdd pmos W=0.1625U L=0.065U
M230_ Vdd __o3t_53_6 O3_at_53_6 Vdd pmos W=0.1625U L=0.065U
M231_ Vdd __u4 u4 Vdd pmos W=0.1625U L=0.065U
M232_ Vdd __o4t_50_6 O4_at_50_6 Vdd pmos W=0.1625U L=0.065U
M233_ Vdd __o4t_51_6 O4_at_51_6 Vdd pmos W=0.1625U L=0.065U
M234_ Vdd __o4t_52_6 O4_at_52_6 Vdd pmos W=0.1625U L=0.065U
M235_ Vdd __o4t_53_6 O4_at_53_6 Vdd pmos W=0.1625U L=0.065U
M236_ Vdd __u5 u5 Vdd pmos W=0.1625U L=0.065U
M237_ Vdd __o5t_50_6 O5_at_50_6 Vdd pmos W=0.1625U L=0.065U
M238_ Vdd __o5t_51_6 O5_at_51_6 Vdd pmos W=0.1625U L=0.065U
M239_ Vdd __o5t_52_6 O5_at_52_6 Vdd pmos W=0.1625U L=0.065U
M240_ Vdd __o5t_53_6 O5_at_53_6 Vdd pmos W=0.1625U L=0.065U
M241_ Vdd __u6 u6 Vdd pmos W=0.1625U L=0.065U
M242_ Vdd __o6t_50_6 O6_at_50_6 Vdd pmos W=0.1625U L=0.065U
M243_ Vdd __o6t_51_6 O6_at_51_6 Vdd pmos W=0.1625U L=0.065U
M244_ Vdd __o6t_52_6 O6_at_52_6 Vdd pmos W=0.1625U L=0.065U
M245_ Vdd __o6t_53_6 O6_at_53_6 Vdd pmos W=0.1625U L=0.065U
M246_ Vdd __u7 u7 Vdd pmos W=0.1625U L=0.065U
M247_ Vdd __o7t_50_6 O7_at_50_6 Vdd pmos W=0.1625U L=0.065U
M248_ Vdd __o7t_51_6 O7_at_51_6 Vdd pmos W=0.1625U L=0.065U
M249_ Vdd __o7t_52_6 O7_at_52_6 Vdd pmos W=0.1625U L=0.065U
M250_ Vdd __o7t_53_6 O7_at_53_6 Vdd pmos W=0.1625U L=0.065U
M251_ Vdd __c_50_6 #fb687# Vdd pmos W=0.1625U L=0.13U
M252_ Vdd b_53_6 #fb690# Vdd pmos W=0.1625U L=0.13U
M253_keeper Vdd GND #688 Vdd pmos W=0.0975U L=2.535U
M254_ Vdd b_52_6 #fb693# Vdd pmos W=0.1625U L=0.13U
M255_keeper Vdd GND #691 Vdd pmos W=0.0975U L=0.585U
M256_ Vdd b_51_6 #fb696# Vdd pmos W=0.1625U L=0.13U
M257_keeper Vdd GND #694 Vdd pmos W=0.0975U L=0.585U
M258_ Vdd b_50_6 #fb699# Vdd pmos W=0.1625U L=0.13U
M259_keeper Vdd GND #697 Vdd pmos W=0.0975U L=0.585U
M260_ Vdd __c_51_6 #fb702# Vdd pmos W=0.1625U L=0.13U
M261_keeper Vdd GND #700 Vdd pmos W=0.0975U L=0.585U
M262_ Vdd b_57_6 #fb705# Vdd pmos W=0.1625U L=0.13U
M263_keeper Vdd GND #703 Vdd pmos W=0.0975U L=2.535U
M264_ Vdd b_56_6 #fb708# Vdd pmos W=0.1625U L=0.13U
M265_keeper Vdd GND #706 Vdd pmos W=0.0975U L=0.585U
M266_ Vdd b_55_6 #fb711# Vdd pmos W=0.1625U L=0.13U
M267_keeper Vdd GND #709 Vdd pmos W=0.0975U L=0.585U
M268_ Vdd b_54_6 #fb714# Vdd pmos W=0.1625U L=0.13U
M269_keeper Vdd GND #712 Vdd pmos W=0.0975U L=0.585U
M270_ Vdd __c_52_6 #fb717# Vdd pmos W=0.1625U L=0.13U
M271_keeper Vdd GND #715 Vdd pmos W=0.0975U L=0.585U
M272_ Vdd b_511_6 #fb720# Vdd pmos W=0.1625U L=0.13U
M273_keeper Vdd GND #718 Vdd pmos W=0.0975U L=2.535U
M274_ Vdd b_510_6 #fb723# Vdd pmos W=0.1625U L=0.13U
M275_keeper Vdd GND #721 Vdd pmos W=0.0975U L=0.585U
M276_ Vdd b_59_6 #fb726# Vdd pmos W=0.1625U L=0.13U
M277_keeper Vdd GND #724 Vdd pmos W=0.0975U L=0.585U
M278_ Vdd b_58_6 #fb729# Vdd pmos W=0.1625U L=0.13U
M279_keeper Vdd GND #727 Vdd pmos W=0.0975U L=0.585U
M280_ Vdd __c_53_6 #fb732# Vdd pmos W=0.1625U L=0.13U
M281_keeper Vdd GND #730 Vdd pmos W=0.0975U L=0.585U
M282_ Vdd b_515_6 #fb735# Vdd pmos W=0.1625U L=0.13U
M283_keeper Vdd GND #733 Vdd pmos W=0.0975U L=2.535U
M284_ Vdd b_514_6 #fb738# Vdd pmos W=0.1625U L=0.13U
M285_keeper Vdd GND #736 Vdd pmos W=0.0975U L=0.585U
M286_ Vdd b_513_6 #fb741# Vdd pmos W=0.1625U L=0.13U
M287_keeper Vdd GND #739 Vdd pmos W=0.0975U L=0.585U
M288_ Vdd b_512_6 #fb744# Vdd pmos W=0.1625U L=0.13U
M289_keeper Vdd GND #742 Vdd pmos W=0.0975U L=0.585U
M290_ Vdd __c_54_6 #fb747# Vdd pmos W=0.1625U L=0.13U
M291_keeper Vdd GND #745 Vdd pmos W=0.0975U L=0.585U
M292_ Vdd b_519_6 #fb750# Vdd pmos W=0.1625U L=0.13U
M293_keeper Vdd GND #748 Vdd pmos W=0.0975U L=2.535U
M294_ Vdd b_518_6 #fb753# Vdd pmos W=0.1625U L=0.13U
M295_keeper Vdd GND #751 Vdd pmos W=0.0975U L=0.585U
M296_ Vdd b_517_6 #fb756# Vdd pmos W=0.1625U L=0.13U
M297_keeper Vdd GND #754 Vdd pmos W=0.0975U L=0.585U
M298_ Vdd b_516_6 #fb759# Vdd pmos W=0.1625U L=0.13U
M299_keeper Vdd GND #757 Vdd pmos W=0.0975U L=0.585U
M300_ Vdd __c_55_6 #fb762# Vdd pmos W=0.1625U L=0.13U
M301_keeper Vdd GND #760 Vdd pmos W=0.0975U L=0.585U
M302_ Vdd b_523_6 #fb765# Vdd pmos W=0.1625U L=0.13U
M303_keeper Vdd GND #763 Vdd pmos W=0.0975U L=2.535U
M304_ Vdd b_522_6 #fb768# Vdd pmos W=0.1625U L=0.13U
M305_keeper Vdd GND #766 Vdd pmos W=0.0975U L=0.585U
M306_ Vdd b_521_6 #fb771# Vdd pmos W=0.1625U L=0.13U
M307_keeper Vdd GND #769 Vdd pmos W=0.0975U L=0.585U
M308_ Vdd b_520_6 #fb774# Vdd pmos W=0.1625U L=0.13U
M309_keeper Vdd GND #772 Vdd pmos W=0.0975U L=0.585U
M310_ Vdd __c_56_6 #fb777# Vdd pmos W=0.1625U L=0.13U
M311_keeper Vdd GND #775 Vdd pmos W=0.0975U L=0.585U
M312_ Vdd b_527_6 #fb780# Vdd pmos W=0.1625U L=0.13U
M313_keeper Vdd GND #778 Vdd pmos W=0.0975U L=2.535U
M314_ Vdd b_526_6 #fb783# Vdd pmos W=0.1625U L=0.13U
M315_keeper Vdd GND #781 Vdd pmos W=0.0975U L=0.585U
M316_ Vdd b_525_6 #fb786# Vdd pmos W=0.1625U L=0.13U
M317_keeper Vdd GND #784 Vdd pmos W=0.0975U L=0.585U
M318_ Vdd b_524_6 #fb789# Vdd pmos W=0.1625U L=0.13U
M319_keeper Vdd GND #787 Vdd pmos W=0.0975U L=0.585U
M320_ Vdd __c_57_6 #fb792# Vdd pmos W=0.1625U L=0.13U
M321_keeper Vdd GND #790 Vdd pmos W=0.0975U L=0.585U
M322_ Vdd b_531_6 #fb795# Vdd pmos W=0.1625U L=0.13U
M323_keeper Vdd GND #793 Vdd pmos W=0.0975U L=2.535U
M324_ Vdd b_530_6 #fb798# Vdd pmos W=0.1625U L=0.13U
M325_keeper Vdd GND #796 Vdd pmos W=0.0975U L=0.585U
M326_ Vdd b_529_6 #fb801# Vdd pmos W=0.1625U L=0.13U
M327_keeper Vdd GND #799 Vdd pmos W=0.0975U L=0.585U
M328_ Vdd b_528_6 #fb804# Vdd pmos W=0.1625U L=0.13U
M329_keeper Vdd GND #802 Vdd pmos W=0.0975U L=0.585U
M330_ Vdd d_50_6 #fb807# Vdd pmos W=0.1625U L=0.13U
M331_keeper Vdd GND #805 Vdd pmos W=0.0975U L=0.585U
M332_ Vdd d_51_6 #fb810# Vdd pmos W=0.1625U L=0.13U
M333_keeper Vdd GND #808 Vdd pmos W=0.0975U L=0.585U
M334_ Vdd d_52_6 #fb813# Vdd pmos W=0.1625U L=0.13U
M335_keeper Vdd GND #811 Vdd pmos W=0.0975U L=0.585U
M336_ Vdd d_53_6 #fb816# Vdd pmos W=0.1625U L=0.13U
M337_keeper Vdd GND #814 Vdd pmos W=0.0975U L=0.585U
M338_ Vdd __e_50_6 #fb819# Vdd pmos W=0.1625U L=0.13U
M339_keeper Vdd GND #817 Vdd pmos W=0.0975U L=0.585U
M340_ Vdd __e_51_6 #fb822# Vdd pmos W=0.1625U L=0.13U
M341_keeper Vdd GND #820 Vdd pmos W=0.0975U L=0.585U
M342_ Vdd c #fb825# Vdd pmos W=0.1625U L=0.13U
M343_keeper Vdd GND #823 Vdd pmos W=0.0975U L=0.585U
M344_ Vdd __v #fb828# Vdd pmos W=0.1625U L=0.13U
M345_keeper Vdd GND #826 Vdd pmos W=0.0975U L=0.585U
M346_ Vdd __i__a #fb831# Vdd pmos W=0.1625U L=0.13U
M347_keeper Vdd GND #829 Vdd pmos W=0.0975U L=0.26U
M348_ Vdd __u1 #fb834# Vdd pmos W=0.1625U L=0.13U
M349_keeper Vdd GND #832 Vdd pmos W=0.0975U L=0.585U
M350_ Vdd __o1t_50_6 #fb837# Vdd pmos W=0.1625U L=0.13U
M351_keeper Vdd GND #835 Vdd pmos W=0.0975U L=0.26U
M352_ Vdd O1_af_50_6 #fb840# Vdd pmos W=0.1625U L=0.13U
M353_keeper Vdd GND #838 Vdd pmos W=0.0975U L=1.235U
M354_ Vdd __o1t_51_6 #fb843# Vdd pmos W=0.1625U L=0.13U
M355_keeper Vdd GND #841 Vdd pmos W=0.0975U L=0.26U
M356_ Vdd O1_af_51_6 #fb846# Vdd pmos W=0.1625U L=0.13U
M357_keeper Vdd GND #844 Vdd pmos W=0.0975U L=1.235U
M358_ Vdd __o1t_52_6 #fb849# Vdd pmos W=0.1625U L=0.13U
M359_keeper Vdd GND #847 Vdd pmos W=0.0975U L=0.26U
M360_ Vdd O1_af_52_6 #fb852# Vdd pmos W=0.1625U L=0.13U
M361_keeper Vdd GND #850 Vdd pmos W=0.0975U L=1.235U
M362_ Vdd __o1t_53_6 #fb855# Vdd pmos W=0.1625U L=0.13U
M363_keeper Vdd GND #853 Vdd pmos W=0.0975U L=0.26U
M364_ Vdd O1_af_53_6 #fb858# Vdd pmos W=0.1625U L=0.13U
M365_keeper Vdd GND #856 Vdd pmos W=0.0975U L=1.235U
M366_ Vdd __u2 #fb861# Vdd pmos W=0.1625U L=0.13U
M367_keeper Vdd GND #859 Vdd pmos W=0.0975U L=0.26U
M368_ Vdd __o2t_50_6 #fb864# Vdd pmos W=0.1625U L=0.13U
M369_keeper Vdd GND #862 Vdd pmos W=0.0975U L=0.26U
M370_ Vdd O2_af_50_6 #fb867# Vdd pmos W=0.1625U L=0.13U
M371_keeper Vdd GND #865 Vdd pmos W=0.0975U L=1.235U
M372_ Vdd __o2t_51_6 #fb870# Vdd pmos W=0.1625U L=0.13U
M373_keeper Vdd GND #868 Vdd pmos W=0.0975U L=0.26U
M374_ Vdd O2_af_51_6 #fb873# Vdd pmos W=0.1625U L=0.13U
M375_keeper Vdd GND #871 Vdd pmos W=0.0975U L=1.235U
M376_ Vdd __o2t_52_6 #fb876# Vdd pmos W=0.1625U L=0.13U
M377_keeper Vdd GND #874 Vdd pmos W=0.0975U L=0.26U
M378_ Vdd O2_af_52_6 #fb879# Vdd pmos W=0.1625U L=0.13U
M379_keeper Vdd GND #877 Vdd pmos W=0.0975U L=1.235U
M380_ Vdd __o2t_53_6 #fb882# Vdd pmos W=0.1625U L=0.13U
M381_keeper Vdd GND #880 Vdd pmos W=0.0975U L=0.26U
M382_ Vdd O2_af_53_6 #fb885# Vdd pmos W=0.1625U L=0.13U
M383_keeper Vdd GND #883 Vdd pmos W=0.0975U L=1.235U
M384_ Vdd __u3 #fb888# Vdd pmos W=0.1625U L=0.13U
M385_keeper Vdd GND #886 Vdd pmos W=0.0975U L=0.26U
M386_ Vdd __o3t_50_6 #fb891# Vdd pmos W=0.1625U L=0.13U
M387_keeper Vdd GND #889 Vdd pmos W=0.0975U L=0.26U
M388_ Vdd O3_af_50_6 #fb894# Vdd pmos W=0.1625U L=0.13U
M389_keeper Vdd GND #892 Vdd pmos W=0.0975U L=1.235U
M390_ Vdd __o3t_51_6 #fb897# Vdd pmos W=0.1625U L=0.13U
M391_keeper Vdd GND #895 Vdd pmos W=0.0975U L=0.26U
M392_ Vdd O3_af_51_6 #fb900# Vdd pmos W=0.1625U L=0.13U
M393_keeper Vdd GND #898 Vdd pmos W=0.0975U L=1.235U
M394_ Vdd __o3t_52_6 #fb903# Vdd pmos W=0.1625U L=0.13U
M395_keeper Vdd GND #901 Vdd pmos W=0.0975U L=0.26U
M396_ Vdd O3_af_52_6 #fb906# Vdd pmos W=0.1625U L=0.13U
M397_keeper Vdd GND #904 Vdd pmos W=0.0975U L=1.235U
M398_ Vdd __o3t_53_6 #fb909# Vdd pmos W=0.1625U L=0.13U
M399_keeper Vdd GND #907 Vdd pmos W=0.0975U L=0.26U
M400_ Vdd O3_af_53_6 #fb912# Vdd pmos W=0.1625U L=0.13U
M401_keeper Vdd GND #910 Vdd pmos W=0.0975U L=1.235U
M402_ Vdd __u4 #fb915# Vdd pmos W=0.1625U L=0.13U
M403_keeper Vdd GND #913 Vdd pmos W=0.0975U L=0.26U
M404_ Vdd __o4t_50_6 #fb918# Vdd pmos W=0.1625U L=0.13U
M405_keeper Vdd GND #916 Vdd pmos W=0.0975U L=0.26U
M406_ Vdd O4_af_50_6 #fb921# Vdd pmos W=0.1625U L=0.13U
M407_keeper Vdd GND #919 Vdd pmos W=0.0975U L=1.235U
M408_ Vdd __o4t_51_6 #fb924# Vdd pmos W=0.1625U L=0.13U
M409_keeper Vdd GND #922 Vdd pmos W=0.0975U L=0.26U
M410_ Vdd O4_af_51_6 #fb927# Vdd pmos W=0.1625U L=0.13U
M411_keeper Vdd GND #925 Vdd pmos W=0.0975U L=1.235U
M412_ Vdd __o4t_52_6 #fb930# Vdd pmos W=0.1625U L=0.13U
M413_keeper Vdd GND #928 Vdd pmos W=0.0975U L=0.26U
M414_ Vdd O4_af_52_6 #fb933# Vdd pmos W=0.1625U L=0.13U
M415_keeper Vdd GND #931 Vdd pmos W=0.0975U L=1.235U
M416_ Vdd __o4t_53_6 #fb936# Vdd pmos W=0.1625U L=0.13U
M417_keeper Vdd GND #934 Vdd pmos W=0.0975U L=0.26U
M418_ Vdd O4_af_53_6 #fb939# Vdd pmos W=0.1625U L=0.13U
M419_keeper Vdd GND #937 Vdd pmos W=0.0975U L=1.235U
M420_ Vdd __u5 #fb942# Vdd pmos W=0.1625U L=0.13U
M421_keeper Vdd GND #940 Vdd pmos W=0.0975U L=0.26U
M422_ Vdd __o5t_50_6 #fb945# Vdd pmos W=0.1625U L=0.13U
M423_keeper Vdd GND #943 Vdd pmos W=0.0975U L=0.26U
M424_ Vdd O5_af_50_6 #fb948# Vdd pmos W=0.1625U L=0.13U
M425_keeper Vdd GND #946 Vdd pmos W=0.0975U L=1.235U
M426_ Vdd __o5t_51_6 #fb951# Vdd pmos W=0.1625U L=0.13U
M427_keeper Vdd GND #949 Vdd pmos W=0.0975U L=0.26U
M428_ Vdd O5_af_51_6 #fb954# Vdd pmos W=0.1625U L=0.13U
M429_keeper Vdd GND #952 Vdd pmos W=0.0975U L=1.235U
M430_ Vdd __o5t_52_6 #fb957# Vdd pmos W=0.1625U L=0.13U
M431_keeper Vdd GND #955 Vdd pmos W=0.0975U L=0.26U
M432_ Vdd O5_af_52_6 #fb960# Vdd pmos W=0.1625U L=0.13U
M433_keeper Vdd GND #958 Vdd pmos W=0.0975U L=1.235U
M434_ Vdd __o5t_53_6 #fb963# Vdd pmos W=0.1625U L=0.13U
M435_keeper Vdd GND #961 Vdd pmos W=0.0975U L=0.26U
M436_ Vdd O5_af_53_6 #fb966# Vdd pmos W=0.1625U L=0.13U
M437_keeper Vdd GND #964 Vdd pmos W=0.0975U L=1.235U
M438_ Vdd __u6 #fb969# Vdd pmos W=0.1625U L=0.13U
M439_keeper Vdd GND #967 Vdd pmos W=0.0975U L=0.26U
M440_ Vdd __o6t_50_6 #fb972# Vdd pmos W=0.1625U L=0.13U
M441_keeper Vdd GND #970 Vdd pmos W=0.0975U L=0.26U
M442_ Vdd O6_af_50_6 #fb975# Vdd pmos W=0.1625U L=0.13U
M443_keeper Vdd GND #973 Vdd pmos W=0.0975U L=1.235U
M444_ Vdd __o6t_51_6 #fb978# Vdd pmos W=0.1625U L=0.13U
M445_keeper Vdd GND #976 Vdd pmos W=0.0975U L=0.26U
M446_ Vdd O6_af_51_6 #fb981# Vdd pmos W=0.1625U L=0.13U
M447_keeper Vdd GND #979 Vdd pmos W=0.0975U L=1.235U
M448_ Vdd __o6t_52_6 #fb984# Vdd pmos W=0.1625U L=0.13U
M449_keeper Vdd GND #982 Vdd pmos W=0.0975U L=0.26U
M450_ Vdd O6_af_52_6 #fb987# Vdd pmos W=0.1625U L=0.13U
M451_keeper Vdd GND #985 Vdd pmos W=0.0975U L=1.235U
M452_ Vdd __o6t_53_6 #fb990# Vdd pmos W=0.1625U L=0.13U
M453_keeper Vdd GND #988 Vdd pmos W=0.0975U L=0.26U
M454_ Vdd O6_af_53_6 #fb993# Vdd pmos W=0.1625U L=0.13U
M455_keeper Vdd GND #991 Vdd pmos W=0.0975U L=1.235U
M456_ Vdd __u7 #fb996# Vdd pmos W=0.1625U L=0.13U
M457_keeper Vdd GND #994 Vdd pmos W=0.0975U L=0.26U
M458_ Vdd __o7t_50_6 #fb999# Vdd pmos W=0.1625U L=0.13U
M459_keeper Vdd GND #997 Vdd pmos W=0.0975U L=0.26U
M460_ Vdd O7_af_50_6 #fb1002# Vdd pmos W=0.1625U L=0.13U
M461_keeper Vdd GND #1000 Vdd pmos W=0.0975U L=1.235U
M462_ Vdd __o7t_51_6 #fb1005# Vdd pmos W=0.1625U L=0.13U
M463_keeper Vdd GND #1003 Vdd pmos W=0.0975U L=0.26U
M464_ Vdd O7_af_51_6 #fb1008# Vdd pmos W=0.1625U L=0.13U
M465_keeper Vdd GND #1006 Vdd pmos W=0.0975U L=1.235U
M466_ Vdd __o7t_52_6 #fb1011# Vdd pmos W=0.1625U L=0.13U
M467_keeper Vdd GND #1009 Vdd pmos W=0.0975U L=0.26U
M468_ Vdd O7_af_52_6 #fb1014# Vdd pmos W=0.1625U L=0.13U
M469_keeper Vdd GND #1012 Vdd pmos W=0.0975U L=1.235U
M470_ Vdd __o7t_53_6 #fb1017# Vdd pmos W=0.1625U L=0.13U
M471_keeper Vdd GND #1015 Vdd pmos W=0.0975U L=0.26U
M472_ Vdd O7_af_53_6 #fb1020# Vdd pmos W=0.1625U L=0.13U
M473_keeper Vdd GND #1018 Vdd pmos W=0.0975U L=1.235U
M474_keeper Vdd GND #1021 Vdd pmos W=0.0975U L=0.26U
M475_ GND I_at_53_6 #6 GND nmos W=0.0975U L=0.065U
M476_ GND I_af_53_6 #9 GND nmos W=0.0975U L=0.065U
M477_ GND I_at_57_6 #41 GND nmos W=0.0975U L=0.065U
M478_ GND I_af_57_6 #44 GND nmos W=0.0975U L=0.065U
M479_ GND I_at_511_6 #76 GND nmos W=0.0975U L=0.065U
M480_ GND I_af_511_6 #79 GND nmos W=0.0975U L=0.065U
M481_ GND I_at_515_6 #111 GND nmos W=0.0975U L=0.065U
M482_ GND I_af_515_6 #114 GND nmos W=0.0975U L=0.065U
M483_ GND I_at_519_6 #146 GND nmos W=0.0975U L=0.065U
M484_ GND I_af_519_6 #149 GND nmos W=0.0975U L=0.065U
M485_ GND I_at_523_6 #181 GND nmos W=0.0975U L=0.065U
M486_ GND I_af_523_6 #184 GND nmos W=0.0975U L=0.065U
M487_ GND I_at_527_6 #216 GND nmos W=0.0975U L=0.065U
M488_ GND I_af_527_6 #219 GND nmos W=0.0975U L=0.065U
M489_ GND I_at_531_6 #251 GND nmos W=0.0975U L=0.065U
M490_ GND I_af_531_6 #254 GND nmos W=0.0975U L=0.065U
M491_ GND __c_51_6 #284 GND nmos W=0.0975U L=0.065U
M492_ GND __c_53_6 #287 GND nmos W=0.0975U L=0.065U
M493_ GND __c_55_6 #290 GND nmos W=0.0975U L=0.065U
M494_ GND __c_57_6 #293 GND nmos W=0.0975U L=0.065U
M495_ GND d_51_6 #295 GND nmos W=0.0975U L=0.065U
M496_ GND d_53_6 #298 GND nmos W=0.0975U L=0.065U
M497_ GND __e_51_6 #302 GND nmos W=0.0975U L=0.065U
M498_ GND c __v GND nmos W=0.0975U L=0.065U
M499_ GND u1 #320 GND nmos W=0.0975U L=0.065U
M500_ GND __v #325 GND nmos W=0.0975U L=0.065U
M501_ GND reset b_50_6 GND nmos W=0.0975U L=0.065U
M502_ GND __v #329 GND nmos W=0.0975U L=0.065U
M503_ GND reset b_51_6 GND nmos W=0.0975U L=0.065U
M504_ GND __v #332 GND nmos W=0.0975U L=0.065U
M505_ GND reset b_52_6 GND nmos W=0.0975U L=0.065U
M506_ GND __v #335 GND nmos W=0.0975U L=0.065U
M507_ GND reset b_53_6 GND nmos W=0.0975U L=0.065U
M508_ GND __v #338 GND nmos W=0.0975U L=0.065U
M509_ GND reset b_54_6 GND nmos W=0.0975U L=0.065U
M510_ GND __v #341 GND nmos W=0.0975U L=0.065U
M511_ GND reset b_55_6 GND nmos W=0.0975U L=0.065U
M512_ GND __v #344 GND nmos W=0.0975U L=0.065U
M513_ GND reset b_56_6 GND nmos W=0.0975U L=0.065U
M514_ GND __v #347 GND nmos W=0.0975U L=0.065U
M515_ GND reset b_57_6 GND nmos W=0.0975U L=0.065U
M516_ GND __v #350 GND nmos W=0.0975U L=0.065U
M517_ GND reset b_58_6 GND nmos W=0.0975U L=0.065U
M518_ GND __v #353 GND nmos W=0.0975U L=0.065U
M519_ GND reset b_59_6 GND nmos W=0.0975U L=0.065U
M520_ GND __v #356 GND nmos W=0.0975U L=0.065U
M521_ GND reset b_510_6 GND nmos W=0.0975U L=0.065U
M522_ GND __v #359 GND nmos W=0.0975U L=0.065U
M523_ GND reset b_511_6 GND nmos W=0.0975U L=0.065U
M524_ GND __v #362 GND nmos W=0.0975U L=0.065U
M525_ GND reset b_512_6 GND nmos W=0.0975U L=0.065U
M526_ GND __v #365 GND nmos W=0.0975U L=0.065U
M527_ GND reset b_513_6 GND nmos W=0.0975U L=0.065U
M528_ GND __v #368 GND nmos W=0.0975U L=0.065U
M529_ GND reset b_514_6 GND nmos W=0.0975U L=0.065U
M530_ GND __v #371 GND nmos W=0.0975U L=0.065U
M531_ GND reset b_515_6 GND nmos W=0.0975U L=0.065U
M532_ GND __v #374 GND nmos W=0.0975U L=0.065U
M533_ GND reset b_516_6 GND nmos W=0.0975U L=0.065U
M534_ GND __v #377 GND nmos W=0.0975U L=0.065U
M535_ GND reset b_517_6 GND nmos W=0.0975U L=0.065U
M536_ GND __v #380 GND nmos W=0.0975U L=0.065U
M537_ GND reset b_518_6 GND nmos W=0.0975U L=0.065U
M538_ GND __v #383 GND nmos W=0.0975U L=0.065U
M539_ GND reset b_519_6 GND nmos W=0.0975U L=0.065U
M540_ GND __v #386 GND nmos W=0.0975U L=0.065U
M541_ GND reset b_520_6 GND nmos W=0.0975U L=0.065U
M542_ GND __v #389 GND nmos W=0.0975U L=0.065U
M543_ GND reset b_521_6 GND nmos W=0.0975U L=0.065U
M544_ GND __v #392 GND nmos W=0.0975U L=0.065U
M545_ GND reset b_522_6 GND nmos W=0.0975U L=0.065U
M546_ GND __v #395 GND nmos W=0.0975U L=0.065U
M547_ GND reset b_523_6 GND nmos W=0.0975U L=0.065U
M548_ GND __v #398 GND nmos W=0.0975U L=0.065U
M549_ GND reset b_524_6 GND nmos W=0.0975U L=0.065U
M550_ GND __v #401 GND nmos W=0.0975U L=0.065U
M551_ GND reset b_525_6 GND nmos W=0.0975U L=0.065U
M552_ GND __v #404 GND nmos W=0.0975U L=0.065U
M553_ GND reset b_526_6 GND nmos W=0.0975U L=0.065U
M554_ GND __v #407 GND nmos W=0.0975U L=0.065U
M555_ GND reset b_527_6 GND nmos W=0.0975U L=0.065U
M556_ GND __v #410 GND nmos W=0.0975U L=0.065U
M557_ GND reset b_528_6 GND nmos W=0.0975U L=0.065U
M558_ GND __v #413 GND nmos W=0.0975U L=0.065U
M559_ GND reset b_529_6 GND nmos W=0.0975U L=0.065U
M560_ GND __v #416 GND nmos W=0.0975U L=0.065U
M561_ GND reset b_530_6 GND nmos W=0.0975U L=0.065U
M562_ GND __v #419 GND nmos W=0.0975U L=0.065U
M563_ GND reset b_531_6 GND nmos W=0.0975U L=0.065U
M564_ GND O1_aa __u1 GND nmos W=0.0975U L=0.065U
M565_ GND __u1 #425 GND nmos W=0.0975U L=0.065U
M566_ GND u1 O1_af_50_6 GND nmos W=0.0975U L=0.065U
M567_ GND reset O1_af_50_6 GND nmos W=0.0975U L=0.065U
M568_ GND __u1 #434 GND nmos W=0.0975U L=0.065U
M569_ GND u1 O1_af_51_6 GND nmos W=0.0975U L=0.065U
M570_ GND reset O1_af_51_6 GND nmos W=0.0975U L=0.065U
M571_ GND __u1 #442 GND nmos W=0.0975U L=0.065U
M572_ GND u1 O1_af_52_6 GND nmos W=0.0975U L=0.065U
M573_ GND reset O1_af_52_6 GND nmos W=0.0975U L=0.065U
M574_ GND __u1 #450 GND nmos W=0.0975U L=0.065U
M575_ GND u1 O1_af_53_6 GND nmos W=0.0975U L=0.065U
M576_ GND reset O1_af_53_6 GND nmos W=0.0975U L=0.065U
M577_ GND O2_aa __u2 GND nmos W=0.0975U L=0.065U
M578_ GND __u2 #460 GND nmos W=0.0975U L=0.065U
M579_ GND u2 O2_af_50_6 GND nmos W=0.0975U L=0.065U
M580_ GND reset O2_af_50_6 GND nmos W=0.0975U L=0.065U
M581_ GND __u2 #468 GND nmos W=0.0975U L=0.065U
M582_ GND u2 O2_af_51_6 GND nmos W=0.0975U L=0.065U
M583_ GND reset O2_af_51_6 GND nmos W=0.0975U L=0.065U
M584_ GND __u2 #476 GND nmos W=0.0975U L=0.065U
M585_ GND u2 O2_af_52_6 GND nmos W=0.0975U L=0.065U
M586_ GND reset O2_af_52_6 GND nmos W=0.0975U L=0.065U
M587_ GND __u2 #484 GND nmos W=0.0975U L=0.065U
M588_ GND u2 O2_af_53_6 GND nmos W=0.0975U L=0.065U
M589_ GND reset O2_af_53_6 GND nmos W=0.0975U L=0.065U
M590_ GND O3_aa __u3 GND nmos W=0.0975U L=0.065U
M591_ GND __u3 #494 GND nmos W=0.0975U L=0.065U
M592_ GND u3 O3_af_50_6 GND nmos W=0.0975U L=0.065U
M593_ GND reset O3_af_50_6 GND nmos W=0.0975U L=0.065U
M594_ GND __u3 #502 GND nmos W=0.0975U L=0.065U
M595_ GND u3 O3_af_51_6 GND nmos W=0.0975U L=0.065U
M596_ GND reset O3_af_51_6 GND nmos W=0.0975U L=0.065U
M597_ GND __u3 #510 GND nmos W=0.0975U L=0.065U
M598_ GND u3 O3_af_52_6 GND nmos W=0.0975U L=0.065U
M599_ GND reset O3_af_52_6 GND nmos W=0.0975U L=0.065U
M600_ GND __u3 #518 GND nmos W=0.0975U L=0.065U
M601_ GND u3 O3_af_53_6 GND nmos W=0.0975U L=0.065U
M602_ GND reset O3_af_53_6 GND nmos W=0.0975U L=0.065U
M603_ GND O4_aa __u4 GND nmos W=0.0975U L=0.065U
M604_ GND __u4 #528 GND nmos W=0.0975U L=0.065U
M605_ GND u4 O4_af_50_6 GND nmos W=0.0975U L=0.065U
M606_ GND reset O4_af_50_6 GND nmos W=0.0975U L=0.065U
M607_ GND __u4 #536 GND nmos W=0.0975U L=0.065U
M608_ GND u4 O4_af_51_6 GND nmos W=0.0975U L=0.065U
M609_ GND reset O4_af_51_6 GND nmos W=0.0975U L=0.065U
M610_ GND __u4 #544 GND nmos W=0.0975U L=0.065U
M611_ GND u4 O4_af_52_6 GND nmos W=0.0975U L=0.065U
M612_ GND reset O4_af_52_6 GND nmos W=0.0975U L=0.065U
M613_ GND __u4 #552 GND nmos W=0.0975U L=0.065U
M614_ GND u4 O4_af_53_6 GND nmos W=0.0975U L=0.065U
M615_ GND reset O4_af_53_6 GND nmos W=0.0975U L=0.065U
M616_ GND O5_aa __u5 GND nmos W=0.0975U L=0.065U
M617_ GND __u5 #562 GND nmos W=0.0975U L=0.065U
M618_ GND u5 O5_af_50_6 GND nmos W=0.0975U L=0.065U
M619_ GND reset O5_af_50_6 GND nmos W=0.0975U L=0.065U
M620_ GND __u5 #570 GND nmos W=0.0975U L=0.065U
M621_ GND u5 O5_af_51_6 GND nmos W=0.0975U L=0.065U
M622_ GND reset O5_af_51_6 GND nmos W=0.0975U L=0.065U
M623_ GND __u5 #578 GND nmos W=0.0975U L=0.065U
M624_ GND u5 O5_af_52_6 GND nmos W=0.0975U L=0.065U
M625_ GND reset O5_af_52_6 GND nmos W=0.0975U L=0.065U
M626_ GND __u5 #586 GND nmos W=0.0975U L=0.065U
M627_ GND u5 O5_af_53_6 GND nmos W=0.0975U L=0.065U
M628_ GND reset O5_af_53_6 GND nmos W=0.0975U L=0.065U
M629_ GND O6_aa __u6 GND nmos W=0.0975U L=0.065U
M630_ GND __u6 #596 GND nmos W=0.0975U L=0.065U
M631_ GND u6 O6_af_50_6 GND nmos W=0.0975U L=0.065U
M632_ GND reset O6_af_50_6 GND nmos W=0.0975U L=0.065U
M633_ GND __u6 #604 GND nmos W=0.0975U L=0.065U
M634_ GND u6 O6_af_51_6 GND nmos W=0.0975U L=0.065U
M635_ GND reset O6_af_51_6 GND nmos W=0.0975U L=0.065U
M636_ GND __u6 #612 GND nmos W=0.0975U L=0.065U
M637_ GND u6 O6_af_52_6 GND nmos W=0.0975U L=0.065U
M638_ GND reset O6_af_52_6 GND nmos W=0.0975U L=0.065U
M639_ GND __u6 #620 GND nmos W=0.0975U L=0.065U
M640_ GND u6 O6_af_53_6 GND nmos W=0.0975U L=0.065U
M641_ GND reset O6_af_53_6 GND nmos W=0.0975U L=0.065U
M642_ GND O7_aa __u7 GND nmos W=0.0975U L=0.065U
M643_ GND __u7 #630 GND nmos W=0.0975U L=0.065U
M644_ GND u7 O7_af_50_6 GND nmos W=0.0975U L=0.065U
M645_ GND reset O7_af_50_6 GND nmos W=0.0975U L=0.065U
M646_ GND __u7 #638 GND nmos W=0.0975U L=0.065U
M647_ GND u7 O7_af_51_6 GND nmos W=0.0975U L=0.065U
M648_ GND reset O7_af_51_6 GND nmos W=0.0975U L=0.065U
M649_ GND __u7 #646 GND nmos W=0.0975U L=0.065U
M650_ GND u7 O7_af_52_6 GND nmos W=0.0975U L=0.065U
M651_ GND reset O7_af_52_6 GND nmos W=0.0975U L=0.065U
M652_ GND __u7 #654 GND nmos W=0.0975U L=0.065U
M653_ GND u7 O7_af_53_6 GND nmos W=0.0975U L=0.065U
M654_ GND reset O7_af_53_6 GND nmos W=0.0975U L=0.065U
M655_ GND reset __r GND nmos W=0.0975U L=0.065U
M656_ GND __v v GND nmos W=0.0975U L=0.065U
M657_ GND __i__a I_aa GND nmos W=0.0975U L=0.065U
M658_ GND O1_aa __o1a GND nmos W=0.0975U L=0.065U
M659_ GND b_50_6 __b_50_6 GND nmos W=0.0975U L=0.065U
M660_ GND I_at_50_6 __i__t_50_6 GND nmos W=0.0975U L=0.065U
M661_ GND b_51_6 __b_51_6 GND nmos W=0.0975U L=0.065U
M662_ GND I_at_51_6 __i__t_51_6 GND nmos W=0.0975U L=0.065U
M663_ GND b_52_6 __b_52_6 GND nmos W=0.0975U L=0.065U
M664_ GND I_at_52_6 __i__t_52_6 GND nmos W=0.0975U L=0.065U
M665_ GND b_53_6 __b_53_6 GND nmos W=0.0975U L=0.065U
M666_ GND I_at_53_6 __i__t_53_6 GND nmos W=0.0975U L=0.065U
M667_ GND b_54_6 __b_54_6 GND nmos W=0.0975U L=0.065U
M668_ GND I_at_54_6 __i__t_54_6 GND nmos W=0.0975U L=0.065U
M669_ GND b_55_6 __b_55_6 GND nmos W=0.0975U L=0.065U
M670_ GND I_at_55_6 __i__t_55_6 GND nmos W=0.0975U L=0.065U
M671_ GND b_56_6 __b_56_6 GND nmos W=0.0975U L=0.065U
M672_ GND I_at_56_6 __i__t_56_6 GND nmos W=0.0975U L=0.065U
M673_ GND b_57_6 __b_57_6 GND nmos W=0.0975U L=0.065U
M674_ GND I_at_57_6 __i__t_57_6 GND nmos W=0.0975U L=0.065U
M675_ GND b_58_6 __b_58_6 GND nmos W=0.0975U L=0.065U
M676_ GND I_at_58_6 __i__t_58_6 GND nmos W=0.0975U L=0.065U
M677_ GND b_59_6 __b_59_6 GND nmos W=0.0975U L=0.065U
M678_ GND I_at_59_6 __i__t_59_6 GND nmos W=0.0975U L=0.065U
M679_ GND b_510_6 __b_510_6 GND nmos W=0.0975U L=0.065U
M680_ GND I_at_510_6 __i__t_510_6 GND nmos W=0.0975U L=0.065U
M681_ GND b_511_6 __b_511_6 GND nmos W=0.0975U L=0.065U
M682_ GND I_at_511_6 __i__t_511_6 GND nmos W=0.0975U L=0.065U
M683_ GND b_512_6 __b_512_6 GND nmos W=0.0975U L=0.065U
M684_ GND I_at_512_6 __i__t_512_6 GND nmos W=0.0975U L=0.065U
M685_ GND b_513_6 __b_513_6 GND nmos W=0.0975U L=0.065U
M686_ GND I_at_513_6 __i__t_513_6 GND nmos W=0.0975U L=0.065U
M687_ GND b_514_6 __b_514_6 GND nmos W=0.0975U L=0.065U
M688_ GND I_at_514_6 __i__t_514_6 GND nmos W=0.0975U L=0.065U
M689_ GND b_515_6 __b_515_6 GND nmos W=0.0975U L=0.065U
M690_ GND I_at_515_6 __i__t_515_6 GND nmos W=0.0975U L=0.065U
M691_ GND b_516_6 __b_516_6 GND nmos W=0.0975U L=0.065U
M692_ GND I_at_516_6 __i__t_516_6 GND nmos W=0.0975U L=0.065U
M693_ GND b_517_6 __b_517_6 GND nmos W=0.0975U L=0.065U
M694_ GND I_at_517_6 __i__t_517_6 GND nmos W=0.0975U L=0.065U
M695_ GND b_518_6 __b_518_6 GND nmos W=0.0975U L=0.065U
M696_ GND I_at_518_6 __i__t_518_6 GND nmos W=0.0975U L=0.065U
M697_ GND b_519_6 __b_519_6 GND nmos W=0.0975U L=0.065U
M698_ GND I_at_519_6 __i__t_519_6 GND nmos W=0.0975U L=0.065U
M699_ GND b_520_6 __b_520_6 GND nmos W=0.0975U L=0.065U
M700_ GND I_at_520_6 __i__t_520_6 GND nmos W=0.0975U L=0.065U
M701_ GND b_521_6 __b_521_6 GND nmos W=0.0975U L=0.065U
M702_ GND I_at_521_6 __i__t_521_6 GND nmos W=0.0975U L=0.065U
M703_ GND b_522_6 __b_522_6 GND nmos W=0.0975U L=0.065U
M704_ GND I_at_522_6 __i__t_522_6 GND nmos W=0.0975U L=0.065U
M705_ GND b_523_6 __b_523_6 GND nmos W=0.0975U L=0.065U
M706_ GND I_at_523_6 __i__t_523_6 GND nmos W=0.0975U L=0.065U
M707_ GND b_524_6 __b_524_6 GND nmos W=0.0975U L=0.065U
M708_ GND I_at_524_6 __i__t_524_6 GND nmos W=0.0975U L=0.065U
M709_ GND b_525_6 __b_525_6 GND nmos W=0.0975U L=0.065U
M710_ GND I_at_525_6 __i__t_525_6 GND nmos W=0.0975U L=0.065U
M711_ GND b_526_6 __b_526_6 GND nmos W=0.0975U L=0.065U
M712_ GND I_at_526_6 __i__t_526_6 GND nmos W=0.0975U L=0.065U
M713_ GND b_527_6 __b_527_6 GND nmos W=0.0975U L=0.065U
M714_ GND I_at_527_6 __i__t_527_6 GND nmos W=0.0975U L=0.065U
M715_ GND b_528_6 __b_528_6 GND nmos W=0.0975U L=0.065U
M716_ GND I_at_528_6 __i__t_528_6 GND nmos W=0.0975U L=0.065U
M717_ GND b_529_6 __b_529_6 GND nmos W=0.0975U L=0.065U
M718_ GND I_at_529_6 __i__t_529_6 GND nmos W=0.0975U L=0.065U
M719_ GND b_530_6 __b_530_6 GND nmos W=0.0975U L=0.065U
M720_ GND I_at_530_6 __i__t_530_6 GND nmos W=0.0975U L=0.065U
M721_ GND b_531_6 __b_531_6 GND nmos W=0.0975U L=0.065U
M722_ GND I_at_531_6 __i__t_531_6 GND nmos W=0.0975U L=0.065U
M723_ GND __u1 u1 GND nmos W=0.0975U L=0.065U
M724_ GND __o1t_50_6 O1_at_50_6 GND nmos W=0.0975U L=0.065U
M725_ GND __o1t_51_6 O1_at_51_6 GND nmos W=0.0975U L=0.065U
M726_ GND __o1t_52_6 O1_at_52_6 GND nmos W=0.0975U L=0.065U
M727_ GND __o1t_53_6 O1_at_53_6 GND nmos W=0.0975U L=0.065U
M728_ GND __u2 u2 GND nmos W=0.0975U L=0.065U
M729_ GND __o2t_50_6 O2_at_50_6 GND nmos W=0.0975U L=0.065U
M730_ GND __o2t_51_6 O2_at_51_6 GND nmos W=0.0975U L=0.065U
M731_ GND __o2t_52_6 O2_at_52_6 GND nmos W=0.0975U L=0.065U
M732_ GND __o2t_53_6 O2_at_53_6 GND nmos W=0.0975U L=0.065U
M733_ GND __u3 u3 GND nmos W=0.0975U L=0.065U
M734_ GND __o3t_50_6 O3_at_50_6 GND nmos W=0.0975U L=0.065U
M735_ GND __o3t_51_6 O3_at_51_6 GND nmos W=0.0975U L=0.065U
M736_ GND __o3t_52_6 O3_at_52_6 GND nmos W=0.0975U L=0.065U
M737_ GND __o3t_53_6 O3_at_53_6 GND nmos W=0.0975U L=0.065U
M738_ GND __u4 u4 GND nmos W=0.0975U L=0.065U
M739_ GND __o4t_50_6 O4_at_50_6 GND nmos W=0.0975U L=0.065U
M740_ GND __o4t_51_6 O4_at_51_6 GND nmos W=0.0975U L=0.065U
M741_ GND __o4t_52_6 O4_at_52_6 GND nmos W=0.0975U L=0.065U
M742_ GND __o4t_53_6 O4_at_53_6 GND nmos W=0.0975U L=0.065U
M743_ GND __u5 u5 GND nmos W=0.0975U L=0.065U
M744_ GND __o5t_50_6 O5_at_50_6 GND nmos W=0.0975U L=0.065U
M745_ GND __o5t_51_6 O5_at_51_6 GND nmos W=0.0975U L=0.065U
M746_ GND __o5t_52_6 O5_at_52_6 GND nmos W=0.0975U L=0.065U
M747_ GND __o5t_53_6 O5_at_53_6 GND nmos W=0.0975U L=0.065U
M748_ GND __u6 u6 GND nmos W=0.0975U L=0.065U
M749_ GND __o6t_50_6 O6_at_50_6 GND nmos W=0.0975U L=0.065U
M750_ GND __o6t_51_6 O6_at_51_6 GND nmos W=0.0975U L=0.065U
M751_ GND __o6t_52_6 O6_at_52_6 GND nmos W=0.0975U L=0.065U
M752_ GND __o6t_53_6 O6_at_53_6 GND nmos W=0.0975U L=0.065U
M753_ GND __u7 u7 GND nmos W=0.0975U L=0.065U
M754_ GND __o7t_50_6 O7_at_50_6 GND nmos W=0.0975U L=0.065U
M755_ GND __o7t_51_6 O7_at_51_6 GND nmos W=0.0975U L=0.065U
M756_ GND __o7t_52_6 O7_at_52_6 GND nmos W=0.0975U L=0.065U
M757_ GND __o7t_53_6 O7_at_53_6 GND nmos W=0.0975U L=0.065U
M758_ GND __c_50_6 #fb687# GND nmos W=0.0975U L=0.13U
M759_ GND b_53_6 #fb690# GND nmos W=0.0975U L=0.13U
M760_keeper GND Vdd #689 GND nmos W=0.0975U L=6.175U
M761_ GND b_52_6 #fb693# GND nmos W=0.0975U L=0.13U
M762_keeper GND Vdd #692 GND nmos W=0.0975U L=1.495U
M763_ GND b_51_6 #fb696# GND nmos W=0.0975U L=0.13U
M764_keeper GND Vdd #695 GND nmos W=0.0975U L=1.495U
M765_ GND b_50_6 #fb699# GND nmos W=0.0975U L=0.13U
M766_keeper GND Vdd #698 GND nmos W=0.0975U L=1.495U
M767_ GND __c_51_6 #fb702# GND nmos W=0.0975U L=0.13U
M768_keeper GND Vdd #701 GND nmos W=0.0975U L=1.495U
M769_ GND b_57_6 #fb705# GND nmos W=0.0975U L=0.13U
M770_keeper GND Vdd #704 GND nmos W=0.0975U L=6.175U
M771_ GND b_56_6 #fb708# GND nmos W=0.0975U L=0.13U
M772_keeper GND Vdd #707 GND nmos W=0.0975U L=1.495U
M773_ GND b_55_6 #fb711# GND nmos W=0.0975U L=0.13U
M774_keeper GND Vdd #710 GND nmos W=0.0975U L=1.495U
M775_ GND b_54_6 #fb714# GND nmos W=0.0975U L=0.13U
M776_keeper GND Vdd #713 GND nmos W=0.0975U L=1.495U
M777_ GND __c_52_6 #fb717# GND nmos W=0.0975U L=0.13U
M778_keeper GND Vdd #716 GND nmos W=0.0975U L=1.495U
M779_ GND b_511_6 #fb720# GND nmos W=0.0975U L=0.13U
M780_keeper GND Vdd #719 GND nmos W=0.0975U L=6.175U
M781_ GND b_510_6 #fb723# GND nmos W=0.0975U L=0.13U
M782_keeper GND Vdd #722 GND nmos W=0.0975U L=1.495U
M783_ GND b_59_6 #fb726# GND nmos W=0.0975U L=0.13U
M784_keeper GND Vdd #725 GND nmos W=0.0975U L=1.495U
M785_ GND b_58_6 #fb729# GND nmos W=0.0975U L=0.13U
M786_keeper GND Vdd #728 GND nmos W=0.0975U L=1.495U
M787_ GND __c_53_6 #fb732# GND nmos W=0.0975U L=0.13U
M788_keeper GND Vdd #731 GND nmos W=0.0975U L=1.495U
M789_ GND b_515_6 #fb735# GND nmos W=0.0975U L=0.13U
M790_keeper GND Vdd #734 GND nmos W=0.0975U L=6.175U
M791_ GND b_514_6 #fb738# GND nmos W=0.0975U L=0.13U
M792_keeper GND Vdd #737 GND nmos W=0.0975U L=1.495U
M793_ GND b_513_6 #fb741# GND nmos W=0.0975U L=0.13U
M794_keeper GND Vdd #740 GND nmos W=0.0975U L=1.495U
M795_ GND b_512_6 #fb744# GND nmos W=0.0975U L=0.13U
M796_keeper GND Vdd #743 GND nmos W=0.0975U L=1.495U
M797_ GND __c_54_6 #fb747# GND nmos W=0.0975U L=0.13U
M798_keeper GND Vdd #746 GND nmos W=0.0975U L=1.495U
M799_ GND b_519_6 #fb750# GND nmos W=0.0975U L=0.13U
M800_keeper GND Vdd #749 GND nmos W=0.0975U L=6.175U
M801_ GND b_518_6 #fb753# GND nmos W=0.0975U L=0.13U
M802_keeper GND Vdd #752 GND nmos W=0.0975U L=1.495U
M803_ GND b_517_6 #fb756# GND nmos W=0.0975U L=0.13U
M804_keeper GND Vdd #755 GND nmos W=0.0975U L=1.495U
M805_ GND b_516_6 #fb759# GND nmos W=0.0975U L=0.13U
M806_keeper GND Vdd #758 GND nmos W=0.0975U L=1.495U
M807_ GND __c_55_6 #fb762# GND nmos W=0.0975U L=0.13U
M808_keeper GND Vdd #761 GND nmos W=0.0975U L=1.495U
M809_ GND b_523_6 #fb765# GND nmos W=0.0975U L=0.13U
M810_keeper GND Vdd #764 GND nmos W=0.0975U L=6.175U
M811_ GND b_522_6 #fb768# GND nmos W=0.0975U L=0.13U
M812_keeper GND Vdd #767 GND nmos W=0.0975U L=1.495U
M813_ GND b_521_6 #fb771# GND nmos W=0.0975U L=0.13U
M814_keeper GND Vdd #770 GND nmos W=0.0975U L=1.495U
M815_ GND b_520_6 #fb774# GND nmos W=0.0975U L=0.13U
M816_keeper GND Vdd #773 GND nmos W=0.0975U L=1.495U
M817_ GND __c_56_6 #fb777# GND nmos W=0.0975U L=0.13U
M818_keeper GND Vdd #776 GND nmos W=0.0975U L=1.495U
M819_ GND b_527_6 #fb780# GND nmos W=0.0975U L=0.13U
M820_keeper GND Vdd #779 GND nmos W=0.0975U L=6.175U
M821_ GND b_526_6 #fb783# GND nmos W=0.0975U L=0.13U
M822_keeper GND Vdd #782 GND nmos W=0.0975U L=1.495U
M823_ GND b_525_6 #fb786# GND nmos W=0.0975U L=0.13U
M824_keeper GND Vdd #785 GND nmos W=0.0975U L=1.495U
M825_ GND b_524_6 #fb789# GND nmos W=0.0975U L=0.13U
M826_keeper GND Vdd #788 GND nmos W=0.0975U L=1.495U
M827_ GND __c_57_6 #fb792# GND nmos W=0.0975U L=0.13U
M828_keeper GND Vdd #791 GND nmos W=0.0975U L=1.495U
M829_ GND b_531_6 #fb795# GND nmos W=0.0975U L=0.13U
M830_keeper GND Vdd #794 GND nmos W=0.0975U L=6.175U
M831_ GND b_530_6 #fb798# GND nmos W=0.0975U L=0.13U
M832_keeper GND Vdd #797 GND nmos W=0.0975U L=1.495U
M833_ GND b_529_6 #fb801# GND nmos W=0.0975U L=0.13U
M834_keeper GND Vdd #800 GND nmos W=0.0975U L=1.495U
M835_ GND b_528_6 #fb804# GND nmos W=0.0975U L=0.13U
M836_keeper GND Vdd #803 GND nmos W=0.0975U L=1.495U
M837_ GND d_50_6 #fb807# GND nmos W=0.0975U L=0.13U
M838_keeper GND Vdd #806 GND nmos W=0.0975U L=1.495U
M839_ GND d_51_6 #fb810# GND nmos W=0.0975U L=0.13U
M840_keeper GND Vdd #809 GND nmos W=0.0975U L=1.495U
M841_ GND d_52_6 #fb813# GND nmos W=0.0975U L=0.13U
M842_keeper GND Vdd #812 GND nmos W=0.0975U L=1.495U
M843_ GND d_53_6 #fb816# GND nmos W=0.0975U L=0.13U
M844_keeper GND Vdd #815 GND nmos W=0.0975U L=1.495U
M845_ GND __e_50_6 #fb819# GND nmos W=0.0975U L=0.13U
M846_keeper GND Vdd #818 GND nmos W=0.0975U L=1.495U
M847_ GND __e_51_6 #fb822# GND nmos W=0.0975U L=0.13U
M848_keeper GND Vdd #821 GND nmos W=0.0975U L=1.495U
M849_ GND c #fb825# GND nmos W=0.0975U L=0.13U
M850_keeper GND Vdd #824 GND nmos W=0.0975U L=1.495U
M851_ GND __v #fb828# GND nmos W=0.0975U L=0.13U
M852_keeper GND Vdd #827 GND nmos W=0.0975U L=1.495U
M853_ GND __i__a #fb831# GND nmos W=0.0975U L=0.13U
M854_keeper GND Vdd #830 GND nmos W=0.0975U L=6.175U
M855_ GND __u1 #fb834# GND nmos W=0.0975U L=0.13U
M856_keeper GND Vdd #833 GND nmos W=0.0975U L=0.715U
M857_ GND __o1t_50_6 #fb837# GND nmos W=0.0975U L=0.13U
M858_keeper GND Vdd #836 GND nmos W=0.0975U L=0.715U
M859_ GND O1_af_50_6 #fb840# GND nmos W=0.0975U L=0.13U
M860_keeper GND Vdd #839 GND nmos W=0.0975U L=0.715U
M861_ GND __o1t_51_6 #fb843# GND nmos W=0.0975U L=0.13U
M862_keeper GND Vdd #842 GND nmos W=0.0975U L=3.055U
M863_ GND O1_af_51_6 #fb846# GND nmos W=0.0975U L=0.13U
M864_keeper GND Vdd #845 GND nmos W=0.0975U L=0.715U
M865_ GND __o1t_52_6 #fb849# GND nmos W=0.0975U L=0.13U
M866_keeper GND Vdd #848 GND nmos W=0.0975U L=3.055U
M867_ GND O1_af_52_6 #fb852# GND nmos W=0.0975U L=0.13U
M868_keeper GND Vdd #851 GND nmos W=0.0975U L=0.715U
M869_ GND __o1t_53_6 #fb855# GND nmos W=0.0975U L=0.13U
M870_keeper GND Vdd #854 GND nmos W=0.0975U L=3.055U
M871_ GND O1_af_53_6 #fb858# GND nmos W=0.0975U L=0.13U
M872_keeper GND Vdd #857 GND nmos W=0.0975U L=0.715U
M873_ GND __u2 #fb861# GND nmos W=0.0975U L=0.13U
M874_keeper GND Vdd #860 GND nmos W=0.0975U L=3.055U
M875_ GND __o2t_50_6 #fb864# GND nmos W=0.0975U L=0.13U
M876_keeper GND Vdd #863 GND nmos W=0.0975U L=0.715U
M877_ GND O2_af_50_6 #fb867# GND nmos W=0.0975U L=0.13U
M878_keeper GND Vdd #866 GND nmos W=0.0975U L=0.715U
M879_ GND __o2t_51_6 #fb870# GND nmos W=0.0975U L=0.13U
M880_keeper GND Vdd #869 GND nmos W=0.0975U L=3.055U
M881_ GND O2_af_51_6 #fb873# GND nmos W=0.0975U L=0.13U
M882_keeper GND Vdd #872 GND nmos W=0.0975U L=0.715U
M883_ GND __o2t_52_6 #fb876# GND nmos W=0.0975U L=0.13U
M884_keeper GND Vdd #875 GND nmos W=0.0975U L=3.055U
M885_ GND O2_af_52_6 #fb879# GND nmos W=0.0975U L=0.13U
M886_keeper GND Vdd #878 GND nmos W=0.0975U L=0.715U
M887_ GND __o2t_53_6 #fb882# GND nmos W=0.0975U L=0.13U
M888_keeper GND Vdd #881 GND nmos W=0.0975U L=3.055U
M889_ GND O2_af_53_6 #fb885# GND nmos W=0.0975U L=0.13U
M890_keeper GND Vdd #884 GND nmos W=0.0975U L=0.715U
M891_ GND __u3 #fb888# GND nmos W=0.0975U L=0.13U
M892_keeper GND Vdd #887 GND nmos W=0.0975U L=3.055U
M893_ GND __o3t_50_6 #fb891# GND nmos W=0.0975U L=0.13U
M894_keeper GND Vdd #890 GND nmos W=0.0975U L=0.715U
M895_ GND O3_af_50_6 #fb894# GND nmos W=0.0975U L=0.13U
M896_keeper GND Vdd #893 GND nmos W=0.0975U L=0.715U
M897_ GND __o3t_51_6 #fb897# GND nmos W=0.0975U L=0.13U
M898_keeper GND Vdd #896 GND nmos W=0.0975U L=3.055U
M899_ GND O3_af_51_6 #fb900# GND nmos W=0.0975U L=0.13U
M900_keeper GND Vdd #899 GND nmos W=0.0975U L=0.715U
M901_ GND __o3t_52_6 #fb903# GND nmos W=0.0975U L=0.13U
M902_keeper GND Vdd #902 GND nmos W=0.0975U L=3.055U
M903_ GND O3_af_52_6 #fb906# GND nmos W=0.0975U L=0.13U
M904_keeper GND Vdd #905 GND nmos W=0.0975U L=0.715U
M905_ GND __o3t_53_6 #fb909# GND nmos W=0.0975U L=0.13U
M906_keeper GND Vdd #908 GND nmos W=0.0975U L=3.055U
M907_ GND O3_af_53_6 #fb912# GND nmos W=0.0975U L=0.13U
M908_keeper GND Vdd #911 GND nmos W=0.0975U L=0.715U
M909_ GND __u4 #fb915# GND nmos W=0.0975U L=0.13U
M910_keeper GND Vdd #914 GND nmos W=0.0975U L=3.055U
M911_ GND __o4t_50_6 #fb918# GND nmos W=0.0975U L=0.13U
M912_keeper GND Vdd #917 GND nmos W=0.0975U L=0.715U
M913_ GND O4_af_50_6 #fb921# GND nmos W=0.0975U L=0.13U
M914_keeper GND Vdd #920 GND nmos W=0.0975U L=0.715U
M915_ GND __o4t_51_6 #fb924# GND nmos W=0.0975U L=0.13U
M916_keeper GND Vdd #923 GND nmos W=0.0975U L=3.055U
M917_ GND O4_af_51_6 #fb927# GND nmos W=0.0975U L=0.13U
M918_keeper GND Vdd #926 GND nmos W=0.0975U L=0.715U
M919_ GND __o4t_52_6 #fb930# GND nmos W=0.0975U L=0.13U
M920_keeper GND Vdd #929 GND nmos W=0.0975U L=3.055U
M921_ GND O4_af_52_6 #fb933# GND nmos W=0.0975U L=0.13U
M922_keeper GND Vdd #932 GND nmos W=0.0975U L=0.715U
M923_ GND __o4t_53_6 #fb936# GND nmos W=0.0975U L=0.13U
M924_keeper GND Vdd #935 GND nmos W=0.0975U L=3.055U
M925_ GND O4_af_53_6 #fb939# GND nmos W=0.0975U L=0.13U
M926_keeper GND Vdd #938 GND nmos W=0.0975U L=0.715U
M927_ GND __u5 #fb942# GND nmos W=0.0975U L=0.13U
M928_keeper GND Vdd #941 GND nmos W=0.0975U L=3.055U
M929_ GND __o5t_50_6 #fb945# GND nmos W=0.0975U L=0.13U
M930_keeper GND Vdd #944 GND nmos W=0.0975U L=0.715U
M931_ GND O5_af_50_6 #fb948# GND nmos W=0.0975U L=0.13U
M932_keeper GND Vdd #947 GND nmos W=0.0975U L=0.715U
M933_ GND __o5t_51_6 #fb951# GND nmos W=0.0975U L=0.13U
M934_keeper GND Vdd #950 GND nmos W=0.0975U L=3.055U
M935_ GND O5_af_51_6 #fb954# GND nmos W=0.0975U L=0.13U
M936_keeper GND Vdd #953 GND nmos W=0.0975U L=0.715U
M937_ GND __o5t_52_6 #fb957# GND nmos W=0.0975U L=0.13U
M938_keeper GND Vdd #956 GND nmos W=0.0975U L=3.055U
M939_ GND O5_af_52_6 #fb960# GND nmos W=0.0975U L=0.13U
M940_keeper GND Vdd #959 GND nmos W=0.0975U L=0.715U
M941_ GND __o5t_53_6 #fb963# GND nmos W=0.0975U L=0.13U
M942_keeper GND Vdd #962 GND nmos W=0.0975U L=3.055U
M943_ GND O5_af_53_6 #fb966# GND nmos W=0.0975U L=0.13U
M944_keeper GND Vdd #965 GND nmos W=0.0975U L=0.715U
M945_ GND __u6 #fb969# GND nmos W=0.0975U L=0.13U
M946_keeper GND Vdd #968 GND nmos W=0.0975U L=3.055U
M947_ GND __o6t_50_6 #fb972# GND nmos W=0.0975U L=0.13U
M948_keeper GND Vdd #971 GND nmos W=0.0975U L=0.715U
M949_ GND O6_af_50_6 #fb975# GND nmos W=0.0975U L=0.13U
M950_keeper GND Vdd #974 GND nmos W=0.0975U L=0.715U
M951_ GND __o6t_51_6 #fb978# GND nmos W=0.0975U L=0.13U
M952_keeper GND Vdd #977 GND nmos W=0.0975U L=3.055U
M953_ GND O6_af_51_6 #fb981# GND nmos W=0.0975U L=0.13U
M954_keeper GND Vdd #980 GND nmos W=0.0975U L=0.715U
M955_ GND __o6t_52_6 #fb984# GND nmos W=0.0975U L=0.13U
M956_keeper GND Vdd #983 GND nmos W=0.0975U L=3.055U
M957_ GND O6_af_52_6 #fb987# GND nmos W=0.0975U L=0.13U
M958_keeper GND Vdd #986 GND nmos W=0.0975U L=0.715U
M959_ GND __o6t_53_6 #fb990# GND nmos W=0.0975U L=0.13U
M960_keeper GND Vdd #989 GND nmos W=0.0975U L=3.055U
M961_ GND O6_af_53_6 #fb993# GND nmos W=0.0975U L=0.13U
M962_keeper GND Vdd #992 GND nmos W=0.0975U L=0.715U
M963_ GND __u7 #fb996# GND nmos W=0.0975U L=0.13U
M964_keeper GND Vdd #995 GND nmos W=0.0975U L=3.055U
M965_ GND __o7t_50_6 #fb999# GND nmos W=0.0975U L=0.13U
M966_keeper GND Vdd #998 GND nmos W=0.0975U L=0.715U
M967_ GND O7_af_50_6 #fb1002# GND nmos W=0.0975U L=0.13U
M968_keeper GND Vdd #1001 GND nmos W=0.0975U L=0.715U
M969_ GND __o7t_51_6 #fb1005# GND nmos W=0.0975U L=0.13U
M970_keeper GND Vdd #1004 GND nmos W=0.0975U L=3.055U
M971_ GND O7_af_51_6 #fb1008# GND nmos W=0.0975U L=0.13U
M972_keeper GND Vdd #1007 GND nmos W=0.0975U L=0.715U
M973_ GND __o7t_52_6 #fb1011# GND nmos W=0.0975U L=0.13U
M974_keeper GND Vdd #1010 GND nmos W=0.0975U L=3.055U
M975_ GND O7_af_52_6 #fb1014# GND nmos W=0.0975U L=0.13U
M976_keeper GND Vdd #1013 GND nmos W=0.0975U L=0.715U
M977_ GND __o7t_53_6 #fb1017# GND nmos W=0.0975U L=0.13U
M978_keeper GND Vdd #1016 GND nmos W=0.0975U L=3.055U
M979_ GND O7_af_53_6 #fb1020# GND nmos W=0.0975U L=0.13U
M980_keeper GND Vdd #1019 GND nmos W=0.0975U L=0.715U
M981_keeper GND Vdd #1022 GND nmos W=0.0975U L=3.055U
M982_ #24 b_50_6 __c_50_6 GND nmos W=0.0975U L=0.065U
M983_ #27 __b_50_6 __c_50_6 GND nmos W=0.0975U L=0.065U
M984_ #36 I_af_50_6 __c_50_6 Vdd pmos W=0.1625U L=0.065U
M985_keeper #688 #fb687# __c_50_6 Vdd pmos W=0.0975U L=0.065U
M986_keeper #689 #fb687# __c_50_6 GND nmos W=0.0975U L=0.065U
M987_ #18 b_51_6 #3 GND nmos W=0.0975U L=0.065U
M988_ #21 __b_51_6 #3 GND nmos W=0.0975U L=0.065U
M989_ #3 I_at_50_6 #24 GND nmos W=0.0975U L=0.065U
M990_ #3 I_af_50_6 #27 GND nmos W=0.0975U L=0.065U
M991_ #12 b_52_6 #4 GND nmos W=0.0975U L=0.065U
M992_ #15 __b_52_6 #4 GND nmos W=0.0975U L=0.065U
M993_ #4 I_at_51_6 #18 GND nmos W=0.0975U L=0.065U
M994_ #4 I_af_51_6 #21 GND nmos W=0.0975U L=0.065U
M995_ #6 b_53_6 #5 GND nmos W=0.0975U L=0.065U
M996_ #9 __b_53_6 #5 GND nmos W=0.0975U L=0.065U
M997_ #5 I_at_52_6 #12 GND nmos W=0.0975U L=0.065U
M998_ #5 I_af_52_6 #15 GND nmos W=0.0975U L=0.065U
M999_ #333 __i__t_53_6 b_53_6 Vdd pmos W=0.1625U L=0.065U
M1000_ #335 I_af_53_6 b_53_6 GND nmos W=0.0975U L=0.065U
M1001_keeper #691 #fb690# b_53_6 Vdd pmos W=0.0975U L=0.065U
M1002_keeper #692 #fb690# b_53_6 GND nmos W=0.0975U L=0.065U
M1003_ #330 __i__t_52_6 b_52_6 Vdd pmos W=0.1625U L=0.065U
M1004_ #332 I_af_52_6 b_52_6 GND nmos W=0.0975U L=0.065U
M1005_keeper #694 #fb693# b_52_6 Vdd pmos W=0.0975U L=0.065U
M1006_keeper #695 #fb693# b_52_6 GND nmos W=0.0975U L=0.065U
M1007_ #327 __i__t_51_6 b_51_6 Vdd pmos W=0.1625U L=0.065U
M1008_ #329 I_af_51_6 b_51_6 GND nmos W=0.0975U L=0.065U
M1009_keeper #697 #fb696# b_51_6 Vdd pmos W=0.0975U L=0.065U
M1010_keeper #698 #fb696# b_51_6 GND nmos W=0.0975U L=0.065U
M1011_ #323 __i__t_50_6 b_50_6 Vdd pmos W=0.1625U L=0.065U
M1012_ #325 I_af_50_6 b_50_6 GND nmos W=0.0975U L=0.065U
M1013_keeper #700 #fb699# b_50_6 Vdd pmos W=0.0975U L=0.065U
M1014_keeper #701 #fb699# b_50_6 GND nmos W=0.0975U L=0.065U
M1015_ #35 I_af_51_6 #30 Vdd pmos W=0.1625U L=0.065U
M1016_ #30 I_at_50_6 #36 Vdd pmos W=0.1625U L=0.065U
M1017_ #34 I_af_52_6 #31 Vdd pmos W=0.1625U L=0.065U
M1018_ #31 I_at_51_6 #35 Vdd pmos W=0.1625U L=0.065U
M1019_ #33 I_af_53_6 #32 Vdd pmos W=0.1625U L=0.065U
M1020_ #32 I_at_52_6 #34 Vdd pmos W=0.1625U L=0.065U
M1021_ #59 b_54_6 __c_51_6 GND nmos W=0.0975U L=0.065U
M1022_ #62 __b_54_6 __c_51_6 GND nmos W=0.0975U L=0.065U
M1023_ #71 I_af_54_6 __c_51_6 Vdd pmos W=0.1625U L=0.065U
M1024_keeper #703 #fb702# __c_51_6 Vdd pmos W=0.0975U L=0.065U
M1025_keeper #704 #fb702# __c_51_6 GND nmos W=0.0975U L=0.065U
M1026_ #53 b_55_6 #38 GND nmos W=0.0975U L=0.065U
M1027_ #56 __b_55_6 #38 GND nmos W=0.0975U L=0.065U
M1028_ #38 I_at_54_6 #59 GND nmos W=0.0975U L=0.065U
M1029_ #38 I_af_54_6 #62 GND nmos W=0.0975U L=0.065U
M1030_ #47 b_56_6 #39 GND nmos W=0.0975U L=0.065U
M1031_ #50 __b_56_6 #39 GND nmos W=0.0975U L=0.065U
M1032_ #39 I_at_55_6 #53 GND nmos W=0.0975U L=0.065U
M1033_ #39 I_af_55_6 #56 GND nmos W=0.0975U L=0.065U
M1034_ #41 b_57_6 #40 GND nmos W=0.0975U L=0.065U
M1035_ #44 __b_57_6 #40 GND nmos W=0.0975U L=0.065U
M1036_ #40 I_at_56_6 #47 GND nmos W=0.0975U L=0.065U
M1037_ #40 I_af_56_6 #50 GND nmos W=0.0975U L=0.065U
M1038_ #345 __i__t_57_6 b_57_6 Vdd pmos W=0.1625U L=0.065U
M1039_ #347 I_af_57_6 b_57_6 GND nmos W=0.0975U L=0.065U
M1040_keeper #706 #fb705# b_57_6 Vdd pmos W=0.0975U L=0.065U
M1041_keeper #707 #fb705# b_57_6 GND nmos W=0.0975U L=0.065U
M1042_ #342 __i__t_56_6 b_56_6 Vdd pmos W=0.1625U L=0.065U
M1043_ #344 I_af_56_6 b_56_6 GND nmos W=0.0975U L=0.065U
M1044_keeper #709 #fb708# b_56_6 Vdd pmos W=0.0975U L=0.065U
M1045_keeper #710 #fb708# b_56_6 GND nmos W=0.0975U L=0.065U
M1046_ #339 __i__t_55_6 b_55_6 Vdd pmos W=0.1625U L=0.065U
M1047_ #341 I_af_55_6 b_55_6 GND nmos W=0.0975U L=0.065U
M1048_keeper #712 #fb711# b_55_6 Vdd pmos W=0.0975U L=0.065U
M1049_keeper #713 #fb711# b_55_6 GND nmos W=0.0975U L=0.065U
M1050_ #336 __i__t_54_6 b_54_6 Vdd pmos W=0.1625U L=0.065U
M1051_ #338 I_af_54_6 b_54_6 GND nmos W=0.0975U L=0.065U
M1052_keeper #715 #fb714# b_54_6 Vdd pmos W=0.0975U L=0.065U
M1053_keeper #716 #fb714# b_54_6 GND nmos W=0.0975U L=0.065U
M1054_ #70 I_af_55_6 #65 Vdd pmos W=0.1625U L=0.065U
M1055_ #65 I_at_54_6 #71 Vdd pmos W=0.1625U L=0.065U
M1056_ #69 I_af_56_6 #66 Vdd pmos W=0.1625U L=0.065U
M1057_ #66 I_at_55_6 #70 Vdd pmos W=0.1625U L=0.065U
M1058_ #68 I_af_57_6 #67 Vdd pmos W=0.1625U L=0.065U
M1059_ #67 I_at_56_6 #69 Vdd pmos W=0.1625U L=0.065U
M1060_ #94 b_58_6 __c_52_6 GND nmos W=0.0975U L=0.065U
M1061_ #97 __b_58_6 __c_52_6 GND nmos W=0.0975U L=0.065U
M1062_ #106 I_af_58_6 __c_52_6 Vdd pmos W=0.1625U L=0.065U
M1063_keeper #718 #fb717# __c_52_6 Vdd pmos W=0.0975U L=0.065U
M1064_keeper #719 #fb717# __c_52_6 GND nmos W=0.0975U L=0.065U
M1065_ #88 b_59_6 #73 GND nmos W=0.0975U L=0.065U
M1066_ #91 __b_59_6 #73 GND nmos W=0.0975U L=0.065U
M1067_ #73 I_at_58_6 #94 GND nmos W=0.0975U L=0.065U
M1068_ #73 I_af_58_6 #97 GND nmos W=0.0975U L=0.065U
M1069_ #82 b_510_6 #74 GND nmos W=0.0975U L=0.065U
M1070_ #85 __b_510_6 #74 GND nmos W=0.0975U L=0.065U
M1071_ #74 I_at_59_6 #88 GND nmos W=0.0975U L=0.065U
M1072_ #74 I_af_59_6 #91 GND nmos W=0.0975U L=0.065U
M1073_ #76 b_511_6 #75 GND nmos W=0.0975U L=0.065U
M1074_ #79 __b_511_6 #75 GND nmos W=0.0975U L=0.065U
M1075_ #75 I_at_510_6 #82 GND nmos W=0.0975U L=0.065U
M1076_ #75 I_af_510_6 #85 GND nmos W=0.0975U L=0.065U
M1077_ #357 __i__t_511_6 b_511_6 Vdd pmos W=0.1625U L=0.065U
M1078_ #359 I_af_511_6 b_511_6 GND nmos W=0.0975U L=0.065U
M1079_keeper #721 #fb720# b_511_6 Vdd pmos W=0.0975U L=0.065U
M1080_keeper #722 #fb720# b_511_6 GND nmos W=0.0975U L=0.065U
M1081_ #354 __i__t_510_6 b_510_6 Vdd pmos W=0.1625U L=0.065U
M1082_ #356 I_af_510_6 b_510_6 GND nmos W=0.0975U L=0.065U
M1083_keeper #724 #fb723# b_510_6 Vdd pmos W=0.0975U L=0.065U
M1084_keeper #725 #fb723# b_510_6 GND nmos W=0.0975U L=0.065U
M1085_ #351 __i__t_59_6 b_59_6 Vdd pmos W=0.1625U L=0.065U
M1086_ #353 I_af_59_6 b_59_6 GND nmos W=0.0975U L=0.065U
M1087_keeper #727 #fb726# b_59_6 Vdd pmos W=0.0975U L=0.065U
M1088_keeper #728 #fb726# b_59_6 GND nmos W=0.0975U L=0.065U
M1089_ #348 __i__t_58_6 b_58_6 Vdd pmos W=0.1625U L=0.065U
M1090_ #350 I_af_58_6 b_58_6 GND nmos W=0.0975U L=0.065U
M1091_keeper #730 #fb729# b_58_6 Vdd pmos W=0.0975U L=0.065U
M1092_keeper #731 #fb729# b_58_6 GND nmos W=0.0975U L=0.065U
M1093_ #105 I_af_59_6 #100 Vdd pmos W=0.1625U L=0.065U
M1094_ #100 I_at_58_6 #106 Vdd pmos W=0.1625U L=0.065U
M1095_ #104 I_af_510_6 #101 Vdd pmos W=0.1625U L=0.065U
M1096_ #101 I_at_59_6 #105 Vdd pmos W=0.1625U L=0.065U
M1097_ #103 I_af_511_6 #102 Vdd pmos W=0.1625U L=0.065U
M1098_ #102 I_at_510_6 #104 Vdd pmos W=0.1625U L=0.065U
M1099_ #129 b_512_6 __c_53_6 GND nmos W=0.0975U L=0.065U
M1100_ #132 __b_512_6 __c_53_6 GND nmos W=0.0975U L=0.065U
M1101_ #141 I_af_512_6 __c_53_6 Vdd pmos W=0.1625U L=0.065U
M1102_keeper #733 #fb732# __c_53_6 Vdd pmos W=0.0975U L=0.065U
M1103_keeper #734 #fb732# __c_53_6 GND nmos W=0.0975U L=0.065U
M1104_ #123 b_513_6 #108 GND nmos W=0.0975U L=0.065U
M1105_ #126 __b_513_6 #108 GND nmos W=0.0975U L=0.065U
M1106_ #108 I_at_512_6 #129 GND nmos W=0.0975U L=0.065U
M1107_ #108 I_af_512_6 #132 GND nmos W=0.0975U L=0.065U
M1108_ #117 b_514_6 #109 GND nmos W=0.0975U L=0.065U
M1109_ #120 __b_514_6 #109 GND nmos W=0.0975U L=0.065U
M1110_ #109 I_at_513_6 #123 GND nmos W=0.0975U L=0.065U
M1111_ #109 I_af_513_6 #126 GND nmos W=0.0975U L=0.065U
M1112_ #111 b_515_6 #110 GND nmos W=0.0975U L=0.065U
M1113_ #114 __b_515_6 #110 GND nmos W=0.0975U L=0.065U
M1114_ #110 I_at_514_6 #117 GND nmos W=0.0975U L=0.065U
M1115_ #110 I_af_514_6 #120 GND nmos W=0.0975U L=0.065U
M1116_ #369 __i__t_515_6 b_515_6 Vdd pmos W=0.1625U L=0.065U
M1117_ #371 I_af_515_6 b_515_6 GND nmos W=0.0975U L=0.065U
M1118_keeper #736 #fb735# b_515_6 Vdd pmos W=0.0975U L=0.065U
M1119_keeper #737 #fb735# b_515_6 GND nmos W=0.0975U L=0.065U
M1120_ #366 __i__t_514_6 b_514_6 Vdd pmos W=0.1625U L=0.065U
M1121_ #368 I_af_514_6 b_514_6 GND nmos W=0.0975U L=0.065U
M1122_keeper #739 #fb738# b_514_6 Vdd pmos W=0.0975U L=0.065U
M1123_keeper #740 #fb738# b_514_6 GND nmos W=0.0975U L=0.065U
M1124_ #363 __i__t_513_6 b_513_6 Vdd pmos W=0.1625U L=0.065U
M1125_ #365 I_af_513_6 b_513_6 GND nmos W=0.0975U L=0.065U
M1126_keeper #742 #fb741# b_513_6 Vdd pmos W=0.0975U L=0.065U
M1127_keeper #743 #fb741# b_513_6 GND nmos W=0.0975U L=0.065U
M1128_ #360 __i__t_512_6 b_512_6 Vdd pmos W=0.1625U L=0.065U
M1129_ #362 I_af_512_6 b_512_6 GND nmos W=0.0975U L=0.065U
M1130_keeper #745 #fb744# b_512_6 Vdd pmos W=0.0975U L=0.065U
M1131_keeper #746 #fb744# b_512_6 GND nmos W=0.0975U L=0.065U
M1132_ #140 I_af_513_6 #135 Vdd pmos W=0.1625U L=0.065U
M1133_ #135 I_at_512_6 #141 Vdd pmos W=0.1625U L=0.065U
M1134_ #139 I_af_514_6 #136 Vdd pmos W=0.1625U L=0.065U
M1135_ #136 I_at_513_6 #140 Vdd pmos W=0.1625U L=0.065U
M1136_ #138 I_af_515_6 #137 Vdd pmos W=0.1625U L=0.065U
M1137_ #137 I_at_514_6 #139 Vdd pmos W=0.1625U L=0.065U
M1138_ #164 b_516_6 __c_54_6 GND nmos W=0.0975U L=0.065U
M1139_ #167 __b_516_6 __c_54_6 GND nmos W=0.0975U L=0.065U
M1140_ #176 I_af_516_6 __c_54_6 Vdd pmos W=0.1625U L=0.065U
M1141_keeper #748 #fb747# __c_54_6 Vdd pmos W=0.0975U L=0.065U
M1142_keeper #749 #fb747# __c_54_6 GND nmos W=0.0975U L=0.065U
M1143_ #158 b_517_6 #143 GND nmos W=0.0975U L=0.065U
M1144_ #161 __b_517_6 #143 GND nmos W=0.0975U L=0.065U
M1145_ #143 I_at_516_6 #164 GND nmos W=0.0975U L=0.065U
M1146_ #143 I_af_516_6 #167 GND nmos W=0.0975U L=0.065U
M1147_ #152 b_518_6 #144 GND nmos W=0.0975U L=0.065U
M1148_ #155 __b_518_6 #144 GND nmos W=0.0975U L=0.065U
M1149_ #144 I_at_517_6 #158 GND nmos W=0.0975U L=0.065U
M1150_ #144 I_af_517_6 #161 GND nmos W=0.0975U L=0.065U
M1151_ #146 b_519_6 #145 GND nmos W=0.0975U L=0.065U
M1152_ #149 __b_519_6 #145 GND nmos W=0.0975U L=0.065U
M1153_ #145 I_at_518_6 #152 GND nmos W=0.0975U L=0.065U
M1154_ #145 I_af_518_6 #155 GND nmos W=0.0975U L=0.065U
M1155_ #381 __i__t_519_6 b_519_6 Vdd pmos W=0.1625U L=0.065U
M1156_ #383 I_af_519_6 b_519_6 GND nmos W=0.0975U L=0.065U
M1157_keeper #751 #fb750# b_519_6 Vdd pmos W=0.0975U L=0.065U
M1158_keeper #752 #fb750# b_519_6 GND nmos W=0.0975U L=0.065U
M1159_ #378 __i__t_518_6 b_518_6 Vdd pmos W=0.1625U L=0.065U
M1160_ #380 I_af_518_6 b_518_6 GND nmos W=0.0975U L=0.065U
M1161_keeper #754 #fb753# b_518_6 Vdd pmos W=0.0975U L=0.065U
M1162_keeper #755 #fb753# b_518_6 GND nmos W=0.0975U L=0.065U
M1163_ #375 __i__t_517_6 b_517_6 Vdd pmos W=0.1625U L=0.065U
M1164_ #377 I_af_517_6 b_517_6 GND nmos W=0.0975U L=0.065U
M1165_keeper #757 #fb756# b_517_6 Vdd pmos W=0.0975U L=0.065U
M1166_keeper #758 #fb756# b_517_6 GND nmos W=0.0975U L=0.065U
M1167_ #372 __i__t_516_6 b_516_6 Vdd pmos W=0.1625U L=0.065U
M1168_ #374 I_af_516_6 b_516_6 GND nmos W=0.0975U L=0.065U
M1169_keeper #760 #fb759# b_516_6 Vdd pmos W=0.0975U L=0.065U
M1170_keeper #761 #fb759# b_516_6 GND nmos W=0.0975U L=0.065U
M1171_ #175 I_af_517_6 #170 Vdd pmos W=0.1625U L=0.065U
M1172_ #170 I_at_516_6 #176 Vdd pmos W=0.1625U L=0.065U
M1173_ #174 I_af_518_6 #171 Vdd pmos W=0.1625U L=0.065U
M1174_ #171 I_at_517_6 #175 Vdd pmos W=0.1625U L=0.065U
M1175_ #173 I_af_519_6 #172 Vdd pmos W=0.1625U L=0.065U
M1176_ #172 I_at_518_6 #174 Vdd pmos W=0.1625U L=0.065U
M1177_ #199 b_520_6 __c_55_6 GND nmos W=0.0975U L=0.065U
M1178_ #202 __b_520_6 __c_55_6 GND nmos W=0.0975U L=0.065U
M1179_ #211 I_af_520_6 __c_55_6 Vdd pmos W=0.1625U L=0.065U
M1180_keeper #763 #fb762# __c_55_6 Vdd pmos W=0.0975U L=0.065U
M1181_keeper #764 #fb762# __c_55_6 GND nmos W=0.0975U L=0.065U
M1182_ #193 b_521_6 #178 GND nmos W=0.0975U L=0.065U
M1183_ #196 __b_521_6 #178 GND nmos W=0.0975U L=0.065U
M1184_ #178 I_at_520_6 #199 GND nmos W=0.0975U L=0.065U
M1185_ #178 I_af_520_6 #202 GND nmos W=0.0975U L=0.065U
M1186_ #187 b_522_6 #179 GND nmos W=0.0975U L=0.065U
M1187_ #190 __b_522_6 #179 GND nmos W=0.0975U L=0.065U
M1188_ #179 I_at_521_6 #193 GND nmos W=0.0975U L=0.065U
M1189_ #179 I_af_521_6 #196 GND nmos W=0.0975U L=0.065U
M1190_ #181 b_523_6 #180 GND nmos W=0.0975U L=0.065U
M1191_ #184 __b_523_6 #180 GND nmos W=0.0975U L=0.065U
M1192_ #180 I_at_522_6 #187 GND nmos W=0.0975U L=0.065U
M1193_ #180 I_af_522_6 #190 GND nmos W=0.0975U L=0.065U
M1194_ #393 __i__t_523_6 b_523_6 Vdd pmos W=0.1625U L=0.065U
M1195_ #395 I_af_523_6 b_523_6 GND nmos W=0.0975U L=0.065U
M1196_keeper #766 #fb765# b_523_6 Vdd pmos W=0.0975U L=0.065U
M1197_keeper #767 #fb765# b_523_6 GND nmos W=0.0975U L=0.065U
M1198_ #390 __i__t_522_6 b_522_6 Vdd pmos W=0.1625U L=0.065U
M1199_ #392 I_af_522_6 b_522_6 GND nmos W=0.0975U L=0.065U
M1200_keeper #769 #fb768# b_522_6 Vdd pmos W=0.0975U L=0.065U
M1201_keeper #770 #fb768# b_522_6 GND nmos W=0.0975U L=0.065U
M1202_ #387 __i__t_521_6 b_521_6 Vdd pmos W=0.1625U L=0.065U
M1203_ #389 I_af_521_6 b_521_6 GND nmos W=0.0975U L=0.065U
M1204_keeper #772 #fb771# b_521_6 Vdd pmos W=0.0975U L=0.065U
M1205_keeper #773 #fb771# b_521_6 GND nmos W=0.0975U L=0.065U
M1206_ #384 __i__t_520_6 b_520_6 Vdd pmos W=0.1625U L=0.065U
M1207_ #386 I_af_520_6 b_520_6 GND nmos W=0.0975U L=0.065U
M1208_keeper #775 #fb774# b_520_6 Vdd pmos W=0.0975U L=0.065U
M1209_keeper #776 #fb774# b_520_6 GND nmos W=0.0975U L=0.065U
M1210_ #210 I_af_521_6 #205 Vdd pmos W=0.1625U L=0.065U
M1211_ #205 I_at_520_6 #211 Vdd pmos W=0.1625U L=0.065U
M1212_ #209 I_af_522_6 #206 Vdd pmos W=0.1625U L=0.065U
M1213_ #206 I_at_521_6 #210 Vdd pmos W=0.1625U L=0.065U
M1214_ #208 I_af_523_6 #207 Vdd pmos W=0.1625U L=0.065U
M1215_ #207 I_at_522_6 #209 Vdd pmos W=0.1625U L=0.065U
M1216_ #234 b_524_6 __c_56_6 GND nmos W=0.0975U L=0.065U
M1217_ #237 __b_524_6 __c_56_6 GND nmos W=0.0975U L=0.065U
M1218_ #246 I_af_524_6 __c_56_6 Vdd pmos W=0.1625U L=0.065U
M1219_keeper #778 #fb777# __c_56_6 Vdd pmos W=0.0975U L=0.065U
M1220_keeper #779 #fb777# __c_56_6 GND nmos W=0.0975U L=0.065U
M1221_ #228 b_525_6 #213 GND nmos W=0.0975U L=0.065U
M1222_ #231 __b_525_6 #213 GND nmos W=0.0975U L=0.065U
M1223_ #213 I_at_524_6 #234 GND nmos W=0.0975U L=0.065U
M1224_ #213 I_af_524_6 #237 GND nmos W=0.0975U L=0.065U
M1225_ #222 b_526_6 #214 GND nmos W=0.0975U L=0.065U
M1226_ #225 __b_526_6 #214 GND nmos W=0.0975U L=0.065U
M1227_ #214 I_at_525_6 #228 GND nmos W=0.0975U L=0.065U
M1228_ #214 I_af_525_6 #231 GND nmos W=0.0975U L=0.065U
M1229_ #216 b_527_6 #215 GND nmos W=0.0975U L=0.065U
M1230_ #219 __b_527_6 #215 GND nmos W=0.0975U L=0.065U
M1231_ #215 I_at_526_6 #222 GND nmos W=0.0975U L=0.065U
M1232_ #215 I_af_526_6 #225 GND nmos W=0.0975U L=0.065U
M1233_ #405 __i__t_527_6 b_527_6 Vdd pmos W=0.1625U L=0.065U
M1234_ #407 I_af_527_6 b_527_6 GND nmos W=0.0975U L=0.065U
M1235_keeper #781 #fb780# b_527_6 Vdd pmos W=0.0975U L=0.065U
M1236_keeper #782 #fb780# b_527_6 GND nmos W=0.0975U L=0.065U
M1237_ #402 __i__t_526_6 b_526_6 Vdd pmos W=0.1625U L=0.065U
M1238_ #404 I_af_526_6 b_526_6 GND nmos W=0.0975U L=0.065U
M1239_keeper #784 #fb783# b_526_6 Vdd pmos W=0.0975U L=0.065U
M1240_keeper #785 #fb783# b_526_6 GND nmos W=0.0975U L=0.065U
M1241_ #399 __i__t_525_6 b_525_6 Vdd pmos W=0.1625U L=0.065U
M1242_ #401 I_af_525_6 b_525_6 GND nmos W=0.0975U L=0.065U
M1243_keeper #787 #fb786# b_525_6 Vdd pmos W=0.0975U L=0.065U
M1244_keeper #788 #fb786# b_525_6 GND nmos W=0.0975U L=0.065U
M1245_ #396 __i__t_524_6 b_524_6 Vdd pmos W=0.1625U L=0.065U
M1246_ #398 I_af_524_6 b_524_6 GND nmos W=0.0975U L=0.065U
M1247_keeper #790 #fb789# b_524_6 Vdd pmos W=0.0975U L=0.065U
M1248_keeper #791 #fb789# b_524_6 GND nmos W=0.0975U L=0.065U
M1249_ #245 I_af_525_6 #240 Vdd pmos W=0.1625U L=0.065U
M1250_ #240 I_at_524_6 #246 Vdd pmos W=0.1625U L=0.065U
M1251_ #244 I_af_526_6 #241 Vdd pmos W=0.1625U L=0.065U
M1252_ #241 I_at_525_6 #245 Vdd pmos W=0.1625U L=0.065U
M1253_ #243 I_af_527_6 #242 Vdd pmos W=0.1625U L=0.065U
M1254_ #242 I_at_526_6 #244 Vdd pmos W=0.1625U L=0.065U
M1255_ #269 b_528_6 __c_57_6 GND nmos W=0.0975U L=0.065U
M1256_ #272 __b_528_6 __c_57_6 GND nmos W=0.0975U L=0.065U
M1257_ #281 I_af_528_6 __c_57_6 Vdd pmos W=0.1625U L=0.065U
M1258_keeper #793 #fb792# __c_57_6 Vdd pmos W=0.0975U L=0.065U
M1259_keeper #794 #fb792# __c_57_6 GND nmos W=0.0975U L=0.065U
M1260_ #263 b_529_6 #248 GND nmos W=0.0975U L=0.065U
M1261_ #266 __b_529_6 #248 GND nmos W=0.0975U L=0.065U
M1262_ #248 I_at_528_6 #269 GND nmos W=0.0975U L=0.065U
M1263_ #248 I_af_528_6 #272 GND nmos W=0.0975U L=0.065U
M1264_ #257 b_530_6 #249 GND nmos W=0.0975U L=0.065U
M1265_ #260 __b_530_6 #249 GND nmos W=0.0975U L=0.065U
M1266_ #249 I_at_529_6 #263 GND nmos W=0.0975U L=0.065U
M1267_ #249 I_af_529_6 #266 GND nmos W=0.0975U L=0.065U
M1268_ #251 b_531_6 #250 GND nmos W=0.0975U L=0.065U
M1269_ #254 __b_531_6 #250 GND nmos W=0.0975U L=0.065U
M1270_ #250 I_at_530_6 #257 GND nmos W=0.0975U L=0.065U
M1271_ #250 I_af_530_6 #260 GND nmos W=0.0975U L=0.065U
M1272_ #417 __i__t_531_6 b_531_6 Vdd pmos W=0.1625U L=0.065U
M1273_ #419 I_af_531_6 b_531_6 GND nmos W=0.0975U L=0.065U
M1274_keeper #796 #fb795# b_531_6 Vdd pmos W=0.0975U L=0.065U
M1275_keeper #797 #fb795# b_531_6 GND nmos W=0.0975U L=0.065U
M1276_ #414 __i__t_530_6 b_530_6 Vdd pmos W=0.1625U L=0.065U
M1277_ #416 I_af_530_6 b_530_6 GND nmos W=0.0975U L=0.065U
M1278_keeper #799 #fb798# b_530_6 Vdd pmos W=0.0975U L=0.065U
M1279_keeper #800 #fb798# b_530_6 GND nmos W=0.0975U L=0.065U
M1280_ #411 __i__t_529_6 b_529_6 Vdd pmos W=0.1625U L=0.065U
M1281_ #413 I_af_529_6 b_529_6 GND nmos W=0.0975U L=0.065U
M1282_keeper #802 #fb801# b_529_6 Vdd pmos W=0.0975U L=0.065U
M1283_keeper #803 #fb801# b_529_6 GND nmos W=0.0975U L=0.065U
M1284_ #408 __i__t_528_6 b_528_6 Vdd pmos W=0.1625U L=0.065U
M1285_ #410 I_af_528_6 b_528_6 GND nmos W=0.0975U L=0.065U
M1286_keeper #805 #fb804# b_528_6 Vdd pmos W=0.0975U L=0.065U
M1287_keeper #806 #fb804# b_528_6 GND nmos W=0.0975U L=0.065U
M1288_ #280 I_af_529_6 #275 Vdd pmos W=0.1625U L=0.065U
M1289_ #275 I_at_528_6 #281 Vdd pmos W=0.1625U L=0.065U
M1290_ #279 I_af_530_6 #276 Vdd pmos W=0.1625U L=0.065U
M1291_ #276 I_at_529_6 #280 Vdd pmos W=0.1625U L=0.065U
M1292_ #278 I_af_531_6 #277 Vdd pmos W=0.1625U L=0.065U
M1293_ #277 I_at_530_6 #279 Vdd pmos W=0.1625U L=0.065U
M1294_ #283 __c_50_6 d_50_6 Vdd pmos W=0.1625U L=0.065U
M1295_ #284 __c_50_6 d_50_6 GND nmos W=0.0975U L=0.065U
M1296_keeper #808 #fb807# d_50_6 Vdd pmos W=0.0975U L=0.065U
M1297_keeper #809 #fb807# d_50_6 GND nmos W=0.0975U L=0.065U
M1298_ #286 __c_52_6 d_51_6 Vdd pmos W=0.1625U L=0.065U
M1299_ #287 __c_52_6 d_51_6 GND nmos W=0.0975U L=0.065U
M1300_keeper #811 #fb810# d_51_6 Vdd pmos W=0.0975U L=0.065U
M1301_keeper #812 #fb810# d_51_6 GND nmos W=0.0975U L=0.065U
M1302_ #289 __c_54_6 d_52_6 Vdd pmos W=0.1625U L=0.065U
M1303_ #290 __c_54_6 d_52_6 GND nmos W=0.0975U L=0.065U
M1304_keeper #814 #fb813# d_52_6 Vdd pmos W=0.0975U L=0.065U
M1305_keeper #815 #fb813# d_52_6 GND nmos W=0.0975U L=0.065U
M1306_ #292 __c_56_6 d_53_6 Vdd pmos W=0.1625U L=0.065U
M1307_ #293 __c_56_6 d_53_6 GND nmos W=0.0975U L=0.065U
M1308_keeper #817 #fb816# d_53_6 Vdd pmos W=0.0975U L=0.065U
M1309_keeper #818 #fb816# d_53_6 GND nmos W=0.0975U L=0.065U
M1310_ #295 d_50_6 __e_50_6 GND nmos W=0.0975U L=0.065U
M1311_ #296 d_50_6 __e_50_6 Vdd pmos W=0.1625U L=0.065U
M1312_keeper #820 #fb819# __e_50_6 Vdd pmos W=0.0975U L=0.065U
M1313_keeper #821 #fb819# __e_50_6 GND nmos W=0.0975U L=0.065U
M1314_ #298 d_52_6 __e_51_6 GND nmos W=0.0975U L=0.065U
M1315_ #299 d_52_6 __e_51_6 Vdd pmos W=0.1625U L=0.065U
M1316_keeper #823 #fb822# __e_51_6 Vdd pmos W=0.0975U L=0.065U
M1317_keeper #824 #fb822# __e_51_6 GND nmos W=0.0975U L=0.065U
M1318_ #301 __e_50_6 c Vdd pmos W=0.1625U L=0.065U
M1319_ #302 __e_50_6 c GND nmos W=0.0975U L=0.065U
M1320_keeper #826 #fb825# c Vdd pmos W=0.0975U L=0.065U
M1321_keeper #827 #fb825# c GND nmos W=0.0975U L=0.065U
M1322_ #304 u1 __v Vdd pmos W=0.1625U L=0.065U
M1323_keeper #829 #fb828# __v Vdd pmos W=0.0975U L=0.065U
M1324_keeper #830 #fb828# __v GND nmos W=0.0975U L=0.065U
M1325_ #305 u2 #304 Vdd pmos W=0.1625U L=0.065U
M1326_ #306 u3 #305 Vdd pmos W=0.1625U L=0.065U
M1327_ #307 u4 #306 Vdd pmos W=0.1625U L=0.065U
M1328_ #308 u5 #307 Vdd pmos W=0.1625U L=0.065U
M1329_ #309 u6 #308 Vdd pmos W=0.1625U L=0.065U
M1330_ #310 u7 #309 Vdd pmos W=0.1625U L=0.065U
M1331_ #320 __o1a __i__a GND nmos W=0.0975U L=0.065U
M1332_keeper #832 #fb831# __i__a Vdd pmos W=0.0975U L=0.065U
M1333_keeper #833 #fb831# __i__a GND nmos W=0.0975U L=0.065U
M1334_keeper #835 #fb834# __u1 Vdd pmos W=0.0975U L=0.065U
M1335_keeper #836 #fb834# __u1 GND nmos W=0.0975U L=0.065U
M1336_ #423 b_54_6 __o1t_50_6 GND nmos W=0.0975U L=0.065U
M1337_keeper #838 #fb837# __o1t_50_6 Vdd pmos W=0.0975U L=0.065U
M1338_keeper #839 #fb837# __o1t_50_6 GND nmos W=0.0975U L=0.065U
M1339_ #424 __i__a #423 GND nmos W=0.0975U L=0.065U
M1340_ #425 v #424 GND nmos W=0.0975U L=0.065U
M1341_ #427 b_54_6 O1_af_50_6 Vdd pmos W=0.1625U L=0.065U
M1342_keeper #841 #fb840# O1_af_50_6 Vdd pmos W=0.0975U L=0.065U
M1343_keeper #842 #fb840# O1_af_50_6 GND nmos W=0.0975U L=0.065U
M1344_ #428 I_aa #427 Vdd pmos W=0.1625U L=0.065U
M1345_ #429 __v #428 Vdd pmos W=0.1625U L=0.065U
M1346_ #432 b_55_6 __o1t_51_6 GND nmos W=0.0975U L=0.065U
M1347_keeper #844 #fb843# __o1t_51_6 Vdd pmos W=0.0975U L=0.065U
M1348_keeper #845 #fb843# __o1t_51_6 GND nmos W=0.0975U L=0.065U
M1349_ #433 __i__a #432 GND nmos W=0.0975U L=0.065U
M1350_ #434 v #433 GND nmos W=0.0975U L=0.065U
M1351_ #436 b_55_6 O1_af_51_6 Vdd pmos W=0.1625U L=0.065U
M1352_keeper #847 #fb846# O1_af_51_6 Vdd pmos W=0.0975U L=0.065U
M1353_keeper #848 #fb846# O1_af_51_6 GND nmos W=0.0975U L=0.065U
M1354_ #437 I_aa #436 Vdd pmos W=0.1625U L=0.065U
M1355_ #438 __v #437 Vdd pmos W=0.1625U L=0.065U
M1356_ #440 b_56_6 __o1t_52_6 GND nmos W=0.0975U L=0.065U
M1357_keeper #850 #fb849# __o1t_52_6 Vdd pmos W=0.0975U L=0.065U
M1358_keeper #851 #fb849# __o1t_52_6 GND nmos W=0.0975U L=0.065U
M1359_ #441 __i__a #440 GND nmos W=0.0975U L=0.065U
M1360_ #442 v #441 GND nmos W=0.0975U L=0.065U
M1361_ #444 b_56_6 O1_af_52_6 Vdd pmos W=0.1625U L=0.065U
M1362_keeper #853 #fb852# O1_af_52_6 Vdd pmos W=0.0975U L=0.065U
M1363_keeper #854 #fb852# O1_af_52_6 GND nmos W=0.0975U L=0.065U
M1364_ #445 I_aa #444 Vdd pmos W=0.1625U L=0.065U
M1365_ #446 __v #445 Vdd pmos W=0.1625U L=0.065U
M1366_ #448 b_57_6 __o1t_53_6 GND nmos W=0.0975U L=0.065U
M1367_keeper #856 #fb855# __o1t_53_6 Vdd pmos W=0.0975U L=0.065U
M1368_keeper #857 #fb855# __o1t_53_6 GND nmos W=0.0975U L=0.065U
M1369_ #449 __i__a #448 GND nmos W=0.0975U L=0.065U
M1370_ #450 v #449 GND nmos W=0.0975U L=0.065U
M1371_ #452 b_57_6 O1_af_53_6 Vdd pmos W=0.1625U L=0.065U
M1372_keeper #859 #fb858# O1_af_53_6 Vdd pmos W=0.0975U L=0.065U
M1373_keeper #860 #fb858# O1_af_53_6 GND nmos W=0.0975U L=0.065U
M1374_ #453 I_aa #452 Vdd pmos W=0.1625U L=0.065U
M1375_ #454 __v #453 Vdd pmos W=0.1625U L=0.065U
M1376_keeper #862 #fb861# __u2 Vdd pmos W=0.0975U L=0.065U
M1377_keeper #863 #fb861# __u2 GND nmos W=0.0975U L=0.065U
M1378_ #458 b_58_6 __o2t_50_6 GND nmos W=0.0975U L=0.065U
M1379_keeper #865 #fb864# __o2t_50_6 Vdd pmos W=0.0975U L=0.065U
M1380_keeper #866 #fb864# __o2t_50_6 GND nmos W=0.0975U L=0.065U
M1381_ #459 __i__a #458 GND nmos W=0.0975U L=0.065U
M1382_ #460 v #459 GND nmos W=0.0975U L=0.065U
M1383_ #462 b_58_6 O2_af_50_6 Vdd pmos W=0.1625U L=0.065U
M1384_keeper #868 #fb867# O2_af_50_6 Vdd pmos W=0.0975U L=0.065U
M1385_keeper #869 #fb867# O2_af_50_6 GND nmos W=0.0975U L=0.065U
M1386_ #463 I_aa #462 Vdd pmos W=0.1625U L=0.065U
M1387_ #464 __v #463 Vdd pmos W=0.1625U L=0.065U
M1388_ #466 b_59_6 __o2t_51_6 GND nmos W=0.0975U L=0.065U
M1389_keeper #871 #fb870# __o2t_51_6 Vdd pmos W=0.0975U L=0.065U
M1390_keeper #872 #fb870# __o2t_51_6 GND nmos W=0.0975U L=0.065U
M1391_ #467 __i__a #466 GND nmos W=0.0975U L=0.065U
M1392_ #468 v #467 GND nmos W=0.0975U L=0.065U
M1393_ #470 b_59_6 O2_af_51_6 Vdd pmos W=0.1625U L=0.065U
M1394_keeper #874 #fb873# O2_af_51_6 Vdd pmos W=0.0975U L=0.065U
M1395_keeper #875 #fb873# O2_af_51_6 GND nmos W=0.0975U L=0.065U
M1396_ #471 I_aa #470 Vdd pmos W=0.1625U L=0.065U
M1397_ #472 __v #471 Vdd pmos W=0.1625U L=0.065U
M1398_ #474 b_510_6 __o2t_52_6 GND nmos W=0.0975U L=0.065U
M1399_keeper #877 #fb876# __o2t_52_6 Vdd pmos W=0.0975U L=0.065U
M1400_keeper #878 #fb876# __o2t_52_6 GND nmos W=0.0975U L=0.065U
M1401_ #475 __i__a #474 GND nmos W=0.0975U L=0.065U
M1402_ #476 v #475 GND nmos W=0.0975U L=0.065U
M1403_ #478 b_510_6 O2_af_52_6 Vdd pmos W=0.1625U L=0.065U
M1404_keeper #880 #fb879# O2_af_52_6 Vdd pmos W=0.0975U L=0.065U
M1405_keeper #881 #fb879# O2_af_52_6 GND nmos W=0.0975U L=0.065U
M1406_ #479 I_aa #478 Vdd pmos W=0.1625U L=0.065U
M1407_ #480 __v #479 Vdd pmos W=0.1625U L=0.065U
M1408_ #482 b_511_6 __o2t_53_6 GND nmos W=0.0975U L=0.065U
M1409_keeper #883 #fb882# __o2t_53_6 Vdd pmos W=0.0975U L=0.065U
M1410_keeper #884 #fb882# __o2t_53_6 GND nmos W=0.0975U L=0.065U
M1411_ #483 __i__a #482 GND nmos W=0.0975U L=0.065U
M1412_ #484 v #483 GND nmos W=0.0975U L=0.065U
M1413_ #486 b_511_6 O2_af_53_6 Vdd pmos W=0.1625U L=0.065U
M1414_keeper #886 #fb885# O2_af_53_6 Vdd pmos W=0.0975U L=0.065U
M1415_keeper #887 #fb885# O2_af_53_6 GND nmos W=0.0975U L=0.065U
M1416_ #487 I_aa #486 Vdd pmos W=0.1625U L=0.065U
M1417_ #488 __v #487 Vdd pmos W=0.1625U L=0.065U
M1418_keeper #889 #fb888# __u3 Vdd pmos W=0.0975U L=0.065U
M1419_keeper #890 #fb888# __u3 GND nmos W=0.0975U L=0.065U
M1420_ #492 b_512_6 __o3t_50_6 GND nmos W=0.0975U L=0.065U
M1421_keeper #892 #fb891# __o3t_50_6 Vdd pmos W=0.0975U L=0.065U
M1422_keeper #893 #fb891# __o3t_50_6 GND nmos W=0.0975U L=0.065U
M1423_ #493 __i__a #492 GND nmos W=0.0975U L=0.065U
M1424_ #494 v #493 GND nmos W=0.0975U L=0.065U
M1425_ #496 b_512_6 O3_af_50_6 Vdd pmos W=0.1625U L=0.065U
M1426_keeper #895 #fb894# O3_af_50_6 Vdd pmos W=0.0975U L=0.065U
M1427_keeper #896 #fb894# O3_af_50_6 GND nmos W=0.0975U L=0.065U
M1428_ #497 I_aa #496 Vdd pmos W=0.1625U L=0.065U
M1429_ #498 __v #497 Vdd pmos W=0.1625U L=0.065U
M1430_ #500 b_513_6 __o3t_51_6 GND nmos W=0.0975U L=0.065U
M1431_keeper #898 #fb897# __o3t_51_6 Vdd pmos W=0.0975U L=0.065U
M1432_keeper #899 #fb897# __o3t_51_6 GND nmos W=0.0975U L=0.065U
M1433_ #501 __i__a #500 GND nmos W=0.0975U L=0.065U
M1434_ #502 v #501 GND nmos W=0.0975U L=0.065U
M1435_ #504 b_513_6 O3_af_51_6 Vdd pmos W=0.1625U L=0.065U
M1436_keeper #901 #fb900# O3_af_51_6 Vdd pmos W=0.0975U L=0.065U
M1437_keeper #902 #fb900# O3_af_51_6 GND nmos W=0.0975U L=0.065U
M1438_ #505 I_aa #504 Vdd pmos W=0.1625U L=0.065U
M1439_ #506 __v #505 Vdd pmos W=0.1625U L=0.065U
M1440_ #508 b_514_6 __o3t_52_6 GND nmos W=0.0975U L=0.065U
M1441_keeper #904 #fb903# __o3t_52_6 Vdd pmos W=0.0975U L=0.065U
M1442_keeper #905 #fb903# __o3t_52_6 GND nmos W=0.0975U L=0.065U
M1443_ #509 __i__a #508 GND nmos W=0.0975U L=0.065U
M1444_ #510 v #509 GND nmos W=0.0975U L=0.065U
M1445_ #512 b_514_6 O3_af_52_6 Vdd pmos W=0.1625U L=0.065U
M1446_keeper #907 #fb906# O3_af_52_6 Vdd pmos W=0.0975U L=0.065U
M1447_keeper #908 #fb906# O3_af_52_6 GND nmos W=0.0975U L=0.065U
M1448_ #513 I_aa #512 Vdd pmos W=0.1625U L=0.065U
M1449_ #514 __v #513 Vdd pmos W=0.1625U L=0.065U
M1450_ #516 b_515_6 __o3t_53_6 GND nmos W=0.0975U L=0.065U
M1451_keeper #910 #fb909# __o3t_53_6 Vdd pmos W=0.0975U L=0.065U
M1452_keeper #911 #fb909# __o3t_53_6 GND nmos W=0.0975U L=0.065U
M1453_ #517 __i__a #516 GND nmos W=0.0975U L=0.065U
M1454_ #518 v #517 GND nmos W=0.0975U L=0.065U
M1455_ #520 b_515_6 O3_af_53_6 Vdd pmos W=0.1625U L=0.065U
M1456_keeper #913 #fb912# O3_af_53_6 Vdd pmos W=0.0975U L=0.065U
M1457_keeper #914 #fb912# O3_af_53_6 GND nmos W=0.0975U L=0.065U
M1458_ #521 I_aa #520 Vdd pmos W=0.1625U L=0.065U
M1459_ #522 __v #521 Vdd pmos W=0.1625U L=0.065U
M1460_keeper #916 #fb915# __u4 Vdd pmos W=0.0975U L=0.065U
M1461_keeper #917 #fb915# __u4 GND nmos W=0.0975U L=0.065U
M1462_ #526 b_516_6 __o4t_50_6 GND nmos W=0.0975U L=0.065U
M1463_keeper #919 #fb918# __o4t_50_6 Vdd pmos W=0.0975U L=0.065U
M1464_keeper #920 #fb918# __o4t_50_6 GND nmos W=0.0975U L=0.065U
M1465_ #527 __i__a #526 GND nmos W=0.0975U L=0.065U
M1466_ #528 v #527 GND nmos W=0.0975U L=0.065U
M1467_ #530 b_516_6 O4_af_50_6 Vdd pmos W=0.1625U L=0.065U
M1468_keeper #922 #fb921# O4_af_50_6 Vdd pmos W=0.0975U L=0.065U
M1469_keeper #923 #fb921# O4_af_50_6 GND nmos W=0.0975U L=0.065U
M1470_ #531 I_aa #530 Vdd pmos W=0.1625U L=0.065U
M1471_ #532 __v #531 Vdd pmos W=0.1625U L=0.065U
M1472_ #534 b_517_6 __o4t_51_6 GND nmos W=0.0975U L=0.065U
M1473_keeper #925 #fb924# __o4t_51_6 Vdd pmos W=0.0975U L=0.065U
M1474_keeper #926 #fb924# __o4t_51_6 GND nmos W=0.0975U L=0.065U
M1475_ #535 __i__a #534 GND nmos W=0.0975U L=0.065U
M1476_ #536 v #535 GND nmos W=0.0975U L=0.065U
M1477_ #538 b_517_6 O4_af_51_6 Vdd pmos W=0.1625U L=0.065U
M1478_keeper #928 #fb927# O4_af_51_6 Vdd pmos W=0.0975U L=0.065U
M1479_keeper #929 #fb927# O4_af_51_6 GND nmos W=0.0975U L=0.065U
M1480_ #539 I_aa #538 Vdd pmos W=0.1625U L=0.065U
M1481_ #540 __v #539 Vdd pmos W=0.1625U L=0.065U
M1482_ #542 b_518_6 __o4t_52_6 GND nmos W=0.0975U L=0.065U
M1483_keeper #931 #fb930# __o4t_52_6 Vdd pmos W=0.0975U L=0.065U
M1484_keeper #932 #fb930# __o4t_52_6 GND nmos W=0.0975U L=0.065U
M1485_ #543 __i__a #542 GND nmos W=0.0975U L=0.065U
M1486_ #544 v #543 GND nmos W=0.0975U L=0.065U
M1487_ #546 b_518_6 O4_af_52_6 Vdd pmos W=0.1625U L=0.065U
M1488_keeper #934 #fb933# O4_af_52_6 Vdd pmos W=0.0975U L=0.065U
M1489_keeper #935 #fb933# O4_af_52_6 GND nmos W=0.0975U L=0.065U
M1490_ #547 I_aa #546 Vdd pmos W=0.1625U L=0.065U
M1491_ #548 __v #547 Vdd pmos W=0.1625U L=0.065U
M1492_ #550 b_519_6 __o4t_53_6 GND nmos W=0.0975U L=0.065U
M1493_keeper #937 #fb936# __o4t_53_6 Vdd pmos W=0.0975U L=0.065U
M1494_keeper #938 #fb936# __o4t_53_6 GND nmos W=0.0975U L=0.065U
M1495_ #551 __i__a #550 GND nmos W=0.0975U L=0.065U
M1496_ #552 v #551 GND nmos W=0.0975U L=0.065U
M1497_ #554 b_519_6 O4_af_53_6 Vdd pmos W=0.1625U L=0.065U
M1498_keeper #940 #fb939# O4_af_53_6 Vdd pmos W=0.0975U L=0.065U
M1499_keeper #941 #fb939# O4_af_53_6 GND nmos W=0.0975U L=0.065U
M1500_ #555 I_aa #554 Vdd pmos W=0.1625U L=0.065U
M1501_ #556 __v #555 Vdd pmos W=0.1625U L=0.065U
M1502_keeper #943 #fb942# __u5 Vdd pmos W=0.0975U L=0.065U
M1503_keeper #944 #fb942# __u5 GND nmos W=0.0975U L=0.065U
M1504_ #560 b_520_6 __o5t_50_6 GND nmos W=0.0975U L=0.065U
M1505_keeper #946 #fb945# __o5t_50_6 Vdd pmos W=0.0975U L=0.065U
M1506_keeper #947 #fb945# __o5t_50_6 GND nmos W=0.0975U L=0.065U
M1507_ #561 __i__a #560 GND nmos W=0.0975U L=0.065U
M1508_ #562 v #561 GND nmos W=0.0975U L=0.065U
M1509_ #564 b_520_6 O5_af_50_6 Vdd pmos W=0.1625U L=0.065U
M1510_keeper #949 #fb948# O5_af_50_6 Vdd pmos W=0.0975U L=0.065U
M1511_keeper #950 #fb948# O5_af_50_6 GND nmos W=0.0975U L=0.065U
M1512_ #565 I_aa #564 Vdd pmos W=0.1625U L=0.065U
M1513_ #566 __v #565 Vdd pmos W=0.1625U L=0.065U
M1514_ #568 b_521_6 __o5t_51_6 GND nmos W=0.0975U L=0.065U
M1515_keeper #952 #fb951# __o5t_51_6 Vdd pmos W=0.0975U L=0.065U
M1516_keeper #953 #fb951# __o5t_51_6 GND nmos W=0.0975U L=0.065U
M1517_ #569 __i__a #568 GND nmos W=0.0975U L=0.065U
M1518_ #570 v #569 GND nmos W=0.0975U L=0.065U
M1519_ #572 b_521_6 O5_af_51_6 Vdd pmos W=0.1625U L=0.065U
M1520_keeper #955 #fb954# O5_af_51_6 Vdd pmos W=0.0975U L=0.065U
M1521_keeper #956 #fb954# O5_af_51_6 GND nmos W=0.0975U L=0.065U
M1522_ #573 I_aa #572 Vdd pmos W=0.1625U L=0.065U
M1523_ #574 __v #573 Vdd pmos W=0.1625U L=0.065U
M1524_ #576 b_522_6 __o5t_52_6 GND nmos W=0.0975U L=0.065U
M1525_keeper #958 #fb957# __o5t_52_6 Vdd pmos W=0.0975U L=0.065U
M1526_keeper #959 #fb957# __o5t_52_6 GND nmos W=0.0975U L=0.065U
M1527_ #577 __i__a #576 GND nmos W=0.0975U L=0.065U
M1528_ #578 v #577 GND nmos W=0.0975U L=0.065U
M1529_ #580 b_522_6 O5_af_52_6 Vdd pmos W=0.1625U L=0.065U
M1530_keeper #961 #fb960# O5_af_52_6 Vdd pmos W=0.0975U L=0.065U
M1531_keeper #962 #fb960# O5_af_52_6 GND nmos W=0.0975U L=0.065U
M1532_ #581 I_aa #580 Vdd pmos W=0.1625U L=0.065U
M1533_ #582 __v #581 Vdd pmos W=0.1625U L=0.065U
M1534_ #584 b_523_6 __o5t_53_6 GND nmos W=0.0975U L=0.065U
M1535_keeper #964 #fb963# __o5t_53_6 Vdd pmos W=0.0975U L=0.065U
M1536_keeper #965 #fb963# __o5t_53_6 GND nmos W=0.0975U L=0.065U
M1537_ #585 __i__a #584 GND nmos W=0.0975U L=0.065U
M1538_ #586 v #585 GND nmos W=0.0975U L=0.065U
M1539_ #588 b_523_6 O5_af_53_6 Vdd pmos W=0.1625U L=0.065U
M1540_keeper #967 #fb966# O5_af_53_6 Vdd pmos W=0.0975U L=0.065U
M1541_keeper #968 #fb966# O5_af_53_6 GND nmos W=0.0975U L=0.065U
M1542_ #589 I_aa #588 Vdd pmos W=0.1625U L=0.065U
M1543_ #590 __v #589 Vdd pmos W=0.1625U L=0.065U
M1544_keeper #970 #fb969# __u6 Vdd pmos W=0.0975U L=0.065U
M1545_keeper #971 #fb969# __u6 GND nmos W=0.0975U L=0.065U
M1546_ #594 b_524_6 __o6t_50_6 GND nmos W=0.0975U L=0.065U
M1547_keeper #973 #fb972# __o6t_50_6 Vdd pmos W=0.0975U L=0.065U
M1548_keeper #974 #fb972# __o6t_50_6 GND nmos W=0.0975U L=0.065U
M1549_ #595 __i__a #594 GND nmos W=0.0975U L=0.065U
M1550_ #596 v #595 GND nmos W=0.0975U L=0.065U
M1551_ #598 b_524_6 O6_af_50_6 Vdd pmos W=0.1625U L=0.065U
M1552_keeper #976 #fb975# O6_af_50_6 Vdd pmos W=0.0975U L=0.065U
M1553_keeper #977 #fb975# O6_af_50_6 GND nmos W=0.0975U L=0.065U
M1554_ #599 I_aa #598 Vdd pmos W=0.1625U L=0.065U
M1555_ #600 __v #599 Vdd pmos W=0.1625U L=0.065U
M1556_ #602 b_525_6 __o6t_51_6 GND nmos W=0.0975U L=0.065U
M1557_keeper #979 #fb978# __o6t_51_6 Vdd pmos W=0.0975U L=0.065U
M1558_keeper #980 #fb978# __o6t_51_6 GND nmos W=0.0975U L=0.065U
M1559_ #603 __i__a #602 GND nmos W=0.0975U L=0.065U
M1560_ #604 v #603 GND nmos W=0.0975U L=0.065U
M1561_ #606 b_525_6 O6_af_51_6 Vdd pmos W=0.1625U L=0.065U
M1562_keeper #982 #fb981# O6_af_51_6 Vdd pmos W=0.0975U L=0.065U
M1563_keeper #983 #fb981# O6_af_51_6 GND nmos W=0.0975U L=0.065U
M1564_ #607 I_aa #606 Vdd pmos W=0.1625U L=0.065U
M1565_ #608 __v #607 Vdd pmos W=0.1625U L=0.065U
M1566_ #610 b_526_6 __o6t_52_6 GND nmos W=0.0975U L=0.065U
M1567_keeper #985 #fb984# __o6t_52_6 Vdd pmos W=0.0975U L=0.065U
M1568_keeper #986 #fb984# __o6t_52_6 GND nmos W=0.0975U L=0.065U
M1569_ #611 __i__a #610 GND nmos W=0.0975U L=0.065U
M1570_ #612 v #611 GND nmos W=0.0975U L=0.065U
M1571_ #614 b_526_6 O6_af_52_6 Vdd pmos W=0.1625U L=0.065U
M1572_keeper #988 #fb987# O6_af_52_6 Vdd pmos W=0.0975U L=0.065U
M1573_keeper #989 #fb987# O6_af_52_6 GND nmos W=0.0975U L=0.065U
M1574_ #615 I_aa #614 Vdd pmos W=0.1625U L=0.065U
M1575_ #616 __v #615 Vdd pmos W=0.1625U L=0.065U
M1576_ #618 b_527_6 __o6t_53_6 GND nmos W=0.0975U L=0.065U
M1577_keeper #991 #fb990# __o6t_53_6 Vdd pmos W=0.0975U L=0.065U
M1578_keeper #992 #fb990# __o6t_53_6 GND nmos W=0.0975U L=0.065U
M1579_ #619 __i__a #618 GND nmos W=0.0975U L=0.065U
M1580_ #620 v #619 GND nmos W=0.0975U L=0.065U
M1581_ #622 b_527_6 O6_af_53_6 Vdd pmos W=0.1625U L=0.065U
M1582_keeper #994 #fb993# O6_af_53_6 Vdd pmos W=0.0975U L=0.065U
M1583_keeper #995 #fb993# O6_af_53_6 GND nmos W=0.0975U L=0.065U
M1584_ #623 I_aa #622 Vdd pmos W=0.1625U L=0.065U
M1585_ #624 __v #623 Vdd pmos W=0.1625U L=0.065U
M1586_keeper #997 #fb996# __u7 Vdd pmos W=0.0975U L=0.065U
M1587_keeper #998 #fb996# __u7 GND nmos W=0.0975U L=0.065U
M1588_ #628 b_528_6 __o7t_50_6 GND nmos W=0.0975U L=0.065U
M1589_keeper #1000 #fb999# __o7t_50_6 Vdd pmos W=0.0975U L=0.065U
M1590_keeper #1001 #fb999# __o7t_50_6 GND nmos W=0.0975U L=0.065U
M1591_ #629 __i__a #628 GND nmos W=0.0975U L=0.065U
M1592_ #630 v #629 GND nmos W=0.0975U L=0.065U
M1593_ #632 b_528_6 O7_af_50_6 Vdd pmos W=0.1625U L=0.065U
M1594_keeper #1003 #fb1002# O7_af_50_6 Vdd pmos W=0.0975U L=0.065U
M1595_keeper #1004 #fb1002# O7_af_50_6 GND nmos W=0.0975U L=0.065U
M1596_ #633 I_aa #632 Vdd pmos W=0.1625U L=0.065U
M1597_ #634 __v #633 Vdd pmos W=0.1625U L=0.065U
M1598_ #636 b_529_6 __o7t_51_6 GND nmos W=0.0975U L=0.065U
M1599_keeper #1006 #fb1005# __o7t_51_6 Vdd pmos W=0.0975U L=0.065U
M1600_keeper #1007 #fb1005# __o7t_51_6 GND nmos W=0.0975U L=0.065U
M1601_ #637 __i__a #636 GND nmos W=0.0975U L=0.065U
M1602_ #638 v #637 GND nmos W=0.0975U L=0.065U
M1603_ #640 b_529_6 O7_af_51_6 Vdd pmos W=0.1625U L=0.065U
M1604_keeper #1009 #fb1008# O7_af_51_6 Vdd pmos W=0.0975U L=0.065U
M1605_keeper #1010 #fb1008# O7_af_51_6 GND nmos W=0.0975U L=0.065U
M1606_ #641 I_aa #640 Vdd pmos W=0.1625U L=0.065U
M1607_ #642 __v #641 Vdd pmos W=0.1625U L=0.065U
M1608_ #644 b_530_6 __o7t_52_6 GND nmos W=0.0975U L=0.065U
M1609_keeper #1012 #fb1011# __o7t_52_6 Vdd pmos W=0.0975U L=0.065U
M1610_keeper #1013 #fb1011# __o7t_52_6 GND nmos W=0.0975U L=0.065U
M1611_ #645 __i__a #644 GND nmos W=0.0975U L=0.065U
M1612_ #646 v #645 GND nmos W=0.0975U L=0.065U
M1613_ #648 b_530_6 O7_af_52_6 Vdd pmos W=0.1625U L=0.065U
M1614_keeper #1015 #fb1014# O7_af_52_6 Vdd pmos W=0.0975U L=0.065U
M1615_keeper #1016 #fb1014# O7_af_52_6 GND nmos W=0.0975U L=0.065U
M1616_ #649 I_aa #648 Vdd pmos W=0.1625U L=0.065U
M1617_ #650 __v #649 Vdd pmos W=0.1625U L=0.065U
M1618_ #652 b_531_6 __o7t_53_6 GND nmos W=0.0975U L=0.065U
M1619_keeper #1018 #fb1017# __o7t_53_6 Vdd pmos W=0.0975U L=0.065U
M1620_keeper #1019 #fb1017# __o7t_53_6 GND nmos W=0.0975U L=0.065U
M1621_ #653 __i__a #652 GND nmos W=0.0975U L=0.065U
M1622_ #654 v #653 GND nmos W=0.0975U L=0.065U
M1623_ #656 b_531_6 O7_af_53_6 Vdd pmos W=0.1625U L=0.065U
M1624_keeper #1021 #fb1020# O7_af_53_6 Vdd pmos W=0.0975U L=0.065U
M1625_keeper #1022 #fb1020# O7_af_53_6 GND nmos W=0.0975U L=0.065U
M1626_ #657 I_aa #656 Vdd pmos W=0.1625U L=0.065U
M1627_ #658 __v #657 Vdd pmos W=0.1625U L=0.065U
.ends
*---- end of process: WordBuffer<> -----
*
*---- act defproc: Merge<4,t> -----
* raw ports:  I0.t[0] I0.t[1] I0.t[2] I0.t[3] I0.f[0] I0.f[1] I0.f[2] I0.f[3] I0.a I1.t[0] I1.t[1] I1.t[2] I1.t[3] I1.f[0] I1.f[1] I1.f[2] I1.f[3] I1.a O.t[0] O.t[1] O.t[2] O.t[3] O.f[0] O.f[1] O.f[2] O.f[3] O.a
*
.subckt Merge_34_7t_4 I0_at_50_6 I0_at_51_6 I0_at_52_6 I0_at_53_6 I0_af_50_6 I0_af_51_6 I0_af_52_6 I0_af_53_6 I0_aa I1_at_50_6 I1_at_51_6 I1_at_52_6 I1_at_53_6 I1_af_50_6 I1_af_51_6 I1_af_52_6 I1_af_53_6 I1_aa O_at_50_6 O_at_51_6 O_at_52_6 O_at_53_6 O_af_50_6 O_af_51_6 O_af_52_6 O_af_53_6 O_aa
*.PININFO I0_at_50_6:I I0_at_51_6:I I0_at_52_6:I I0_at_53_6:I I0_af_50_6:I I0_af_51_6:I I0_af_52_6:I I0_af_53_6:I I0_aa:O I1_at_50_6:I I1_at_51_6:I I1_at_52_6:I I1_at_53_6:I I1_af_50_6:I I1_af_51_6:I I1_af_52_6:I I1_af_53_6:I I1_aa:O O_at_50_6:O O_at_51_6:O O_at_52_6:O O_at_53_6:O O_af_50_6:O O_af_51_6:O O_af_52_6:O O_af_53_6:O O_aa:I
*.POWER VDD Vdd
*.POWER GND GND
*.POWER NSUB GND
*.POWER PSUB Vdd
*
* --- node flags ---
*
* n__I0__a (state-holding): pup_reff=0.4; pdn_reff=1.33333
* n__I1__a (state-holding): pup_reff=0.4; pdn_reff=1.33333
* n__O__t_50_6 (combinational)
* n__O__f_50_6 (combinational)
* n__O__t_51_6 (combinational)
* n__O__f_51_6 (combinational)
* n__O__t_52_6 (combinational)
* n__O__f_52_6 (combinational)
* n__O__t_53_6 (combinational)
* n__O__f_53_6 (combinational)
* I0_aa (combinational)
* I1_aa (combinational)
* O_at_50_6 (combinational)
* O_af_50_6 (combinational)
* O_at_51_6 (combinational)
* O_af_51_6 (combinational)
* O_at_52_6 (combinational)
* O_af_52_6 (combinational)
* O_at_53_6 (combinational)
* O_af_53_6 (combinational)
*
* --- end node flags ---
*
M0_ Vdd O_aa n__I0__a Vdd pmos W=0.1625U L=0.065U
M1_ Vdd O_aa n__I1__a Vdd pmos W=0.1625U L=0.065U
M2_ Vdd I0_at_50_6 #14 Vdd pmos W=0.1625U L=0.065U
M3_ Vdd I0_af_50_6 #18 Vdd pmos W=0.1625U L=0.065U
M4_ Vdd I0_at_51_6 #22 Vdd pmos W=0.1625U L=0.065U
M5_ Vdd I0_af_51_6 #26 Vdd pmos W=0.1625U L=0.065U
M6_ Vdd I0_at_52_6 #30 Vdd pmos W=0.1625U L=0.065U
M7_ Vdd I0_af_52_6 #34 Vdd pmos W=0.1625U L=0.065U
M8_ Vdd I0_at_53_6 #36 Vdd pmos W=0.1625U L=0.065U
M9_ Vdd I0_af_53_6 #38 Vdd pmos W=0.1625U L=0.065U
M10_ Vdd n__I0__a I0_aa Vdd pmos W=0.1625U L=0.065U
M11_ Vdd n__I1__a I1_aa Vdd pmos W=0.1625U L=0.065U
M12_ Vdd n__O__t_50_6 O_at_50_6 Vdd pmos W=0.1625U L=0.065U
M13_ Vdd n__O__f_50_6 O_af_50_6 Vdd pmos W=0.1625U L=0.065U
M14_ Vdd n__O__t_51_6 O_at_51_6 Vdd pmos W=0.1625U L=0.065U
M15_ Vdd n__O__f_51_6 O_af_51_6 Vdd pmos W=0.1625U L=0.065U
M16_ Vdd n__O__t_52_6 O_at_52_6 Vdd pmos W=0.1625U L=0.065U
M17_ Vdd n__O__f_52_6 O_af_52_6 Vdd pmos W=0.1625U L=0.065U
M18_ Vdd n__O__t_53_6 O_at_53_6 Vdd pmos W=0.1625U L=0.065U
M19_ Vdd n__O__f_53_6 O_af_53_6 Vdd pmos W=0.1625U L=0.065U
M20_ Vdd n__I0__a #fb49# Vdd pmos W=0.1625U L=0.13U
M21_ Vdd n__I1__a #fb52# Vdd pmos W=0.1625U L=0.13U
M22_keeper Vdd GND #50 Vdd pmos W=0.0975U L=0.585U
M23_keeper Vdd GND #53 Vdd pmos W=0.0975U L=0.585U
M24_ GND O_aa #3 GND nmos W=0.0975U L=0.065U
M25_ GND O_aa #8 GND nmos W=0.0975U L=0.065U
M26_ GND I0_at_50_6 n__O__t_50_6 GND nmos W=0.0975U L=0.065U
M27_ GND I1_at_50_6 n__O__t_50_6 GND nmos W=0.0975U L=0.065U
M28_ GND I0_af_50_6 n__O__f_50_6 GND nmos W=0.0975U L=0.065U
M29_ GND I1_af_50_6 n__O__f_50_6 GND nmos W=0.0975U L=0.065U
M30_ GND I0_at_51_6 n__O__t_51_6 GND nmos W=0.0975U L=0.065U
M31_ GND I1_at_51_6 n__O__t_51_6 GND nmos W=0.0975U L=0.065U
M32_ GND I0_af_51_6 n__O__f_51_6 GND nmos W=0.0975U L=0.065U
M33_ GND I1_af_51_6 n__O__f_51_6 GND nmos W=0.0975U L=0.065U
M34_ GND I0_at_52_6 n__O__t_52_6 GND nmos W=0.0975U L=0.065U
M35_ GND I1_at_52_6 n__O__t_52_6 GND nmos W=0.0975U L=0.065U
M36_ GND I0_af_52_6 n__O__f_52_6 GND nmos W=0.0975U L=0.065U
M37_ GND I1_af_52_6 n__O__f_52_6 GND nmos W=0.0975U L=0.065U
M38_ GND I0_at_53_6 n__O__t_53_6 GND nmos W=0.0975U L=0.065U
M39_ GND I1_at_53_6 n__O__t_53_6 GND nmos W=0.0975U L=0.065U
M40_ GND I0_af_53_6 n__O__f_53_6 GND nmos W=0.0975U L=0.065U
M41_ GND I1_af_53_6 n__O__f_53_6 GND nmos W=0.0975U L=0.065U
M42_ GND n__I0__a I0_aa GND nmos W=0.0975U L=0.065U
M43_ GND n__I1__a I1_aa GND nmos W=0.0975U L=0.065U
M44_ GND n__O__t_50_6 O_at_50_6 GND nmos W=0.0975U L=0.065U
M45_ GND n__O__f_50_6 O_af_50_6 GND nmos W=0.0975U L=0.065U
M46_ GND n__O__t_51_6 O_at_51_6 GND nmos W=0.0975U L=0.065U
M47_ GND n__O__f_51_6 O_af_51_6 GND nmos W=0.0975U L=0.065U
M48_ GND n__O__t_52_6 O_at_52_6 GND nmos W=0.0975U L=0.065U
M49_ GND n__O__f_52_6 O_af_52_6 GND nmos W=0.0975U L=0.065U
M50_ GND n__O__t_53_6 O_at_53_6 GND nmos W=0.0975U L=0.065U
M51_ GND n__O__f_53_6 O_af_53_6 GND nmos W=0.0975U L=0.065U
M52_ GND n__I0__a #fb49# GND nmos W=0.0975U L=0.13U
M53_ GND n__I1__a #fb52# GND nmos W=0.0975U L=0.13U
M54_keeper GND Vdd #51 GND nmos W=0.0975U L=0.715U
M55_keeper GND Vdd #54 GND nmos W=0.0975U L=0.715U
M56_ #3 I0_at_53_6 n__I0__a GND nmos W=0.0975U L=0.065U
M57_ #3 I0_af_53_6 n__I0__a GND nmos W=0.0975U L=0.065U
M58_keeper #50 #fb49# n__I0__a Vdd pmos W=0.0975U L=0.065U
M59_keeper #51 #fb49# n__I0__a GND nmos W=0.0975U L=0.065U
M60_ #8 I1_at_53_6 n__I1__a GND nmos W=0.0975U L=0.065U
M61_ #8 I1_af_53_6 n__I1__a GND nmos W=0.0975U L=0.065U
M62_keeper #53 #fb52# n__I1__a Vdd pmos W=0.0975U L=0.065U
M63_keeper #54 #fb52# n__I1__a GND nmos W=0.0975U L=0.065U
M64_ #14 I1_at_50_6 n__O__t_50_6 Vdd pmos W=0.1625U L=0.065U
M65_ #18 I1_af_50_6 n__O__f_50_6 Vdd pmos W=0.1625U L=0.065U
M66_ #22 I1_at_51_6 n__O__t_51_6 Vdd pmos W=0.1625U L=0.065U
M67_ #26 I1_af_51_6 n__O__f_51_6 Vdd pmos W=0.1625U L=0.065U
M68_ #30 I1_at_52_6 n__O__t_52_6 Vdd pmos W=0.1625U L=0.065U
M69_ #34 I1_af_52_6 n__O__f_52_6 Vdd pmos W=0.1625U L=0.065U
M70_ #36 I1_at_53_6 n__O__t_53_6 Vdd pmos W=0.1625U L=0.065U
M71_ #38 I1_af_53_6 n__O__f_53_6 Vdd pmos W=0.1625U L=0.065U
.ends
*---- end of process: Merge<4,t> -----
*
*---- act defproc: MergeTree7<> -----
* raw ports:  I0.t[0] I0.t[1] I0.t[2] I0.t[3] I0.f[0] I0.f[1] I0.f[2] I0.f[3] I0.a I1.t[0] I1.t[1] I1.t[2] I1.t[3] I1.f[0] I1.f[1] I1.f[2] I1.f[3] I1.a I2.t[0] I2.t[1] I2.t[2] I2.t[3] I2.f[0] I2.f[1] I2.f[2] I2.f[3] I2.a I3.t[0] I3.t[1] I3.t[2] I3.t[3] I3.f[0] I3.f[1] I3.f[2] I3.f[3] I3.a I4.t[0] I4.t[1] I4.t[2] I4.t[3] I4.f[0] I4.f[1] I4.f[2] I4.f[3] I4.a I5.t[0] I5.t[1] I5.t[2] I5.t[3] I5.f[0] I5.f[1] I5.f[2] I5.f[3] I5.a I6.t[0] I6.t[1] I6.t[2] I6.t[3] I6.f[0] I6.f[1] I6.f[2] I6.f[3] I6.a O.t[0] O.t[1] O.t[2] O.t[3] O.f[0] O.f[1] O.f[2] O.f[3] O.a
*
.subckt MergeTree7 I0_at_50_6 I0_at_51_6 I0_at_52_6 I0_at_53_6 I0_af_50_6 I0_af_51_6 I0_af_52_6 I0_af_53_6 I0_aa I1_at_50_6 I1_at_51_6 I1_at_52_6 I1_at_53_6 I1_af_50_6 I1_af_51_6 I1_af_52_6 I1_af_53_6 I1_aa I2_at_50_6 I2_at_51_6 I2_at_52_6 I2_at_53_6 I2_af_50_6 I2_af_51_6 I2_af_52_6 I2_af_53_6 I2_aa I3_at_50_6 I3_at_51_6 I3_at_52_6 I3_at_53_6 I3_af_50_6 I3_af_51_6 I3_af_52_6 I3_af_53_6 I3_aa I4_at_50_6 I4_at_51_6 I4_at_52_6 I4_at_53_6 I4_af_50_6 I4_af_51_6 I4_af_52_6 I4_af_53_6 I4_aa I5_at_50_6 I5_at_51_6 I5_at_52_6 I5_at_53_6 I5_af_50_6 I5_af_51_6 I5_af_52_6 I5_af_53_6 I5_aa I6_at_50_6 I6_at_51_6 I6_at_52_6 I6_at_53_6 I6_af_50_6 I6_af_51_6 I6_af_52_6 I6_af_53_6 I6_aa O_at_50_6 O_at_51_6 O_at_52_6 O_at_53_6 O_af_50_6 O_af_51_6 O_af_52_6 O_af_53_6 O_aa
*.PININFO I0_at_50_6:I I0_at_51_6:I I0_at_52_6:I I0_at_53_6:I I0_af_50_6:I I0_af_51_6:I I0_af_52_6:I I0_af_53_6:I I0_aa:O I1_at_50_6:I I1_at_51_6:I I1_at_52_6:I I1_at_53_6:I I1_af_50_6:I I1_af_51_6:I I1_af_52_6:I I1_af_53_6:I I1_aa:O I2_at_50_6:I I2_at_51_6:I I2_at_52_6:I I2_at_53_6:I I2_af_50_6:I I2_af_51_6:I I2_af_52_6:I I2_af_53_6:I I2_aa:O I3_at_50_6:I I3_at_51_6:I I3_at_52_6:I I3_at_53_6:I I3_af_50_6:I I3_af_51_6:I I3_af_52_6:I I3_af_53_6:I I3_aa:O I4_at_50_6:I I4_at_51_6:I I4_at_52_6:I I4_at_53_6:I I4_af_50_6:I I4_af_51_6:I I4_af_52_6:I I4_af_53_6:I I4_aa:O I5_at_50_6:I I5_at_51_6:I I5_at_52_6:I I5_at_53_6:I I5_af_50_6:I I5_af_51_6:I I5_af_52_6:I I5_af_53_6:I I5_aa:O I6_at_50_6:I I6_at_51_6:I I6_at_52_6:I I6_at_53_6:I I6_af_50_6:I I6_af_51_6:I I6_af_52_6:I I6_af_53_6:I I6_aa:O O_at_50_6:O O_at_51_6:O O_at_52_6:O O_at_53_6:O O_af_50_6:O O_af_51_6:O O_af_52_6:O O_af_53_6:O O_aa:I
*.POWER VDD Vdd
*.POWER GND GND
*.POWER NSUB GND
*.POWER PSUB Vdd
xmerge56 I4_at_50_6 I4_at_51_6 I4_at_52_6 I4_at_53_6 I4_af_50_6 I4_af_51_6 I4_af_52_6 I4_af_53_6 I4_aa I5_at_50_6 I5_at_51_6 I5_at_52_6 I5_at_53_6 I5_af_50_6 I5_af_51_6 I5_af_52_6 I5_af_53_6 I5_aa merge56_aO_at_50_6 merge56_aO_at_51_6 merge56_aO_at_52_6 merge56_aO_at_53_6 merge56_aO_af_50_6 merge56_aO_af_51_6 merge56_aO_af_52_6 merge56_aO_af_53_6 merge56_aO_aa Merge_34_7t_4
xmerge34 I2_at_50_6 I2_at_51_6 I2_at_52_6 I2_at_53_6 I2_af_50_6 I2_af_51_6 I2_af_52_6 I2_af_53_6 I2_aa I3_at_50_6 I3_at_51_6 I3_at_52_6 I3_at_53_6 I3_af_50_6 I3_af_51_6 I3_af_52_6 I3_af_53_6 I3_aa merge34_aO_at_50_6 merge34_aO_at_51_6 merge34_aO_at_52_6 merge34_aO_at_53_6 merge34_aO_af_50_6 merge34_aO_af_51_6 merge34_aO_af_52_6 merge34_aO_af_53_6 merge34_aO_aa Merge_34_7t_4
xroot root_aI0_at_50_6 root_aI0_at_51_6 root_aI0_at_52_6 root_aI0_at_53_6 root_aI0_af_50_6 root_aI0_af_51_6 root_aI0_af_52_6 root_aI0_af_53_6 root_aI0_aa root_aI1_at_50_6 root_aI1_at_51_6 root_aI1_at_52_6 root_aI1_at_53_6 root_aI1_af_50_6 root_aI1_af_51_6 root_aI1_af_52_6 root_aI1_af_53_6 root_aI1_aa O_at_50_6 O_at_51_6 O_at_52_6 O_at_53_6 O_af_50_6 O_af_51_6 O_af_52_6 O_af_53_6 O_aa Merge_34_7t_4
xmerge567 merge56_aO_at_50_6 merge56_aO_at_51_6 merge56_aO_at_52_6 merge56_aO_at_53_6 merge56_aO_af_50_6 merge56_aO_af_51_6 merge56_aO_af_52_6 merge56_aO_af_53_6 merge56_aO_aa I6_at_50_6 I6_at_51_6 I6_at_52_6 I6_at_53_6 I6_af_50_6 I6_af_51_6 I6_af_52_6 I6_af_53_6 I6_aa root_aI1_at_50_6 root_aI1_at_51_6 root_aI1_at_52_6 root_aI1_at_53_6 root_aI1_af_50_6 root_aI1_af_51_6 root_aI1_af_52_6 root_aI1_af_53_6 root_aI1_aa Merge_34_7t_4
xmerge1234 merge12_aO_at_50_6 merge12_aO_at_51_6 merge12_aO_at_52_6 merge12_aO_at_53_6 merge12_aO_af_50_6 merge12_aO_af_51_6 merge12_aO_af_52_6 merge12_aO_af_53_6 merge12_aO_aa merge34_aO_at_50_6 merge34_aO_at_51_6 merge34_aO_at_52_6 merge34_aO_at_53_6 merge34_aO_af_50_6 merge34_aO_af_51_6 merge34_aO_af_52_6 merge34_aO_af_53_6 merge34_aO_aa root_aI0_at_50_6 root_aI0_at_51_6 root_aI0_at_52_6 root_aI0_at_53_6 root_aI0_af_50_6 root_aI0_af_51_6 root_aI0_af_52_6 root_aI0_af_53_6 root_aI0_aa Merge_34_7t_4
xmerge12 I0_at_50_6 I0_at_51_6 I0_at_52_6 I0_at_53_6 I0_af_50_6 I0_af_51_6 I0_af_52_6 I0_af_53_6 I0_aa I1_at_50_6 I1_at_51_6 I1_at_52_6 I1_at_53_6 I1_af_50_6 I1_af_51_6 I1_af_52_6 I1_af_53_6 I1_aa merge12_aO_at_50_6 merge12_aO_at_51_6 merge12_aO_at_52_6 merge12_aO_at_53_6 merge12_aO_af_50_6 merge12_aO_af_51_6 merge12_aO_af_52_6 merge12_aO_af_53_6 merge12_aO_aa Merge_34_7t_4
.ends
*---- end of process: MergeTree7<> -----
*
*---- act defproc: Serializer<> -----
* raw ports:  reset I.t[0] I.t[1] I.t[2] I.t[3] I.t[4] I.t[5] I.t[6] I.t[7] I.t[8] I.t[9] I.t[10] I.t[11] I.t[12] I.t[13] I.t[14] I.t[15] I.t[16] I.t[17] I.t[18] I.t[19] I.t[20] I.t[21] I.t[22] I.t[23] I.t[24] I.t[25] I.t[26] I.t[27] I.t[28] I.t[29] I.t[30] I.t[31] I.f[0] I.f[1] I.f[2] I.f[3] I.f[4] I.f[5] I.f[6] I.f[7] I.f[8] I.f[9] I.f[10] I.f[11] I.f[12] I.f[13] I.f[14] I.f[15] I.f[16] I.f[17] I.f[18] I.f[19] I.f[20] I.f[21] I.f[22] I.f[23] I.f[24] I.f[25] I.f[26] I.f[27] I.f[28] I.f[29] I.f[30] I.f[31] I.a O.t[0] O.t[1] O.t[2] O.t[3] O.f[0] O.f[1] O.f[2] O.f[3] O.a
*
.subckt Serializer reset I_at_50_6 I_at_51_6 I_at_52_6 I_at_53_6 I_at_54_6 I_at_55_6 I_at_56_6 I_at_57_6 I_at_58_6 I_at_59_6 I_at_510_6 I_at_511_6 I_at_512_6 I_at_513_6 I_at_514_6 I_at_515_6 I_at_516_6 I_at_517_6 I_at_518_6 I_at_519_6 I_at_520_6 I_at_521_6 I_at_522_6 I_at_523_6 I_at_524_6 I_at_525_6 I_at_526_6 I_at_527_6 I_at_528_6 I_at_529_6 I_at_530_6 I_at_531_6 I_af_50_6 I_af_51_6 I_af_52_6 I_af_53_6 I_af_54_6 I_af_55_6 I_af_56_6 I_af_57_6 I_af_58_6 I_af_59_6 I_af_510_6 I_af_511_6 I_af_512_6 I_af_513_6 I_af_514_6 I_af_515_6 I_af_516_6 I_af_517_6 I_af_518_6 I_af_519_6 I_af_520_6 I_af_521_6 I_af_522_6 I_af_523_6 I_af_524_6 I_af_525_6 I_af_526_6 I_af_527_6 I_af_528_6 I_af_529_6 I_af_530_6 I_af_531_6 I_aa O_at_50_6 O_at_51_6 O_at_52_6 O_at_53_6 O_af_50_6 O_af_51_6 O_af_52_6 O_af_53_6 O_aa
*.PININFO reset:I I_at_50_6:I I_at_51_6:I I_at_52_6:I I_at_53_6:I I_at_54_6:I I_at_55_6:I I_at_56_6:I I_at_57_6:I I_at_58_6:I I_at_59_6:I I_at_510_6:I I_at_511_6:I I_at_512_6:I I_at_513_6:I I_at_514_6:I I_at_515_6:I I_at_516_6:I I_at_517_6:I I_at_518_6:I I_at_519_6:I I_at_520_6:I I_at_521_6:I I_at_522_6:I I_at_523_6:I I_at_524_6:I I_at_525_6:I I_at_526_6:I I_at_527_6:I I_at_528_6:I I_at_529_6:I I_at_530_6:I I_at_531_6:I I_af_50_6:I I_af_51_6:I I_af_52_6:I I_af_53_6:I I_af_54_6:I I_af_55_6:I I_af_56_6:I I_af_57_6:I I_af_58_6:I I_af_59_6:I I_af_510_6:I I_af_511_6:I I_af_512_6:I I_af_513_6:I I_af_514_6:I I_af_515_6:I I_af_516_6:I I_af_517_6:I I_af_518_6:I I_af_519_6:I I_af_520_6:I I_af_521_6:I I_af_522_6:I I_af_523_6:I I_af_524_6:I I_af_525_6:I I_af_526_6:I I_af_527_6:I I_af_528_6:I I_af_529_6:I I_af_530_6:I I_af_531_6:I I_aa:O O_at_50_6:O O_at_51_6:O O_at_52_6:O O_at_53_6:O O_af_50_6:O O_af_51_6:O O_af_52_6:O O_af_53_6:O O_aa:I
*.POWER VDD Vdd
*.POWER GND GND
*.POWER NSUB GND
*.POWER PSUB Vdd
xqs6 wb_aO6_at_50_6 wb_aO6_at_51_6 wb_aO6_at_52_6 wb_aO6_at_53_6 wb_aO6_af_50_6 wb_aO6_af_51_6 wb_aO6_af_52_6 wb_aO6_af_53_6 qs6_aA_areq qs6_aO_at_50_6 qs6_aO_at_51_6 qs6_aO_at_52_6 qs6_aO_at_53_6 qs6_aO_af_50_6 qs6_aO_af_51_6 qs6_aO_af_52_6 qs6_aO_af_53_6 QSlicer
xqs2 wb_aO2_at_50_6 wb_aO2_at_51_6 wb_aO2_at_52_6 wb_aO2_at_53_6 wb_aO2_af_50_6 wb_aO2_af_51_6 wb_aO2_af_52_6 wb_aO2_af_53_6 qs2_aA_areq qs2_aO_at_50_6 qs2_aO_at_51_6 qs2_aO_at_52_6 qs2_aO_at_53_6 qs2_aO_af_50_6 qs2_aO_af_51_6 qs2_aO_af_52_6 qs2_aO_af_53_6 QSlicer
xqs4 wb_aO4_at_50_6 wb_aO4_at_51_6 wb_aO4_at_52_6 wb_aO4_at_53_6 wb_aO4_af_50_6 wb_aO4_af_51_6 wb_aO4_af_52_6 wb_aO4_af_53_6 qs4_aA_areq qs4_aO_at_50_6 qs4_aO_at_51_6 qs4_aO_at_52_6 qs4_aO_at_53_6 qs4_aO_af_50_6 qs4_aO_af_51_6 qs4_aO_af_52_6 qs4_aO_af_53_6 QSlicer
xseq reset qs7_aA_areq wb_aO7_aa qs6_aA_areq wb_aO6_aa qs5_aA_areq wb_aO5_aa qs4_aA_areq wb_aO4_aa qs3_aA_areq wb_aO3_aa qs2_aA_areq wb_aO2_aa qs1_aA_areq wb_aO1_aa Seq7
xqs7 wb_aO7_at_50_6 wb_aO7_at_51_6 wb_aO7_at_52_6 wb_aO7_at_53_6 wb_aO7_af_50_6 wb_aO7_af_51_6 wb_aO7_af_52_6 wb_aO7_af_53_6 qs7_aA_areq qs7_aO_at_50_6 qs7_aO_at_51_6 qs7_aO_at_52_6 qs7_aO_at_53_6 qs7_aO_af_50_6 qs7_aO_af_51_6 qs7_aO_af_52_6 qs7_aO_af_53_6 QSlicer
xqs1 wb_aO1_at_50_6 wb_aO1_at_51_6 wb_aO1_at_52_6 wb_aO1_at_53_6 wb_aO1_af_50_6 wb_aO1_af_51_6 wb_aO1_af_52_6 wb_aO1_af_53_6 qs1_aA_areq qs1_aO_at_50_6 qs1_aO_at_51_6 qs1_aO_at_52_6 qs1_aO_at_53_6 qs1_aO_af_50_6 qs1_aO_af_51_6 qs1_aO_af_52_6 qs1_aO_af_53_6 QSlicer
xqs3 wb_aO3_at_50_6 wb_aO3_at_51_6 wb_aO3_at_52_6 wb_aO3_at_53_6 wb_aO3_af_50_6 wb_aO3_af_51_6 wb_aO3_af_52_6 wb_aO3_af_53_6 qs3_aA_areq qs3_aO_at_50_6 qs3_aO_at_51_6 qs3_aO_at_52_6 qs3_aO_at_53_6 qs3_aO_af_50_6 qs3_aO_af_51_6 qs3_aO_af_52_6 qs3_aO_af_53_6 QSlicer
xqs5 wb_aO5_at_50_6 wb_aO5_at_51_6 wb_aO5_at_52_6 wb_aO5_at_53_6 wb_aO5_af_50_6 wb_aO5_af_51_6 wb_aO5_af_52_6 wb_aO5_af_53_6 qs5_aA_areq qs5_aO_at_50_6 qs5_aO_at_51_6 qs5_aO_at_52_6 qs5_aO_at_53_6 qs5_aO_af_50_6 qs5_aO_af_51_6 qs5_aO_af_52_6 qs5_aO_af_53_6 QSlicer
xwb reset I_at_50_6 I_at_51_6 I_at_52_6 I_at_53_6 I_at_54_6 I_at_55_6 I_at_56_6 I_at_57_6 I_at_58_6 I_at_59_6 I_at_510_6 I_at_511_6 I_at_512_6 I_at_513_6 I_at_514_6 I_at_515_6 I_at_516_6 I_at_517_6 I_at_518_6 I_at_519_6 I_at_520_6 I_at_521_6 I_at_522_6 I_at_523_6 I_at_524_6 I_at_525_6 I_at_526_6 I_at_527_6 I_at_528_6 I_at_529_6 I_at_530_6 I_at_531_6 I_af_50_6 I_af_51_6 I_af_52_6 I_af_53_6 I_af_54_6 I_af_55_6 I_af_56_6 I_af_57_6 I_af_58_6 I_af_59_6 I_af_510_6 I_af_511_6 I_af_512_6 I_af_513_6 I_af_514_6 I_af_515_6 I_af_516_6 I_af_517_6 I_af_518_6 I_af_519_6 I_af_520_6 I_af_521_6 I_af_522_6 I_af_523_6 I_af_524_6 I_af_525_6 I_af_526_6 I_af_527_6 I_af_528_6 I_af_529_6 I_af_530_6 I_af_531_6 I_aa wb_aO1_at_50_6 wb_aO1_at_51_6 wb_aO1_at_52_6 wb_aO1_at_53_6 wb_aO1_af_50_6 wb_aO1_af_51_6 wb_aO1_af_52_6 wb_aO1_af_53_6 wb_aO1_aa wb_aO2_at_50_6 wb_aO2_at_51_6 wb_aO2_at_52_6 wb_aO2_at_53_6 wb_aO2_af_50_6 wb_aO2_af_51_6 wb_aO2_af_52_6 wb_aO2_af_53_6 wb_aO2_aa wb_aO3_at_50_6 wb_aO3_at_51_6 wb_aO3_at_52_6 wb_aO3_at_53_6 wb_aO3_af_50_6 wb_aO3_af_51_6 wb_aO3_af_52_6 wb_aO3_af_53_6 wb_aO3_aa wb_aO4_at_50_6 wb_aO4_at_51_6 wb_aO4_at_52_6 wb_aO4_at_53_6 wb_aO4_af_50_6 wb_aO4_af_51_6 wb_aO4_af_52_6 wb_aO4_af_53_6 wb_aO4_aa wb_aO5_at_50_6 wb_aO5_at_51_6 wb_aO5_at_52_6 wb_aO5_at_53_6 wb_aO5_af_50_6 wb_aO5_af_51_6 wb_aO5_af_52_6 wb_aO5_af_53_6 wb_aO5_aa wb_aO6_at_50_6 wb_aO6_at_51_6 wb_aO6_at_52_6 wb_aO6_at_53_6 wb_aO6_af_50_6 wb_aO6_af_51_6 wb_aO6_af_52_6 wb_aO6_af_53_6 wb_aO6_aa wb_aO7_at_50_6 wb_aO7_at_51_6 wb_aO7_at_52_6 wb_aO7_at_53_6 wb_aO7_af_50_6 wb_aO7_af_51_6 wb_aO7_af_52_6 wb_aO7_af_53_6 wb_aO7_aa WordBuffer
xmerge qs1_aO_at_50_6 qs1_aO_at_51_6 qs1_aO_at_52_6 qs1_aO_at_53_6 qs1_aO_af_50_6 qs1_aO_af_51_6 qs1_aO_af_52_6 qs1_aO_af_53_6 wb_aO1_aa qs2_aO_at_50_6 qs2_aO_at_51_6 qs2_aO_at_52_6 qs2_aO_at_53_6 qs2_aO_af_50_6 qs2_aO_af_51_6 qs2_aO_af_52_6 qs2_aO_af_53_6 wb_aO2_aa qs3_aO_at_50_6 qs3_aO_at_51_6 qs3_aO_at_52_6 qs3_aO_at_53_6 qs3_aO_af_50_6 qs3_aO_af_51_6 qs3_aO_af_52_6 qs3_aO_af_53_6 wb_aO3_aa qs4_aO_at_50_6 qs4_aO_at_51_6 qs4_aO_at_52_6 qs4_aO_at_53_6 qs4_aO_af_50_6 qs4_aO_af_51_6 qs4_aO_af_52_6 qs4_aO_af_53_6 wb_aO4_aa qs5_aO_at_50_6 qs5_aO_at_51_6 qs5_aO_at_52_6 qs5_aO_at_53_6 qs5_aO_af_50_6 qs5_aO_af_51_6 qs5_aO_af_52_6 qs5_aO_af_53_6 wb_aO5_aa qs6_aO_at_50_6 qs6_aO_at_51_6 qs6_aO_at_52_6 qs6_aO_at_53_6 qs6_aO_af_50_6 qs6_aO_af_51_6 qs6_aO_af_52_6 qs6_aO_af_53_6 wb_aO6_aa qs7_aO_at_50_6 qs7_aO_at_51_6 qs7_aO_at_52_6 qs7_aO_at_53_6 qs7_aO_af_50_6 qs7_aO_af_51_6 qs7_aO_af_52_6 qs7_aO_af_53_6 wb_aO7_aa O_at_50_6 O_at_51_6 O_at_52_6 O_at_53_6 O_af_50_6 O_af_51_6 O_af_52_6 O_af_53_6 O_aa MergeTree7
.ends
*---- end of process: Serializer<> -----
*
*---- act defproc: ChildDispatch<> -----
* raw ports:  reset C.t[0] C.f[0] C.a I.t[0] I.t[1] I.t[2] I.t[3] I.t[4] I.t[5] I.t[6] I.t[7] I.t[8] I.t[9] I.t[10] I.t[11] I.t[12] I.t[13] I.t[14] I.t[15] I.t[16] I.t[17] I.t[18] I.t[19] I.t[20] I.t[21] I.t[22] I.t[23] I.t[24] I.t[25] I.t[26] I.t[27] I.t[28] I.t[29] I.t[30] I.t[31] I.f[0] I.f[1] I.f[2] I.f[3] I.f[4] I.f[5] I.f[6] I.f[7] I.f[8] I.f[9] I.f[10] I.f[11] I.f[12] I.f[13] I.f[14] I.f[15] I.f[16] I.f[17] I.f[18] I.f[19] I.f[20] I.f[21] I.f[22] I.f[23] I.f[24] I.f[25] I.f[26] I.f[27] I.f[28] I.f[29] I.f[30] I.f[31] I.a O.t[0] O.t[1] O.t[2] O.t[3] O.t[4] O.t[5] O.t[6] O.t[7] O.t[8] O.t[9] O.t[10] O.t[11] O.t[12] O.t[13] O.t[14] O.t[15] O.t[16] O.t[17] O.t[18] O.t[19] O.t[20] O.t[21] O.t[22] O.t[23] O.t[24] O.t[25] O.t[26] O.t[27] O.t[28] O.t[29] O.t[30] O.t[31] O.f[0] O.f[1] O.f[2] O.f[3] O.f[4] O.f[5] O.f[6] O.f[7] O.f[8] O.f[9] O.f[10] O.f[11] O.f[12] O.f[13] O.f[14] O.f[15] O.f[16] O.f[17] O.f[18] O.f[19] O.f[20] O.f[21] O.f[22] O.f[23] O.f[24] O.f[25] O.f[26] O.f[27] O.f[28] O.f[29] O.f[30] O.f[31] O.a
*
.subckt ChildDispatch reset C_at_50_6 C_af_50_6 C_aa I_at_50_6 I_at_51_6 I_at_52_6 I_at_53_6 I_at_54_6 I_at_55_6 I_at_56_6 I_at_57_6 I_at_58_6 I_at_59_6 I_at_510_6 I_at_511_6 I_at_512_6 I_at_513_6 I_at_514_6 I_at_515_6 I_at_516_6 I_at_517_6 I_at_518_6 I_at_519_6 I_at_520_6 I_at_521_6 I_at_522_6 I_at_523_6 I_at_524_6 I_at_525_6 I_at_526_6 I_at_527_6 I_at_528_6 I_at_529_6 I_at_530_6 I_at_531_6 I_af_50_6 I_af_51_6 I_af_52_6 I_af_53_6 I_af_54_6 I_af_55_6 I_af_56_6 I_af_57_6 I_af_58_6 I_af_59_6 I_af_510_6 I_af_511_6 I_af_512_6 I_af_513_6 I_af_514_6 I_af_515_6 I_af_516_6 I_af_517_6 I_af_518_6 I_af_519_6 I_af_520_6 I_af_521_6 I_af_522_6 I_af_523_6 I_af_524_6 I_af_525_6 I_af_526_6 I_af_527_6 I_af_528_6 I_af_529_6 I_af_530_6 I_af_531_6 I_aa O_at_50_6 O_at_51_6 O_at_52_6 O_at_53_6 O_at_54_6 O_at_55_6 O_at_56_6 O_at_57_6 O_at_58_6 O_at_59_6 O_at_510_6 O_at_511_6 O_at_512_6 O_at_513_6 O_at_514_6 O_at_515_6 O_at_516_6 O_at_517_6 O_at_518_6 O_at_519_6 O_at_520_6 O_at_521_6 O_at_522_6 O_at_523_6 O_at_524_6 O_at_525_6 O_at_526_6 O_at_527_6 O_at_528_6 O_at_529_6 O_at_530_6 O_at_531_6 O_af_50_6 O_af_51_6 O_af_52_6 O_af_53_6 O_af_54_6 O_af_55_6 O_af_56_6 O_af_57_6 O_af_58_6 O_af_59_6 O_af_510_6 O_af_511_6 O_af_512_6 O_af_513_6 O_af_514_6 O_af_515_6 O_af_516_6 O_af_517_6 O_af_518_6 O_af_519_6 O_af_520_6 O_af_521_6 O_af_522_6 O_af_523_6 O_af_524_6 O_af_525_6 O_af_526_6 O_af_527_6 O_af_528_6 O_af_529_6 O_af_530_6 O_af_531_6 O_aa
*.PININFO reset:I C_at_50_6:I C_af_50_6:I C_aa:O I_at_50_6:I I_at_51_6:I I_at_52_6:I I_at_53_6:I I_at_54_6:I I_at_55_6:I I_at_56_6:I I_at_57_6:I I_at_58_6:I I_at_59_6:I I_at_510_6:I I_at_511_6:I I_at_512_6:I I_at_513_6:I I_at_514_6:I I_at_515_6:I I_at_516_6:I I_at_517_6:I I_at_518_6:I I_at_519_6:I I_at_520_6:I I_at_521_6:I I_at_522_6:I I_at_523_6:I I_at_524_6:I I_at_525_6:I I_at_526_6:I I_at_527_6:I I_at_528_6:I I_at_529_6:I I_at_530_6:I I_at_531_6:I I_af_50_6:I I_af_51_6:I I_af_52_6:I I_af_53_6:I I_af_54_6:I I_af_55_6:I I_af_56_6:I I_af_57_6:I I_af_58_6:I I_af_59_6:I I_af_510_6:I I_af_511_6:I I_af_512_6:I I_af_513_6:I I_af_514_6:I I_af_515_6:I I_af_516_6:I I_af_517_6:I I_af_518_6:I I_af_519_6:I I_af_520_6:I I_af_521_6:I I_af_522_6:I I_af_523_6:I I_af_524_6:I I_af_525_6:I I_af_526_6:I I_af_527_6:I I_af_528_6:I I_af_529_6:I I_af_530_6:I I_af_531_6:I I_aa:O O_at_50_6:O O_at_51_6:O O_at_52_6:O O_at_53_6:O O_at_54_6:O O_at_55_6:O O_at_56_6:O O_at_57_6:O O_at_58_6:O O_at_59_6:O O_at_510_6:O O_at_511_6:O O_at_512_6:O O_at_513_6:O O_at_514_6:O O_at_515_6:O O_at_516_6:O O_at_517_6:O O_at_518_6:O O_at_519_6:O O_at_520_6:O O_at_521_6:O O_at_522_6:O O_at_523_6:O O_at_524_6:O O_at_525_6:O O_at_526_6:O O_at_527_6:O O_at_528_6:O O_at_529_6:O O_at_530_6:O O_at_531_6:O O_af_50_6:O O_af_51_6:O O_af_52_6:O O_af_53_6:O O_af_54_6:O O_af_55_6:O O_af_56_6:O O_af_57_6:O O_af_58_6:O O_af_59_6:O O_af_510_6:O O_af_511_6:O O_af_512_6:O O_af_513_6:O O_af_514_6:O O_af_515_6:O O_af_516_6:O O_af_517_6:O O_af_518_6:O O_af_519_6:O O_af_520_6:O O_af_521_6:O O_af_522_6:O O_af_523_6:O O_af_524_6:O O_af_525_6:O O_af_526_6:O O_af_527_6:O O_af_528_6:O O_af_529_6:O O_af_530_6:O O_af_531_6:O O_aa:I
*.POWER VDD Vdd
*.POWER GND GND
*.POWER NSUB GND
*.POWER PSUB Vdd
*
* --- node flags ---
*
* c (state-holding): pup_reff=0.4; pdn_reff=2
* __cht (combinational)
* w0 (state-holding): pup_reff=0.8; pdn_reff=2
* I_aa (state-holding): pup_reff=0.4; pdn_reff=2.66667
* __oa (combinational)
* __cha (state-holding): pup_reff=0.8; pdn_reff=1.33333
* __c (combinational)
* __it0 (combinational)
* w1 (state-holding): pup_reff=0.8; pdn_reff=2
* __if0 (combinational)
* v (state-holding): pup_reff=26.4; pdn_reff=0.666667
* __j (state-holding): pup_reff=0.4; pdn_reff=2
* __ia (combinational)
* __v (combinational)
* __r (combinational)
* __w0 (combinational)
* __w1 (combinational)
* __ot_50_6 (state-holding): pup_reff=0.4; pdn_reff=1.33333
* __of_50_6 (state-holding): pup_reff=0.4; pdn_reff=1.33333
* __ot_51_6 (state-holding): pup_reff=0.4; pdn_reff=1.33333
* __of_51_6 (state-holding): pup_reff=0.4; pdn_reff=1.33333
* __ot_52_6 (state-holding): pup_reff=0.4; pdn_reff=1.33333
* __of_52_6 (state-holding): pup_reff=0.4; pdn_reff=1.33333
* __ot_53_6 (state-holding): pup_reff=0.4; pdn_reff=1.33333
* __of_53_6 (state-holding): pup_reff=0.4; pdn_reff=1.33333
* __ot_54_6 (state-holding): pup_reff=0.4; pdn_reff=1.33333
* __of_54_6 (state-holding): pup_reff=0.4; pdn_reff=1.33333
* __ot_55_6 (state-holding): pup_reff=0.4; pdn_reff=1.33333
* __of_55_6 (state-holding): pup_reff=0.4; pdn_reff=1.33333
* __ot_56_6 (state-holding): pup_reff=0.4; pdn_reff=1.33333
* __of_56_6 (state-holding): pup_reff=0.4; pdn_reff=1.33333
* __ot_57_6 (state-holding): pup_reff=0.4; pdn_reff=1.33333
* __of_57_6 (state-holding): pup_reff=0.4; pdn_reff=1.33333
* __ot_58_6 (state-holding): pup_reff=0.4; pdn_reff=1.33333
* __of_58_6 (state-holding): pup_reff=0.4; pdn_reff=1.33333
* __ot_59_6 (state-holding): pup_reff=0.4; pdn_reff=1.33333
* __of_59_6 (state-holding): pup_reff=0.4; pdn_reff=1.33333
* __ot_510_6 (state-holding): pup_reff=0.4; pdn_reff=1.33333
* __of_510_6 (state-holding): pup_reff=0.4; pdn_reff=1.33333
* __ot_511_6 (state-holding): pup_reff=0.4; pdn_reff=1.33333
* __of_511_6 (state-holding): pup_reff=0.4; pdn_reff=1.33333
* __ot_512_6 (state-holding): pup_reff=0.4; pdn_reff=1.33333
* __of_512_6 (state-holding): pup_reff=0.4; pdn_reff=1.33333
* __ot_513_6 (state-holding): pup_reff=0.4; pdn_reff=1.33333
* __of_513_6 (state-holding): pup_reff=0.4; pdn_reff=1.33333
* __ot_514_6 (state-holding): pup_reff=0.4; pdn_reff=1.33333
* __of_514_6 (state-holding): pup_reff=0.4; pdn_reff=1.33333
* __ot_515_6 (state-holding): pup_reff=0.4; pdn_reff=1.33333
* __of_515_6 (state-holding): pup_reff=0.4; pdn_reff=1.33333
* __ot_516_6 (state-holding): pup_reff=0.4; pdn_reff=1.33333
* __of_516_6 (state-holding): pup_reff=0.4; pdn_reff=1.33333
* __ot_517_6 (state-holding): pup_reff=0.4; pdn_reff=1.33333
* __of_517_6 (state-holding): pup_reff=0.4; pdn_reff=1.33333
* __ot_518_6 (state-holding): pup_reff=0.4; pdn_reff=1.33333
* __of_518_6 (state-holding): pup_reff=0.4; pdn_reff=1.33333
* __ot_519_6 (state-holding): pup_reff=0.4; pdn_reff=1.33333
* __of_519_6 (state-holding): pup_reff=0.4; pdn_reff=1.33333
* __ot_520_6 (state-holding): pup_reff=0.4; pdn_reff=1.33333
* __of_520_6 (state-holding): pup_reff=0.4; pdn_reff=1.33333
* __ot_521_6 (state-holding): pup_reff=0.4; pdn_reff=1.33333
* __of_521_6 (state-holding): pup_reff=0.4; pdn_reff=1.33333
* __ot_522_6 (state-holding): pup_reff=0.4; pdn_reff=1.33333
* __of_522_6 (state-holding): pup_reff=0.4; pdn_reff=1.33333
* __ot_523_6 (state-holding): pup_reff=0.4; pdn_reff=1.33333
* __of_523_6 (state-holding): pup_reff=0.4; pdn_reff=1.33333
* __ot_524_6 (state-holding): pup_reff=0.4; pdn_reff=1.33333
* __of_524_6 (state-holding): pup_reff=0.4; pdn_reff=1.33333
* __ot_525_6 (state-holding): pup_reff=0.4; pdn_reff=1.33333
* __of_525_6 (state-holding): pup_reff=0.4; pdn_reff=1.33333
* __ot_526_6 (state-holding): pup_reff=0.4; pdn_reff=1.33333
* __of_526_6 (state-holding): pup_reff=0.4; pdn_reff=1.33333
* __ot_527_6 (state-holding): pup_reff=0.4; pdn_reff=1.33333
* __of_527_6 (state-holding): pup_reff=0.4; pdn_reff=1.33333
* __ot_528_6 (state-holding): pup_reff=0.4; pdn_reff=1.33333
* __of_528_6 (state-holding): pup_reff=0.4; pdn_reff=1.33333
* __ot_529_6 (state-holding): pup_reff=0.4; pdn_reff=1.33333
* __of_529_6 (state-holding): pup_reff=0.4; pdn_reff=1.33333
* __ot_530_6 (state-holding): pup_reff=0.4; pdn_reff=1.33333
* __of_530_6 (state-holding): pup_reff=0.4; pdn_reff=1.33333
* __ot_531_6 (state-holding): pup_reff=0.4; pdn_reff=1.33333
* __of_531_6 (state-holding): pup_reff=0.4; pdn_reff=1.33333
* C_aa (combinational)
* O_at_50_6 (combinational)
* O_af_50_6 (combinational)
* O_at_51_6 (combinational)
* O_af_51_6 (combinational)
* O_at_52_6 (combinational)
* O_af_52_6 (combinational)
* O_at_53_6 (combinational)
* O_af_53_6 (combinational)
* O_at_54_6 (combinational)
* O_af_54_6 (combinational)
* O_at_55_6 (combinational)
* O_af_55_6 (combinational)
* O_at_56_6 (combinational)
* O_af_56_6 (combinational)
* O_at_57_6 (combinational)
* O_af_57_6 (combinational)
* O_at_58_6 (combinational)
* O_af_58_6 (combinational)
* O_at_59_6 (combinational)
* O_af_59_6 (combinational)
* O_at_510_6 (combinational)
* O_af_510_6 (combinational)
* O_at_511_6 (combinational)
* O_af_511_6 (combinational)
* O_at_512_6 (combinational)
* O_af_512_6 (combinational)
* O_at_513_6 (combinational)
* O_af_513_6 (combinational)
* O_at_514_6 (combinational)
* O_af_514_6 (combinational)
* O_at_515_6 (combinational)
* O_af_515_6 (combinational)
* O_at_516_6 (combinational)
* O_af_516_6 (combinational)
* O_at_517_6 (combinational)
* O_af_517_6 (combinational)
* O_at_518_6 (combinational)
* O_af_518_6 (combinational)
* O_at_519_6 (combinational)
* O_af_519_6 (combinational)
* O_at_520_6 (combinational)
* O_af_520_6 (combinational)
* O_at_521_6 (combinational)
* O_af_521_6 (combinational)
* O_at_522_6 (combinational)
* O_af_522_6 (combinational)
* O_at_523_6 (combinational)
* O_af_523_6 (combinational)
* O_at_524_6 (combinational)
* O_af_524_6 (combinational)
* O_at_525_6 (combinational)
* O_af_525_6 (combinational)
* O_at_526_6 (combinational)
* O_af_526_6 (combinational)
* O_at_527_6 (combinational)
* O_af_527_6 (combinational)
* O_at_528_6 (combinational)
* O_af_528_6 (combinational)
* O_at_529_6 (combinational)
* O_af_529_6 (combinational)
* O_at_530_6 (combinational)
* O_af_530_6 (combinational)
* O_at_531_6 (combinational)
* O_af_531_6 (combinational)
*
* --- end node flags ---
*
M0_ Vdd __cht c Vdd pmos W=0.1625U L=0.065U
M1_ Vdd C_at_50_6 #16 Vdd pmos W=0.1625U L=0.065U
M2_ Vdd __it0 #17 Vdd pmos W=0.1625U L=0.065U
M3_ Vdd __if0 #22 Vdd pmos W=0.1625U L=0.065U
M4_ Vdd __j #28 Vdd pmos W=0.1625U L=0.065U
M5_ Vdd __v __j Vdd pmos W=0.1625U L=0.065U
M6_ Vdd __r __j Vdd pmos W=0.1625U L=0.065U
M7_ Vdd __j I_aa Vdd pmos W=0.1625U L=0.065U
M8_ Vdd __oa I_aa Vdd pmos W=0.1625U L=0.065U
M9_ Vdd I_at_50_6 __ot_50_6 Vdd pmos W=0.1625U L=0.065U
M10_ Vdd I_af_50_6 __of_50_6 Vdd pmos W=0.1625U L=0.065U
M11_ Vdd I_at_51_6 __ot_51_6 Vdd pmos W=0.1625U L=0.065U
M12_ Vdd I_af_51_6 __of_51_6 Vdd pmos W=0.1625U L=0.065U
M13_ Vdd I_at_52_6 __ot_52_6 Vdd pmos W=0.1625U L=0.065U
M14_ Vdd I_af_52_6 __of_52_6 Vdd pmos W=0.1625U L=0.065U
M15_ Vdd I_at_53_6 __ot_53_6 Vdd pmos W=0.1625U L=0.065U
M16_ Vdd I_af_53_6 __of_53_6 Vdd pmos W=0.1625U L=0.065U
M17_ Vdd I_at_54_6 __ot_54_6 Vdd pmos W=0.1625U L=0.065U
M18_ Vdd I_af_54_6 __of_54_6 Vdd pmos W=0.1625U L=0.065U
M19_ Vdd I_at_55_6 __ot_55_6 Vdd pmos W=0.1625U L=0.065U
M20_ Vdd I_af_55_6 __of_55_6 Vdd pmos W=0.1625U L=0.065U
M21_ Vdd I_at_56_6 __ot_56_6 Vdd pmos W=0.1625U L=0.065U
M22_ Vdd I_af_56_6 __of_56_6 Vdd pmos W=0.1625U L=0.065U
M23_ Vdd I_at_57_6 __ot_57_6 Vdd pmos W=0.1625U L=0.065U
M24_ Vdd I_af_57_6 __of_57_6 Vdd pmos W=0.1625U L=0.065U
M25_ Vdd I_at_58_6 __ot_58_6 Vdd pmos W=0.1625U L=0.065U
M26_ Vdd I_af_58_6 __of_58_6 Vdd pmos W=0.1625U L=0.065U
M27_ Vdd I_at_59_6 __ot_59_6 Vdd pmos W=0.1625U L=0.065U
M28_ Vdd I_af_59_6 __of_59_6 Vdd pmos W=0.1625U L=0.065U
M29_ Vdd I_at_510_6 __ot_510_6 Vdd pmos W=0.1625U L=0.065U
M30_ Vdd I_af_510_6 __of_510_6 Vdd pmos W=0.1625U L=0.065U
M31_ Vdd I_at_511_6 __ot_511_6 Vdd pmos W=0.1625U L=0.065U
M32_ Vdd I_af_511_6 __of_511_6 Vdd pmos W=0.1625U L=0.065U
M33_ Vdd I_at_512_6 __ot_512_6 Vdd pmos W=0.1625U L=0.065U
M34_ Vdd I_af_512_6 __of_512_6 Vdd pmos W=0.1625U L=0.065U
M35_ Vdd I_at_513_6 __ot_513_6 Vdd pmos W=0.1625U L=0.065U
M36_ Vdd I_af_513_6 __of_513_6 Vdd pmos W=0.1625U L=0.065U
M37_ Vdd I_at_514_6 __ot_514_6 Vdd pmos W=0.1625U L=0.065U
M38_ Vdd I_af_514_6 __of_514_6 Vdd pmos W=0.1625U L=0.065U
M39_ Vdd I_at_515_6 __ot_515_6 Vdd pmos W=0.1625U L=0.065U
M40_ Vdd I_af_515_6 __of_515_6 Vdd pmos W=0.1625U L=0.065U
M41_ Vdd I_at_516_6 __ot_516_6 Vdd pmos W=0.1625U L=0.065U
M42_ Vdd I_af_516_6 __of_516_6 Vdd pmos W=0.1625U L=0.065U
M43_ Vdd I_at_517_6 __ot_517_6 Vdd pmos W=0.1625U L=0.065U
M44_ Vdd I_af_517_6 __of_517_6 Vdd pmos W=0.1625U L=0.065U
M45_ Vdd I_at_518_6 __ot_518_6 Vdd pmos W=0.1625U L=0.065U
M46_ Vdd I_af_518_6 __of_518_6 Vdd pmos W=0.1625U L=0.065U
M47_ Vdd I_at_519_6 __ot_519_6 Vdd pmos W=0.1625U L=0.065U
M48_ Vdd I_af_519_6 __of_519_6 Vdd pmos W=0.1625U L=0.065U
M49_ Vdd I_at_520_6 __ot_520_6 Vdd pmos W=0.1625U L=0.065U
M50_ Vdd I_af_520_6 __of_520_6 Vdd pmos W=0.1625U L=0.065U
M51_ Vdd I_at_521_6 __ot_521_6 Vdd pmos W=0.1625U L=0.065U
M52_ Vdd I_af_521_6 __of_521_6 Vdd pmos W=0.1625U L=0.065U
M53_ Vdd I_at_522_6 __ot_522_6 Vdd pmos W=0.1625U L=0.065U
M54_ Vdd I_af_522_6 __of_522_6 Vdd pmos W=0.1625U L=0.065U
M55_ Vdd I_at_523_6 __ot_523_6 Vdd pmos W=0.1625U L=0.065U
M56_ Vdd I_af_523_6 __of_523_6 Vdd pmos W=0.1625U L=0.065U
M57_ Vdd I_at_524_6 __ot_524_6 Vdd pmos W=0.1625U L=0.065U
M58_ Vdd I_af_524_6 __of_524_6 Vdd pmos W=0.1625U L=0.065U
M59_ Vdd I_at_525_6 __ot_525_6 Vdd pmos W=0.1625U L=0.065U
M60_ Vdd I_af_525_6 __of_525_6 Vdd pmos W=0.1625U L=0.065U
M61_ Vdd I_at_526_6 __ot_526_6 Vdd pmos W=0.1625U L=0.065U
M62_ Vdd I_af_526_6 __of_526_6 Vdd pmos W=0.1625U L=0.065U
M63_ Vdd I_at_527_6 __ot_527_6 Vdd pmos W=0.1625U L=0.065U
M64_ Vdd I_af_527_6 __of_527_6 Vdd pmos W=0.1625U L=0.065U
M65_ Vdd I_at_528_6 __ot_528_6 Vdd pmos W=0.1625U L=0.065U
M66_ Vdd I_af_528_6 __of_528_6 Vdd pmos W=0.1625U L=0.065U
M67_ Vdd I_at_529_6 __ot_529_6 Vdd pmos W=0.1625U L=0.065U
M68_ Vdd I_af_529_6 __of_529_6 Vdd pmos W=0.1625U L=0.065U
M69_ Vdd I_at_530_6 __ot_530_6 Vdd pmos W=0.1625U L=0.065U
M70_ Vdd I_af_530_6 __of_530_6 Vdd pmos W=0.1625U L=0.065U
M71_ Vdd I_at_531_6 __ot_531_6 Vdd pmos W=0.1625U L=0.065U
M72_ Vdd I_af_531_6 __of_531_6 Vdd pmos W=0.1625U L=0.065U
M73_ Vdd C_at_50_6 __cht Vdd pmos W=0.1625U L=0.065U
M74_ Vdd c __c Vdd pmos W=0.1625U L=0.065U
M75_ Vdd O_aa __oa Vdd pmos W=0.1625U L=0.065U
M76_ Vdd I_aa __ia Vdd pmos W=0.1625U L=0.065U
M77_ Vdd v __v Vdd pmos W=0.1625U L=0.065U
M78_ Vdd reset __r Vdd pmos W=0.1625U L=0.065U
M79_ Vdd w0 __w0 Vdd pmos W=0.1625U L=0.065U
M80_ Vdd w1 __w1 Vdd pmos W=0.1625U L=0.065U
M81_ Vdd I_at_50_6 __it0 Vdd pmos W=0.1625U L=0.065U
M82_ Vdd I_af_50_6 __if0 Vdd pmos W=0.1625U L=0.065U
M83_ Vdd __cha C_aa Vdd pmos W=0.1625U L=0.065U
M84_ Vdd __ot_50_6 O_at_50_6 Vdd pmos W=0.1625U L=0.065U
M85_ Vdd __of_50_6 O_af_50_6 Vdd pmos W=0.1625U L=0.065U
M86_ Vdd __ot_51_6 O_at_51_6 Vdd pmos W=0.1625U L=0.065U
M87_ Vdd __of_51_6 O_af_51_6 Vdd pmos W=0.1625U L=0.065U
M88_ Vdd __ot_52_6 O_at_52_6 Vdd pmos W=0.1625U L=0.065U
M89_ Vdd __of_52_6 O_af_52_6 Vdd pmos W=0.1625U L=0.065U
M90_ Vdd __ot_53_6 O_at_53_6 Vdd pmos W=0.1625U L=0.065U
M91_ Vdd __of_53_6 O_af_53_6 Vdd pmos W=0.1625U L=0.065U
M92_ Vdd __ot_54_6 O_at_54_6 Vdd pmos W=0.1625U L=0.065U
M93_ Vdd __of_54_6 O_af_54_6 Vdd pmos W=0.1625U L=0.065U
M94_ Vdd __ot_55_6 O_at_55_6 Vdd pmos W=0.1625U L=0.065U
M95_ Vdd __of_55_6 O_af_55_6 Vdd pmos W=0.1625U L=0.065U
M96_ Vdd __ot_56_6 O_at_56_6 Vdd pmos W=0.1625U L=0.065U
M97_ Vdd __of_56_6 O_af_56_6 Vdd pmos W=0.1625U L=0.065U
M98_ Vdd __ot_57_6 O_at_57_6 Vdd pmos W=0.1625U L=0.065U
M99_ Vdd __of_57_6 O_af_57_6 Vdd pmos W=0.1625U L=0.065U
M100_ Vdd __ot_58_6 O_at_58_6 Vdd pmos W=0.1625U L=0.065U
M101_ Vdd __of_58_6 O_af_58_6 Vdd pmos W=0.1625U L=0.065U
M102_ Vdd __ot_59_6 O_at_59_6 Vdd pmos W=0.1625U L=0.065U
M103_ Vdd __of_59_6 O_af_59_6 Vdd pmos W=0.1625U L=0.065U
M104_ Vdd __ot_510_6 O_at_510_6 Vdd pmos W=0.1625U L=0.065U
M105_ Vdd __of_510_6 O_af_510_6 Vdd pmos W=0.1625U L=0.065U
M106_ Vdd __ot_511_6 O_at_511_6 Vdd pmos W=0.1625U L=0.065U
M107_ Vdd __of_511_6 O_af_511_6 Vdd pmos W=0.1625U L=0.065U
M108_ Vdd __ot_512_6 O_at_512_6 Vdd pmos W=0.1625U L=0.065U
M109_ Vdd __of_512_6 O_af_512_6 Vdd pmos W=0.1625U L=0.065U
M110_ Vdd __ot_513_6 O_at_513_6 Vdd pmos W=0.1625U L=0.065U
M111_ Vdd __of_513_6 O_af_513_6 Vdd pmos W=0.1625U L=0.065U
M112_ Vdd __ot_514_6 O_at_514_6 Vdd pmos W=0.1625U L=0.065U
M113_ Vdd __of_514_6 O_af_514_6 Vdd pmos W=0.1625U L=0.065U
M114_ Vdd __ot_515_6 O_at_515_6 Vdd pmos W=0.1625U L=0.065U
M115_ Vdd __of_515_6 O_af_515_6 Vdd pmos W=0.1625U L=0.065U
M116_ Vdd __ot_516_6 O_at_516_6 Vdd pmos W=0.1625U L=0.065U
M117_ Vdd __of_516_6 O_af_516_6 Vdd pmos W=0.1625U L=0.065U
M118_ Vdd __ot_517_6 O_at_517_6 Vdd pmos W=0.1625U L=0.065U
M119_ Vdd __of_517_6 O_af_517_6 Vdd pmos W=0.1625U L=0.065U
M120_ Vdd __ot_518_6 O_at_518_6 Vdd pmos W=0.1625U L=0.065U
M121_ Vdd __of_518_6 O_af_518_6 Vdd pmos W=0.1625U L=0.065U
M122_ Vdd __ot_519_6 O_at_519_6 Vdd pmos W=0.1625U L=0.065U
M123_ Vdd __of_519_6 O_af_519_6 Vdd pmos W=0.1625U L=0.065U
M124_ Vdd __ot_520_6 O_at_520_6 Vdd pmos W=0.1625U L=0.065U
M125_ Vdd __of_520_6 O_af_520_6 Vdd pmos W=0.1625U L=0.065U
M126_ Vdd __ot_521_6 O_at_521_6 Vdd pmos W=0.1625U L=0.065U
M127_ Vdd __of_521_6 O_af_521_6 Vdd pmos W=0.1625U L=0.065U
M128_ Vdd __ot_522_6 O_at_522_6 Vdd pmos W=0.1625U L=0.065U
M129_ Vdd __of_522_6 O_af_522_6 Vdd pmos W=0.1625U L=0.065U
M130_ Vdd __ot_523_6 O_at_523_6 Vdd pmos W=0.1625U L=0.065U
M131_ Vdd __of_523_6 O_af_523_6 Vdd pmos W=0.1625U L=0.065U
M132_ Vdd __ot_524_6 O_at_524_6 Vdd pmos W=0.1625U L=0.065U
M133_ Vdd __of_524_6 O_af_524_6 Vdd pmos W=0.1625U L=0.065U
M134_ Vdd __ot_525_6 O_at_525_6 Vdd pmos W=0.1625U L=0.065U
M135_ Vdd __of_525_6 O_af_525_6 Vdd pmos W=0.1625U L=0.065U
M136_ Vdd __ot_526_6 O_at_526_6 Vdd pmos W=0.1625U L=0.065U
M137_ Vdd __of_526_6 O_af_526_6 Vdd pmos W=0.1625U L=0.065U
M138_ Vdd __ot_527_6 O_at_527_6 Vdd pmos W=0.1625U L=0.065U
M139_ Vdd __of_527_6 O_af_527_6 Vdd pmos W=0.1625U L=0.065U
M140_ Vdd __ot_528_6 O_at_528_6 Vdd pmos W=0.1625U L=0.065U
M141_ Vdd __of_528_6 O_af_528_6 Vdd pmos W=0.1625U L=0.065U
M142_ Vdd __ot_529_6 O_at_529_6 Vdd pmos W=0.1625U L=0.065U
M143_ Vdd __of_529_6 O_af_529_6 Vdd pmos W=0.1625U L=0.065U
M144_ Vdd __ot_530_6 O_at_530_6 Vdd pmos W=0.1625U L=0.065U
M145_ Vdd __of_530_6 O_af_530_6 Vdd pmos W=0.1625U L=0.065U
M146_ Vdd __ot_531_6 O_at_531_6 Vdd pmos W=0.1625U L=0.065U
M147_ Vdd __of_531_6 O_af_531_6 Vdd pmos W=0.1625U L=0.065U
M148_ Vdd c #fb361# Vdd pmos W=0.1625U L=0.13U
M149_ Vdd w0 #fb364# Vdd pmos W=0.1625U L=0.13U
M150_keeper Vdd GND #362 Vdd pmos W=0.0975U L=0.91U
M151_ Vdd I_aa #fb367# Vdd pmos W=0.1625U L=0.13U
M152_keeper Vdd GND #365 Vdd pmos W=0.0975U L=0.91U
M153_ Vdd __cha #fb370# Vdd pmos W=0.1625U L=0.13U
M154_keeper Vdd GND #368 Vdd pmos W=0.0975U L=1.235U
M155_ Vdd w1 #fb373# Vdd pmos W=0.1625U L=0.13U
M156_keeper Vdd GND #371 Vdd pmos W=0.0975U L=0.585U
M157_ Vdd v #fb376# Vdd pmos W=0.1625U L=0.13U
M158_keeper Vdd GND #374 Vdd pmos W=0.0975U L=0.91U
M159_ Vdd __j #fb379# Vdd pmos W=0.1625U L=0.13U
M160_keeper Vdd GND #377 Vdd pmos W=0.0975U L=0.26U
M161_ Vdd __ot_50_6 #fb382# Vdd pmos W=0.1625U L=0.13U
M162_keeper Vdd GND #380 Vdd pmos W=0.0975U L=0.91U
M163_ Vdd __of_50_6 #fb385# Vdd pmos W=0.1625U L=0.13U
M164_keeper Vdd GND #383 Vdd pmos W=0.0975U L=0.585U
M165_ Vdd __ot_51_6 #fb388# Vdd pmos W=0.1625U L=0.13U
M166_keeper Vdd GND #386 Vdd pmos W=0.0975U L=0.585U
M167_ Vdd __of_51_6 #fb391# Vdd pmos W=0.1625U L=0.13U
M168_keeper Vdd GND #389 Vdd pmos W=0.0975U L=0.585U
M169_ Vdd __ot_52_6 #fb394# Vdd pmos W=0.1625U L=0.13U
M170_keeper Vdd GND #392 Vdd pmos W=0.0975U L=0.585U
M171_ Vdd __of_52_6 #fb397# Vdd pmos W=0.1625U L=0.13U
M172_keeper Vdd GND #395 Vdd pmos W=0.0975U L=0.585U
M173_ Vdd __ot_53_6 #fb400# Vdd pmos W=0.1625U L=0.13U
M174_keeper Vdd GND #398 Vdd pmos W=0.0975U L=0.585U
M175_ Vdd __of_53_6 #fb403# Vdd pmos W=0.1625U L=0.13U
M176_keeper Vdd GND #401 Vdd pmos W=0.0975U L=0.585U
M177_ Vdd __ot_54_6 #fb406# Vdd pmos W=0.1625U L=0.13U
M178_keeper Vdd GND #404 Vdd pmos W=0.0975U L=0.585U
M179_ Vdd __of_54_6 #fb409# Vdd pmos W=0.1625U L=0.13U
M180_keeper Vdd GND #407 Vdd pmos W=0.0975U L=0.585U
M181_ Vdd __ot_55_6 #fb412# Vdd pmos W=0.1625U L=0.13U
M182_keeper Vdd GND #410 Vdd pmos W=0.0975U L=0.585U
M183_ Vdd __of_55_6 #fb415# Vdd pmos W=0.1625U L=0.13U
M184_keeper Vdd GND #413 Vdd pmos W=0.0975U L=0.585U
M185_ Vdd __ot_56_6 #fb418# Vdd pmos W=0.1625U L=0.13U
M186_keeper Vdd GND #416 Vdd pmos W=0.0975U L=0.585U
M187_ Vdd __of_56_6 #fb421# Vdd pmos W=0.1625U L=0.13U
M188_keeper Vdd GND #419 Vdd pmos W=0.0975U L=0.585U
M189_ Vdd __ot_57_6 #fb424# Vdd pmos W=0.1625U L=0.13U
M190_keeper Vdd GND #422 Vdd pmos W=0.0975U L=0.585U
M191_ Vdd __of_57_6 #fb427# Vdd pmos W=0.1625U L=0.13U
M192_keeper Vdd GND #425 Vdd pmos W=0.0975U L=0.585U
M193_ Vdd __ot_58_6 #fb430# Vdd pmos W=0.1625U L=0.13U
M194_keeper Vdd GND #428 Vdd pmos W=0.0975U L=0.585U
M195_ Vdd __of_58_6 #fb433# Vdd pmos W=0.1625U L=0.13U
M196_keeper Vdd GND #431 Vdd pmos W=0.0975U L=0.585U
M197_ Vdd __ot_59_6 #fb436# Vdd pmos W=0.1625U L=0.13U
M198_keeper Vdd GND #434 Vdd pmos W=0.0975U L=0.585U
M199_ Vdd __of_59_6 #fb439# Vdd pmos W=0.1625U L=0.13U
M200_keeper Vdd GND #437 Vdd pmos W=0.0975U L=0.585U
M201_ Vdd __ot_510_6 #fb442# Vdd pmos W=0.1625U L=0.13U
M202_keeper Vdd GND #440 Vdd pmos W=0.0975U L=0.585U
M203_ Vdd __of_510_6 #fb445# Vdd pmos W=0.1625U L=0.13U
M204_keeper Vdd GND #443 Vdd pmos W=0.0975U L=0.585U
M205_ Vdd __ot_511_6 #fb448# Vdd pmos W=0.1625U L=0.13U
M206_keeper Vdd GND #446 Vdd pmos W=0.0975U L=0.585U
M207_ Vdd __of_511_6 #fb451# Vdd pmos W=0.1625U L=0.13U
M208_keeper Vdd GND #449 Vdd pmos W=0.0975U L=0.585U
M209_ Vdd __ot_512_6 #fb454# Vdd pmos W=0.1625U L=0.13U
M210_keeper Vdd GND #452 Vdd pmos W=0.0975U L=0.585U
M211_ Vdd __of_512_6 #fb457# Vdd pmos W=0.1625U L=0.13U
M212_keeper Vdd GND #455 Vdd pmos W=0.0975U L=0.585U
M213_ Vdd __ot_513_6 #fb460# Vdd pmos W=0.1625U L=0.13U
M214_keeper Vdd GND #458 Vdd pmos W=0.0975U L=0.585U
M215_ Vdd __of_513_6 #fb463# Vdd pmos W=0.1625U L=0.13U
M216_keeper Vdd GND #461 Vdd pmos W=0.0975U L=0.585U
M217_ Vdd __ot_514_6 #fb466# Vdd pmos W=0.1625U L=0.13U
M218_keeper Vdd GND #464 Vdd pmos W=0.0975U L=0.585U
M219_ Vdd __of_514_6 #fb469# Vdd pmos W=0.1625U L=0.13U
M220_keeper Vdd GND #467 Vdd pmos W=0.0975U L=0.585U
M221_ Vdd __ot_515_6 #fb472# Vdd pmos W=0.1625U L=0.13U
M222_keeper Vdd GND #470 Vdd pmos W=0.0975U L=0.585U
M223_ Vdd __of_515_6 #fb475# Vdd pmos W=0.1625U L=0.13U
M224_keeper Vdd GND #473 Vdd pmos W=0.0975U L=0.585U
M225_ Vdd __ot_516_6 #fb478# Vdd pmos W=0.1625U L=0.13U
M226_keeper Vdd GND #476 Vdd pmos W=0.0975U L=0.585U
M227_ Vdd __of_516_6 #fb481# Vdd pmos W=0.1625U L=0.13U
M228_keeper Vdd GND #479 Vdd pmos W=0.0975U L=0.585U
M229_ Vdd __ot_517_6 #fb484# Vdd pmos W=0.1625U L=0.13U
M230_keeper Vdd GND #482 Vdd pmos W=0.0975U L=0.585U
M231_ Vdd __of_517_6 #fb487# Vdd pmos W=0.1625U L=0.13U
M232_keeper Vdd GND #485 Vdd pmos W=0.0975U L=0.585U
M233_ Vdd __ot_518_6 #fb490# Vdd pmos W=0.1625U L=0.13U
M234_keeper Vdd GND #488 Vdd pmos W=0.0975U L=0.585U
M235_ Vdd __of_518_6 #fb493# Vdd pmos W=0.1625U L=0.13U
M236_keeper Vdd GND #491 Vdd pmos W=0.0975U L=0.585U
M237_ Vdd __ot_519_6 #fb496# Vdd pmos W=0.1625U L=0.13U
M238_keeper Vdd GND #494 Vdd pmos W=0.0975U L=0.585U
M239_ Vdd __of_519_6 #fb499# Vdd pmos W=0.1625U L=0.13U
M240_keeper Vdd GND #497 Vdd pmos W=0.0975U L=0.585U
M241_ Vdd __ot_520_6 #fb502# Vdd pmos W=0.1625U L=0.13U
M242_keeper Vdd GND #500 Vdd pmos W=0.0975U L=0.585U
M243_ Vdd __of_520_6 #fb505# Vdd pmos W=0.1625U L=0.13U
M244_keeper Vdd GND #503 Vdd pmos W=0.0975U L=0.585U
M245_ Vdd __ot_521_6 #fb508# Vdd pmos W=0.1625U L=0.13U
M246_keeper Vdd GND #506 Vdd pmos W=0.0975U L=0.585U
M247_ Vdd __of_521_6 #fb511# Vdd pmos W=0.1625U L=0.13U
M248_keeper Vdd GND #509 Vdd pmos W=0.0975U L=0.585U
M249_ Vdd __ot_522_6 #fb514# Vdd pmos W=0.1625U L=0.13U
M250_keeper Vdd GND #512 Vdd pmos W=0.0975U L=0.585U
M251_ Vdd __of_522_6 #fb517# Vdd pmos W=0.1625U L=0.13U
M252_keeper Vdd GND #515 Vdd pmos W=0.0975U L=0.585U
M253_ Vdd __ot_523_6 #fb520# Vdd pmos W=0.1625U L=0.13U
M254_keeper Vdd GND #518 Vdd pmos W=0.0975U L=0.585U
M255_ Vdd __of_523_6 #fb523# Vdd pmos W=0.1625U L=0.13U
M256_keeper Vdd GND #521 Vdd pmos W=0.0975U L=0.585U
M257_ Vdd __ot_524_6 #fb526# Vdd pmos W=0.1625U L=0.13U
M258_keeper Vdd GND #524 Vdd pmos W=0.0975U L=0.585U
M259_ Vdd __of_524_6 #fb529# Vdd pmos W=0.1625U L=0.13U
M260_keeper Vdd GND #527 Vdd pmos W=0.0975U L=0.585U
M261_ Vdd __ot_525_6 #fb532# Vdd pmos W=0.1625U L=0.13U
M262_keeper Vdd GND #530 Vdd pmos W=0.0975U L=0.585U
M263_ Vdd __of_525_6 #fb535# Vdd pmos W=0.1625U L=0.13U
M264_keeper Vdd GND #533 Vdd pmos W=0.0975U L=0.585U
M265_ Vdd __ot_526_6 #fb538# Vdd pmos W=0.1625U L=0.13U
M266_keeper Vdd GND #536 Vdd pmos W=0.0975U L=0.585U
M267_ Vdd __of_526_6 #fb541# Vdd pmos W=0.1625U L=0.13U
M268_keeper Vdd GND #539 Vdd pmos W=0.0975U L=0.585U
M269_ Vdd __ot_527_6 #fb544# Vdd pmos W=0.1625U L=0.13U
M270_keeper Vdd GND #542 Vdd pmos W=0.0975U L=0.585U
M271_ Vdd __of_527_6 #fb547# Vdd pmos W=0.1625U L=0.13U
M272_keeper Vdd GND #545 Vdd pmos W=0.0975U L=0.585U
M273_ Vdd __ot_528_6 #fb550# Vdd pmos W=0.1625U L=0.13U
M274_keeper Vdd GND #548 Vdd pmos W=0.0975U L=0.585U
M275_ Vdd __of_528_6 #fb553# Vdd pmos W=0.1625U L=0.13U
M276_keeper Vdd GND #551 Vdd pmos W=0.0975U L=0.585U
M277_ Vdd __ot_529_6 #fb556# Vdd pmos W=0.1625U L=0.13U
M278_keeper Vdd GND #554 Vdd pmos W=0.0975U L=0.585U
M279_ Vdd __of_529_6 #fb559# Vdd pmos W=0.1625U L=0.13U
M280_keeper Vdd GND #557 Vdd pmos W=0.0975U L=0.585U
M281_ Vdd __ot_530_6 #fb562# Vdd pmos W=0.1625U L=0.13U
M282_keeper Vdd GND #560 Vdd pmos W=0.0975U L=0.585U
M283_ Vdd __of_530_6 #fb565# Vdd pmos W=0.1625U L=0.13U
M284_keeper Vdd GND #563 Vdd pmos W=0.0975U L=0.585U
M285_ Vdd __ot_531_6 #fb568# Vdd pmos W=0.1625U L=0.13U
M286_keeper Vdd GND #566 Vdd pmos W=0.0975U L=0.585U
M287_ Vdd __of_531_6 #fb571# Vdd pmos W=0.1625U L=0.13U
M288_keeper Vdd GND #569 Vdd pmos W=0.0975U L=0.585U
M289_keeper Vdd GND #572 Vdd pmos W=0.0975U L=0.585U
M290_ GND w0 #5 GND nmos W=0.0975U L=0.065U
M291_ GND reset c GND nmos W=0.0975U L=0.065U
M292_ GND C_at_50_6 #11 GND nmos W=0.0975U L=0.065U
M293_ GND C_af_50_6 #13 GND nmos W=0.0975U L=0.065U
M294_ GND __c #20 GND nmos W=0.0975U L=0.065U
M295_ GND reset w0 GND nmos W=0.0975U L=0.065U
M296_ GND c #25 GND nmos W=0.0975U L=0.065U
M297_ GND reset w1 GND nmos W=0.0975U L=0.065U
M298_ GND __ia v GND nmos W=0.0975U L=0.065U
M299_ GND reset v GND nmos W=0.0975U L=0.065U
M300_ GND __v #159 GND nmos W=0.0975U L=0.065U
M301_ GND __j #162 GND nmos W=0.0975U L=0.065U
M302_ GND reset I_aa GND nmos W=0.0975U L=0.065U
M303_ GND c #168 GND nmos W=0.0975U L=0.065U
M304_ GND c #170 GND nmos W=0.0975U L=0.065U
M305_ GND c #172 GND nmos W=0.0975U L=0.065U
M306_ GND c #174 GND nmos W=0.0975U L=0.065U
M307_ GND c #176 GND nmos W=0.0975U L=0.065U
M308_ GND c #178 GND nmos W=0.0975U L=0.065U
M309_ GND c #180 GND nmos W=0.0975U L=0.065U
M310_ GND c #182 GND nmos W=0.0975U L=0.065U
M311_ GND c #184 GND nmos W=0.0975U L=0.065U
M312_ GND c #186 GND nmos W=0.0975U L=0.065U
M313_ GND c #188 GND nmos W=0.0975U L=0.065U
M314_ GND c #190 GND nmos W=0.0975U L=0.065U
M315_ GND c #192 GND nmos W=0.0975U L=0.065U
M316_ GND c #194 GND nmos W=0.0975U L=0.065U
M317_ GND c #196 GND nmos W=0.0975U L=0.065U
M318_ GND c #198 GND nmos W=0.0975U L=0.065U
M319_ GND c #200 GND nmos W=0.0975U L=0.065U
M320_ GND c #202 GND nmos W=0.0975U L=0.065U
M321_ GND c #204 GND nmos W=0.0975U L=0.065U
M322_ GND c #206 GND nmos W=0.0975U L=0.065U
M323_ GND c #208 GND nmos W=0.0975U L=0.065U
M324_ GND c #210 GND nmos W=0.0975U L=0.065U
M325_ GND c #212 GND nmos W=0.0975U L=0.065U
M326_ GND c #214 GND nmos W=0.0975U L=0.065U
M327_ GND c #216 GND nmos W=0.0975U L=0.065U
M328_ GND c #218 GND nmos W=0.0975U L=0.065U
M329_ GND c #220 GND nmos W=0.0975U L=0.065U
M330_ GND c #222 GND nmos W=0.0975U L=0.065U
M331_ GND c #224 GND nmos W=0.0975U L=0.065U
M332_ GND c #226 GND nmos W=0.0975U L=0.065U
M333_ GND c #228 GND nmos W=0.0975U L=0.065U
M334_ GND c #230 GND nmos W=0.0975U L=0.065U
M335_ GND c #232 GND nmos W=0.0975U L=0.065U
M336_ GND c #234 GND nmos W=0.0975U L=0.065U
M337_ GND c #236 GND nmos W=0.0975U L=0.065U
M338_ GND c #238 GND nmos W=0.0975U L=0.065U
M339_ GND c #240 GND nmos W=0.0975U L=0.065U
M340_ GND c #242 GND nmos W=0.0975U L=0.065U
M341_ GND c #244 GND nmos W=0.0975U L=0.065U
M342_ GND c #246 GND nmos W=0.0975U L=0.065U
M343_ GND c #248 GND nmos W=0.0975U L=0.065U
M344_ GND c #250 GND nmos W=0.0975U L=0.065U
M345_ GND c #252 GND nmos W=0.0975U L=0.065U
M346_ GND c #254 GND nmos W=0.0975U L=0.065U
M347_ GND c #256 GND nmos W=0.0975U L=0.065U
M348_ GND c #258 GND nmos W=0.0975U L=0.065U
M349_ GND c #260 GND nmos W=0.0975U L=0.065U
M350_ GND c #262 GND nmos W=0.0975U L=0.065U
M351_ GND c #264 GND nmos W=0.0975U L=0.065U
M352_ GND c #266 GND nmos W=0.0975U L=0.065U
M353_ GND c #268 GND nmos W=0.0975U L=0.065U
M354_ GND c #270 GND nmos W=0.0975U L=0.065U
M355_ GND c #272 GND nmos W=0.0975U L=0.065U
M356_ GND c #274 GND nmos W=0.0975U L=0.065U
M357_ GND c #276 GND nmos W=0.0975U L=0.065U
M358_ GND c #278 GND nmos W=0.0975U L=0.065U
M359_ GND c #280 GND nmos W=0.0975U L=0.065U
M360_ GND c #282 GND nmos W=0.0975U L=0.065U
M361_ GND c #284 GND nmos W=0.0975U L=0.065U
M362_ GND c #286 GND nmos W=0.0975U L=0.065U
M363_ GND c #288 GND nmos W=0.0975U L=0.065U
M364_ GND c #290 GND nmos W=0.0975U L=0.065U
M365_ GND c #292 GND nmos W=0.0975U L=0.065U
M366_ GND c #294 GND nmos W=0.0975U L=0.065U
M367_ GND C_at_50_6 __cht GND nmos W=0.0975U L=0.065U
M368_ GND c __c GND nmos W=0.0975U L=0.065U
M369_ GND O_aa __oa GND nmos W=0.0975U L=0.065U
M370_ GND I_aa __ia GND nmos W=0.0975U L=0.065U
M371_ GND v __v GND nmos W=0.0975U L=0.065U
M372_ GND reset __r GND nmos W=0.0975U L=0.065U
M373_ GND w0 __w0 GND nmos W=0.0975U L=0.065U
M374_ GND w1 __w1 GND nmos W=0.0975U L=0.065U
M375_ GND I_at_50_6 __it0 GND nmos W=0.0975U L=0.065U
M376_ GND I_af_50_6 __if0 GND nmos W=0.0975U L=0.065U
M377_ GND __cha C_aa GND nmos W=0.0975U L=0.065U
M378_ GND __ot_50_6 O_at_50_6 GND nmos W=0.0975U L=0.065U
M379_ GND __of_50_6 O_af_50_6 GND nmos W=0.0975U L=0.065U
M380_ GND __ot_51_6 O_at_51_6 GND nmos W=0.0975U L=0.065U
M381_ GND __of_51_6 O_af_51_6 GND nmos W=0.0975U L=0.065U
M382_ GND __ot_52_6 O_at_52_6 GND nmos W=0.0975U L=0.065U
M383_ GND __of_52_6 O_af_52_6 GND nmos W=0.0975U L=0.065U
M384_ GND __ot_53_6 O_at_53_6 GND nmos W=0.0975U L=0.065U
M385_ GND __of_53_6 O_af_53_6 GND nmos W=0.0975U L=0.065U
M386_ GND __ot_54_6 O_at_54_6 GND nmos W=0.0975U L=0.065U
M387_ GND __of_54_6 O_af_54_6 GND nmos W=0.0975U L=0.065U
M388_ GND __ot_55_6 O_at_55_6 GND nmos W=0.0975U L=0.065U
M389_ GND __of_55_6 O_af_55_6 GND nmos W=0.0975U L=0.065U
M390_ GND __ot_56_6 O_at_56_6 GND nmos W=0.0975U L=0.065U
M391_ GND __of_56_6 O_af_56_6 GND nmos W=0.0975U L=0.065U
M392_ GND __ot_57_6 O_at_57_6 GND nmos W=0.0975U L=0.065U
M393_ GND __of_57_6 O_af_57_6 GND nmos W=0.0975U L=0.065U
M394_ GND __ot_58_6 O_at_58_6 GND nmos W=0.0975U L=0.065U
M395_ GND __of_58_6 O_af_58_6 GND nmos W=0.0975U L=0.065U
M396_ GND __ot_59_6 O_at_59_6 GND nmos W=0.0975U L=0.065U
M397_ GND __of_59_6 O_af_59_6 GND nmos W=0.0975U L=0.065U
M398_ GND __ot_510_6 O_at_510_6 GND nmos W=0.0975U L=0.065U
M399_ GND __of_510_6 O_af_510_6 GND nmos W=0.0975U L=0.065U
M400_ GND __ot_511_6 O_at_511_6 GND nmos W=0.0975U L=0.065U
M401_ GND __of_511_6 O_af_511_6 GND nmos W=0.0975U L=0.065U
M402_ GND __ot_512_6 O_at_512_6 GND nmos W=0.0975U L=0.065U
M403_ GND __of_512_6 O_af_512_6 GND nmos W=0.0975U L=0.065U
M404_ GND __ot_513_6 O_at_513_6 GND nmos W=0.0975U L=0.065U
M405_ GND __of_513_6 O_af_513_6 GND nmos W=0.0975U L=0.065U
M406_ GND __ot_514_6 O_at_514_6 GND nmos W=0.0975U L=0.065U
M407_ GND __of_514_6 O_af_514_6 GND nmos W=0.0975U L=0.065U
M408_ GND __ot_515_6 O_at_515_6 GND nmos W=0.0975U L=0.065U
M409_ GND __of_515_6 O_af_515_6 GND nmos W=0.0975U L=0.065U
M410_ GND __ot_516_6 O_at_516_6 GND nmos W=0.0975U L=0.065U
M411_ GND __of_516_6 O_af_516_6 GND nmos W=0.0975U L=0.065U
M412_ GND __ot_517_6 O_at_517_6 GND nmos W=0.0975U L=0.065U
M413_ GND __of_517_6 O_af_517_6 GND nmos W=0.0975U L=0.065U
M414_ GND __ot_518_6 O_at_518_6 GND nmos W=0.0975U L=0.065U
M415_ GND __of_518_6 O_af_518_6 GND nmos W=0.0975U L=0.065U
M416_ GND __ot_519_6 O_at_519_6 GND nmos W=0.0975U L=0.065U
M417_ GND __of_519_6 O_af_519_6 GND nmos W=0.0975U L=0.065U
M418_ GND __ot_520_6 O_at_520_6 GND nmos W=0.0975U L=0.065U
M419_ GND __of_520_6 O_af_520_6 GND nmos W=0.0975U L=0.065U
M420_ GND __ot_521_6 O_at_521_6 GND nmos W=0.0975U L=0.065U
M421_ GND __of_521_6 O_af_521_6 GND nmos W=0.0975U L=0.065U
M422_ GND __ot_522_6 O_at_522_6 GND nmos W=0.0975U L=0.065U
M423_ GND __of_522_6 O_af_522_6 GND nmos W=0.0975U L=0.065U
M424_ GND __ot_523_6 O_at_523_6 GND nmos W=0.0975U L=0.065U
M425_ GND __of_523_6 O_af_523_6 GND nmos W=0.0975U L=0.065U
M426_ GND __ot_524_6 O_at_524_6 GND nmos W=0.0975U L=0.065U
M427_ GND __of_524_6 O_af_524_6 GND nmos W=0.0975U L=0.065U
M428_ GND __ot_525_6 O_at_525_6 GND nmos W=0.0975U L=0.065U
M429_ GND __of_525_6 O_af_525_6 GND nmos W=0.0975U L=0.065U
M430_ GND __ot_526_6 O_at_526_6 GND nmos W=0.0975U L=0.065U
M431_ GND __of_526_6 O_af_526_6 GND nmos W=0.0975U L=0.065U
M432_ GND __ot_527_6 O_at_527_6 GND nmos W=0.0975U L=0.065U
M433_ GND __of_527_6 O_af_527_6 GND nmos W=0.0975U L=0.065U
M434_ GND __ot_528_6 O_at_528_6 GND nmos W=0.0975U L=0.065U
M435_ GND __of_528_6 O_af_528_6 GND nmos W=0.0975U L=0.065U
M436_ GND __ot_529_6 O_at_529_6 GND nmos W=0.0975U L=0.065U
M437_ GND __of_529_6 O_af_529_6 GND nmos W=0.0975U L=0.065U
M438_ GND __ot_530_6 O_at_530_6 GND nmos W=0.0975U L=0.065U
M439_ GND __of_530_6 O_af_530_6 GND nmos W=0.0975U L=0.065U
M440_ GND __ot_531_6 O_at_531_6 GND nmos W=0.0975U L=0.065U
M441_ GND __of_531_6 O_af_531_6 GND nmos W=0.0975U L=0.065U
M442_ GND c #fb361# GND nmos W=0.0975U L=0.13U
M443_ GND w0 #fb364# GND nmos W=0.0975U L=0.13U
M444_keeper GND Vdd #363 GND nmos W=0.0975U L=0.715U
M445_ GND I_aa #fb367# GND nmos W=0.0975U L=0.13U
M446_keeper GND Vdd #366 GND nmos W=0.0975U L=1.495U
M447_ GND __cha #fb370# GND nmos W=0.0975U L=0.13U
M448_keeper GND Vdd #369 GND nmos W=0.0975U L=0.715U
M449_ GND w1 #fb373# GND nmos W=0.0975U L=0.13U
M450_keeper GND Vdd #372 GND nmos W=0.0975U L=1.495U
M451_ GND v #fb376# GND nmos W=0.0975U L=0.13U
M452_keeper GND Vdd #375 GND nmos W=0.0975U L=1.495U
M453_ GND __j #fb379# GND nmos W=0.0975U L=0.13U
M454_keeper GND Vdd #378 GND nmos W=0.0975U L=51.415U
M455_ GND __ot_50_6 #fb382# GND nmos W=0.0975U L=0.13U
M456_keeper GND Vdd #381 GND nmos W=0.0975U L=0.715U
M457_ GND __of_50_6 #fb385# GND nmos W=0.0975U L=0.13U
M458_keeper GND Vdd #384 GND nmos W=0.0975U L=0.715U
M459_ GND __ot_51_6 #fb388# GND nmos W=0.0975U L=0.13U
M460_keeper GND Vdd #387 GND nmos W=0.0975U L=0.715U
M461_ GND __of_51_6 #fb391# GND nmos W=0.0975U L=0.13U
M462_keeper GND Vdd #390 GND nmos W=0.0975U L=0.715U
M463_ GND __ot_52_6 #fb394# GND nmos W=0.0975U L=0.13U
M464_keeper GND Vdd #393 GND nmos W=0.0975U L=0.715U
M465_ GND __of_52_6 #fb397# GND nmos W=0.0975U L=0.13U
M466_keeper GND Vdd #396 GND nmos W=0.0975U L=0.715U
M467_ GND __ot_53_6 #fb400# GND nmos W=0.0975U L=0.13U
M468_keeper GND Vdd #399 GND nmos W=0.0975U L=0.715U
M469_ GND __of_53_6 #fb403# GND nmos W=0.0975U L=0.13U
M470_keeper GND Vdd #402 GND nmos W=0.0975U L=0.715U
M471_ GND __ot_54_6 #fb406# GND nmos W=0.0975U L=0.13U
M472_keeper GND Vdd #405 GND nmos W=0.0975U L=0.715U
M473_ GND __of_54_6 #fb409# GND nmos W=0.0975U L=0.13U
M474_keeper GND Vdd #408 GND nmos W=0.0975U L=0.715U
M475_ GND __ot_55_6 #fb412# GND nmos W=0.0975U L=0.13U
M476_keeper GND Vdd #411 GND nmos W=0.0975U L=0.715U
M477_ GND __of_55_6 #fb415# GND nmos W=0.0975U L=0.13U
M478_keeper GND Vdd #414 GND nmos W=0.0975U L=0.715U
M479_ GND __ot_56_6 #fb418# GND nmos W=0.0975U L=0.13U
M480_keeper GND Vdd #417 GND nmos W=0.0975U L=0.715U
M481_ GND __of_56_6 #fb421# GND nmos W=0.0975U L=0.13U
M482_keeper GND Vdd #420 GND nmos W=0.0975U L=0.715U
M483_ GND __ot_57_6 #fb424# GND nmos W=0.0975U L=0.13U
M484_keeper GND Vdd #423 GND nmos W=0.0975U L=0.715U
M485_ GND __of_57_6 #fb427# GND nmos W=0.0975U L=0.13U
M486_keeper GND Vdd #426 GND nmos W=0.0975U L=0.715U
M487_ GND __ot_58_6 #fb430# GND nmos W=0.0975U L=0.13U
M488_keeper GND Vdd #429 GND nmos W=0.0975U L=0.715U
M489_ GND __of_58_6 #fb433# GND nmos W=0.0975U L=0.13U
M490_keeper GND Vdd #432 GND nmos W=0.0975U L=0.715U
M491_ GND __ot_59_6 #fb436# GND nmos W=0.0975U L=0.13U
M492_keeper GND Vdd #435 GND nmos W=0.0975U L=0.715U
M493_ GND __of_59_6 #fb439# GND nmos W=0.0975U L=0.13U
M494_keeper GND Vdd #438 GND nmos W=0.0975U L=0.715U
M495_ GND __ot_510_6 #fb442# GND nmos W=0.0975U L=0.13U
M496_keeper GND Vdd #441 GND nmos W=0.0975U L=0.715U
M497_ GND __of_510_6 #fb445# GND nmos W=0.0975U L=0.13U
M498_keeper GND Vdd #444 GND nmos W=0.0975U L=0.715U
M499_ GND __ot_511_6 #fb448# GND nmos W=0.0975U L=0.13U
M500_keeper GND Vdd #447 GND nmos W=0.0975U L=0.715U
M501_ GND __of_511_6 #fb451# GND nmos W=0.0975U L=0.13U
M502_keeper GND Vdd #450 GND nmos W=0.0975U L=0.715U
M503_ GND __ot_512_6 #fb454# GND nmos W=0.0975U L=0.13U
M504_keeper GND Vdd #453 GND nmos W=0.0975U L=0.715U
M505_ GND __of_512_6 #fb457# GND nmos W=0.0975U L=0.13U
M506_keeper GND Vdd #456 GND nmos W=0.0975U L=0.715U
M507_ GND __ot_513_6 #fb460# GND nmos W=0.0975U L=0.13U
M508_keeper GND Vdd #459 GND nmos W=0.0975U L=0.715U
M509_ GND __of_513_6 #fb463# GND nmos W=0.0975U L=0.13U
M510_keeper GND Vdd #462 GND nmos W=0.0975U L=0.715U
M511_ GND __ot_514_6 #fb466# GND nmos W=0.0975U L=0.13U
M512_keeper GND Vdd #465 GND nmos W=0.0975U L=0.715U
M513_ GND __of_514_6 #fb469# GND nmos W=0.0975U L=0.13U
M514_keeper GND Vdd #468 GND nmos W=0.0975U L=0.715U
M515_ GND __ot_515_6 #fb472# GND nmos W=0.0975U L=0.13U
M516_keeper GND Vdd #471 GND nmos W=0.0975U L=0.715U
M517_ GND __of_515_6 #fb475# GND nmos W=0.0975U L=0.13U
M518_keeper GND Vdd #474 GND nmos W=0.0975U L=0.715U
M519_ GND __ot_516_6 #fb478# GND nmos W=0.0975U L=0.13U
M520_keeper GND Vdd #477 GND nmos W=0.0975U L=0.715U
M521_ GND __of_516_6 #fb481# GND nmos W=0.0975U L=0.13U
M522_keeper GND Vdd #480 GND nmos W=0.0975U L=0.715U
M523_ GND __ot_517_6 #fb484# GND nmos W=0.0975U L=0.13U
M524_keeper GND Vdd #483 GND nmos W=0.0975U L=0.715U
M525_ GND __of_517_6 #fb487# GND nmos W=0.0975U L=0.13U
M526_keeper GND Vdd #486 GND nmos W=0.0975U L=0.715U
M527_ GND __ot_518_6 #fb490# GND nmos W=0.0975U L=0.13U
M528_keeper GND Vdd #489 GND nmos W=0.0975U L=0.715U
M529_ GND __of_518_6 #fb493# GND nmos W=0.0975U L=0.13U
M530_keeper GND Vdd #492 GND nmos W=0.0975U L=0.715U
M531_ GND __ot_519_6 #fb496# GND nmos W=0.0975U L=0.13U
M532_keeper GND Vdd #495 GND nmos W=0.0975U L=0.715U
M533_ GND __of_519_6 #fb499# GND nmos W=0.0975U L=0.13U
M534_keeper GND Vdd #498 GND nmos W=0.0975U L=0.715U
M535_ GND __ot_520_6 #fb502# GND nmos W=0.0975U L=0.13U
M536_keeper GND Vdd #501 GND nmos W=0.0975U L=0.715U
M537_ GND __of_520_6 #fb505# GND nmos W=0.0975U L=0.13U
M538_keeper GND Vdd #504 GND nmos W=0.0975U L=0.715U
M539_ GND __ot_521_6 #fb508# GND nmos W=0.0975U L=0.13U
M540_keeper GND Vdd #507 GND nmos W=0.0975U L=0.715U
M541_ GND __of_521_6 #fb511# GND nmos W=0.0975U L=0.13U
M542_keeper GND Vdd #510 GND nmos W=0.0975U L=0.715U
M543_ GND __ot_522_6 #fb514# GND nmos W=0.0975U L=0.13U
M544_keeper GND Vdd #513 GND nmos W=0.0975U L=0.715U
M545_ GND __of_522_6 #fb517# GND nmos W=0.0975U L=0.13U
M546_keeper GND Vdd #516 GND nmos W=0.0975U L=0.715U
M547_ GND __ot_523_6 #fb520# GND nmos W=0.0975U L=0.13U
M548_keeper GND Vdd #519 GND nmos W=0.0975U L=0.715U
M549_ GND __of_523_6 #fb523# GND nmos W=0.0975U L=0.13U
M550_keeper GND Vdd #522 GND nmos W=0.0975U L=0.715U
M551_ GND __ot_524_6 #fb526# GND nmos W=0.0975U L=0.13U
M552_keeper GND Vdd #525 GND nmos W=0.0975U L=0.715U
M553_ GND __of_524_6 #fb529# GND nmos W=0.0975U L=0.13U
M554_keeper GND Vdd #528 GND nmos W=0.0975U L=0.715U
M555_ GND __ot_525_6 #fb532# GND nmos W=0.0975U L=0.13U
M556_keeper GND Vdd #531 GND nmos W=0.0975U L=0.715U
M557_ GND __of_525_6 #fb535# GND nmos W=0.0975U L=0.13U
M558_keeper GND Vdd #534 GND nmos W=0.0975U L=0.715U
M559_ GND __ot_526_6 #fb538# GND nmos W=0.0975U L=0.13U
M560_keeper GND Vdd #537 GND nmos W=0.0975U L=0.715U
M561_ GND __of_526_6 #fb541# GND nmos W=0.0975U L=0.13U
M562_keeper GND Vdd #540 GND nmos W=0.0975U L=0.715U
M563_ GND __ot_527_6 #fb544# GND nmos W=0.0975U L=0.13U
M564_keeper GND Vdd #543 GND nmos W=0.0975U L=0.715U
M565_ GND __of_527_6 #fb547# GND nmos W=0.0975U L=0.13U
M566_keeper GND Vdd #546 GND nmos W=0.0975U L=0.715U
M567_ GND __ot_528_6 #fb550# GND nmos W=0.0975U L=0.13U
M568_keeper GND Vdd #549 GND nmos W=0.0975U L=0.715U
M569_ GND __of_528_6 #fb553# GND nmos W=0.0975U L=0.13U
M570_keeper GND Vdd #552 GND nmos W=0.0975U L=0.715U
M571_ GND __ot_529_6 #fb556# GND nmos W=0.0975U L=0.13U
M572_keeper GND Vdd #555 GND nmos W=0.0975U L=0.715U
M573_ GND __of_529_6 #fb559# GND nmos W=0.0975U L=0.13U
M574_keeper GND Vdd #558 GND nmos W=0.0975U L=0.715U
M575_ GND __ot_530_6 #fb562# GND nmos W=0.0975U L=0.13U
M576_keeper GND Vdd #561 GND nmos W=0.0975U L=0.715U
M577_ GND __of_530_6 #fb565# GND nmos W=0.0975U L=0.13U
M578_keeper GND Vdd #564 GND nmos W=0.0975U L=0.715U
M579_ GND __ot_531_6 #fb568# GND nmos W=0.0975U L=0.13U
M580_keeper GND Vdd #567 GND nmos W=0.0975U L=0.715U
M581_ GND __of_531_6 #fb571# GND nmos W=0.0975U L=0.13U
M582_keeper GND Vdd #570 GND nmos W=0.0975U L=0.715U
M583_keeper GND Vdd #573 GND nmos W=0.0975U L=0.715U
M584_ #4 __oa c GND nmos W=0.0975U L=0.065U
M585_keeper #362 #fb361# c Vdd pmos W=0.0975U L=0.065U
M586_keeper #363 #fb361# c GND nmos W=0.0975U L=0.065U
M587_ #5 I_aa #4 GND nmos W=0.0975U L=0.065U
M588_ #17 __c w0 Vdd pmos W=0.1625U L=0.065U
M589_ #19 __oa w0 GND nmos W=0.0975U L=0.065U
M590_keeper #365 #fb364# w0 Vdd pmos W=0.0975U L=0.065U
M591_keeper #366 #fb364# w0 GND nmos W=0.0975U L=0.065U
M592_ #162 v I_aa GND nmos W=0.0975U L=0.065U
M593_ #163 __oa I_aa GND nmos W=0.0975U L=0.065U
M594_keeper #368 #fb367# I_aa Vdd pmos W=0.0975U L=0.065U
M595_keeper #369 #fb367# I_aa GND nmos W=0.0975U L=0.065U
M596_ #11 c __cha GND nmos W=0.0975U L=0.065U
M597_ #13 __c __cha GND nmos W=0.0975U L=0.065U
M598_ #16 C_af_50_6 __cha Vdd pmos W=0.1625U L=0.065U
M599_keeper #371 #fb370# __cha Vdd pmos W=0.0975U L=0.065U
M600_keeper #372 #fb370# __cha GND nmos W=0.0975U L=0.065U
M601_ #20 I_aa #19 GND nmos W=0.0975U L=0.065U
M602_ #22 __c w1 Vdd pmos W=0.1625U L=0.065U
M603_ #24 __oa w1 GND nmos W=0.0975U L=0.065U
M604_keeper #374 #fb373# w1 Vdd pmos W=0.0975U L=0.065U
M605_keeper #375 #fb373# w1 GND nmos W=0.0975U L=0.065U
M606_ #25 I_aa #24 GND nmos W=0.0975U L=0.065U
M607_ #155 I_af_50_6 v Vdd pmos W=0.1625U L=0.065U
M608_keeper #377 #fb376# v Vdd pmos W=0.0975U L=0.065U
M609_keeper #378 #fb376# v GND nmos W=0.0975U L=0.065U
M610_ #28 __ia #27 Vdd pmos W=0.1625U L=0.065U
M611_ #27 I_at_531_6 #62 Vdd pmos W=0.1625U L=0.065U
M612_ #158 I_at_531_6 __j GND nmos W=0.0975U L=0.065U
M613_ #158 I_af_531_6 __j GND nmos W=0.0975U L=0.065U
M614_keeper #380 #fb379# __j Vdd pmos W=0.0975U L=0.065U
M615_keeper #381 #fb379# __j GND nmos W=0.0975U L=0.065U
M616_ #152 I_af_51_6 #31 Vdd pmos W=0.1625U L=0.065U
M617_ #31 I_at_50_6 #155 Vdd pmos W=0.1625U L=0.065U
M618_ #149 I_af_52_6 #32 Vdd pmos W=0.1625U L=0.065U
M619_ #32 I_at_51_6 #152 Vdd pmos W=0.1625U L=0.065U
M620_ #146 I_af_53_6 #33 Vdd pmos W=0.1625U L=0.065U
M621_ #33 I_at_52_6 #149 Vdd pmos W=0.1625U L=0.065U
M622_ #143 I_af_54_6 #34 Vdd pmos W=0.1625U L=0.065U
M623_ #34 I_at_53_6 #146 Vdd pmos W=0.1625U L=0.065U
M624_ #140 I_af_55_6 #35 Vdd pmos W=0.1625U L=0.065U
M625_ #35 I_at_54_6 #143 Vdd pmos W=0.1625U L=0.065U
M626_ #137 I_af_56_6 #36 Vdd pmos W=0.1625U L=0.065U
M627_ #36 I_at_55_6 #140 Vdd pmos W=0.1625U L=0.065U
M628_ #134 I_af_57_6 #37 Vdd pmos W=0.1625U L=0.065U
M629_ #37 I_at_56_6 #137 Vdd pmos W=0.1625U L=0.065U
M630_ #131 I_af_58_6 #38 Vdd pmos W=0.1625U L=0.065U
M631_ #38 I_at_57_6 #134 Vdd pmos W=0.1625U L=0.065U
M632_ #128 I_af_59_6 #39 Vdd pmos W=0.1625U L=0.065U
M633_ #39 I_at_58_6 #131 Vdd pmos W=0.1625U L=0.065U
M634_ #125 I_af_510_6 #40 Vdd pmos W=0.1625U L=0.065U
M635_ #40 I_at_59_6 #128 Vdd pmos W=0.1625U L=0.065U
M636_ #122 I_af_511_6 #41 Vdd pmos W=0.1625U L=0.065U
M637_ #41 I_at_510_6 #125 Vdd pmos W=0.1625U L=0.065U
M638_ #119 I_af_512_6 #42 Vdd pmos W=0.1625U L=0.065U
M639_ #42 I_at_511_6 #122 Vdd pmos W=0.1625U L=0.065U
M640_ #116 I_af_513_6 #43 Vdd pmos W=0.1625U L=0.065U
M641_ #43 I_at_512_6 #119 Vdd pmos W=0.1625U L=0.065U
M642_ #113 I_af_514_6 #44 Vdd pmos W=0.1625U L=0.065U
M643_ #44 I_at_513_6 #116 Vdd pmos W=0.1625U L=0.065U
M644_ #110 I_af_515_6 #45 Vdd pmos W=0.1625U L=0.065U
M645_ #45 I_at_514_6 #113 Vdd pmos W=0.1625U L=0.065U
M646_ #107 I_af_516_6 #46 Vdd pmos W=0.1625U L=0.065U
M647_ #46 I_at_515_6 #110 Vdd pmos W=0.1625U L=0.065U
M648_ #104 I_af_517_6 #47 Vdd pmos W=0.1625U L=0.065U
M649_ #47 I_at_516_6 #107 Vdd pmos W=0.1625U L=0.065U
M650_ #101 I_af_518_6 #48 Vdd pmos W=0.1625U L=0.065U
M651_ #48 I_at_517_6 #104 Vdd pmos W=0.1625U L=0.065U
M652_ #98 I_af_519_6 #49 Vdd pmos W=0.1625U L=0.065U
M653_ #49 I_at_518_6 #101 Vdd pmos W=0.1625U L=0.065U
M654_ #95 I_af_520_6 #50 Vdd pmos W=0.1625U L=0.065U
M655_ #50 I_at_519_6 #98 Vdd pmos W=0.1625U L=0.065U
M656_ #92 I_af_521_6 #51 Vdd pmos W=0.1625U L=0.065U
M657_ #51 I_at_520_6 #95 Vdd pmos W=0.1625U L=0.065U
M658_ #89 I_af_522_6 #52 Vdd pmos W=0.1625U L=0.065U
M659_ #52 I_at_521_6 #92 Vdd pmos W=0.1625U L=0.065U
M660_ #86 I_af_523_6 #53 Vdd pmos W=0.1625U L=0.065U
M661_ #53 I_at_522_6 #89 Vdd pmos W=0.1625U L=0.065U
M662_ #83 I_af_524_6 #54 Vdd pmos W=0.1625U L=0.065U
M663_ #54 I_at_523_6 #86 Vdd pmos W=0.1625U L=0.065U
M664_ #80 I_af_525_6 #55 Vdd pmos W=0.1625U L=0.065U
M665_ #55 I_at_524_6 #83 Vdd pmos W=0.1625U L=0.065U
M666_ #77 I_af_526_6 #56 Vdd pmos W=0.1625U L=0.065U
M667_ #56 I_at_525_6 #80 Vdd pmos W=0.1625U L=0.065U
M668_ #74 I_af_527_6 #57 Vdd pmos W=0.1625U L=0.065U
M669_ #57 I_at_526_6 #77 Vdd pmos W=0.1625U L=0.065U
M670_ #71 I_af_528_6 #58 Vdd pmos W=0.1625U L=0.065U
M671_ #58 I_at_527_6 #74 Vdd pmos W=0.1625U L=0.065U
M672_ #68 I_af_529_6 #59 Vdd pmos W=0.1625U L=0.065U
M673_ #59 I_at_528_6 #71 Vdd pmos W=0.1625U L=0.065U
M674_ #65 I_af_530_6 #60 Vdd pmos W=0.1625U L=0.065U
M675_ #60 I_at_529_6 #68 Vdd pmos W=0.1625U L=0.065U
M676_ #62 I_af_531_6 #61 Vdd pmos W=0.1625U L=0.065U
M677_ #61 I_at_530_6 #65 Vdd pmos W=0.1625U L=0.065U
M678_ #159 __c #158 GND nmos W=0.0975U L=0.065U
M679_ #162 __w0 #164 GND nmos W=0.0975U L=0.065U
M680_ #164 __w1 #163 GND nmos W=0.0975U L=0.065U
M681_ #168 I_at_50_6 __ot_50_6 GND nmos W=0.0975U L=0.065U
M682_keeper #383 #fb382# __ot_50_6 Vdd pmos W=0.0975U L=0.065U
M683_keeper #384 #fb382# __ot_50_6 GND nmos W=0.0975U L=0.065U
M684_ #170 I_af_50_6 __of_50_6 GND nmos W=0.0975U L=0.065U
M685_keeper #386 #fb385# __of_50_6 Vdd pmos W=0.0975U L=0.065U
M686_keeper #387 #fb385# __of_50_6 GND nmos W=0.0975U L=0.065U
M687_ #172 I_at_51_6 __ot_51_6 GND nmos W=0.0975U L=0.065U
M688_keeper #389 #fb388# __ot_51_6 Vdd pmos W=0.0975U L=0.065U
M689_keeper #390 #fb388# __ot_51_6 GND nmos W=0.0975U L=0.065U
M690_ #174 I_af_51_6 __of_51_6 GND nmos W=0.0975U L=0.065U
M691_keeper #392 #fb391# __of_51_6 Vdd pmos W=0.0975U L=0.065U
M692_keeper #393 #fb391# __of_51_6 GND nmos W=0.0975U L=0.065U
M693_ #176 I_at_52_6 __ot_52_6 GND nmos W=0.0975U L=0.065U
M694_keeper #395 #fb394# __ot_52_6 Vdd pmos W=0.0975U L=0.065U
M695_keeper #396 #fb394# __ot_52_6 GND nmos W=0.0975U L=0.065U
M696_ #178 I_af_52_6 __of_52_6 GND nmos W=0.0975U L=0.065U
M697_keeper #398 #fb397# __of_52_6 Vdd pmos W=0.0975U L=0.065U
M698_keeper #399 #fb397# __of_52_6 GND nmos W=0.0975U L=0.065U
M699_ #180 I_at_53_6 __ot_53_6 GND nmos W=0.0975U L=0.065U
M700_keeper #401 #fb400# __ot_53_6 Vdd pmos W=0.0975U L=0.065U
M701_keeper #402 #fb400# __ot_53_6 GND nmos W=0.0975U L=0.065U
M702_ #182 I_af_53_6 __of_53_6 GND nmos W=0.0975U L=0.065U
M703_keeper #404 #fb403# __of_53_6 Vdd pmos W=0.0975U L=0.065U
M704_keeper #405 #fb403# __of_53_6 GND nmos W=0.0975U L=0.065U
M705_ #184 I_at_54_6 __ot_54_6 GND nmos W=0.0975U L=0.065U
M706_keeper #407 #fb406# __ot_54_6 Vdd pmos W=0.0975U L=0.065U
M707_keeper #408 #fb406# __ot_54_6 GND nmos W=0.0975U L=0.065U
M708_ #186 I_af_54_6 __of_54_6 GND nmos W=0.0975U L=0.065U
M709_keeper #410 #fb409# __of_54_6 Vdd pmos W=0.0975U L=0.065U
M710_keeper #411 #fb409# __of_54_6 GND nmos W=0.0975U L=0.065U
M711_ #188 I_at_55_6 __ot_55_6 GND nmos W=0.0975U L=0.065U
M712_keeper #413 #fb412# __ot_55_6 Vdd pmos W=0.0975U L=0.065U
M713_keeper #414 #fb412# __ot_55_6 GND nmos W=0.0975U L=0.065U
M714_ #190 I_af_55_6 __of_55_6 GND nmos W=0.0975U L=0.065U
M715_keeper #416 #fb415# __of_55_6 Vdd pmos W=0.0975U L=0.065U
M716_keeper #417 #fb415# __of_55_6 GND nmos W=0.0975U L=0.065U
M717_ #192 I_at_56_6 __ot_56_6 GND nmos W=0.0975U L=0.065U
M718_keeper #419 #fb418# __ot_56_6 Vdd pmos W=0.0975U L=0.065U
M719_keeper #420 #fb418# __ot_56_6 GND nmos W=0.0975U L=0.065U
M720_ #194 I_af_56_6 __of_56_6 GND nmos W=0.0975U L=0.065U
M721_keeper #422 #fb421# __of_56_6 Vdd pmos W=0.0975U L=0.065U
M722_keeper #423 #fb421# __of_56_6 GND nmos W=0.0975U L=0.065U
M723_ #196 I_at_57_6 __ot_57_6 GND nmos W=0.0975U L=0.065U
M724_keeper #425 #fb424# __ot_57_6 Vdd pmos W=0.0975U L=0.065U
M725_keeper #426 #fb424# __ot_57_6 GND nmos W=0.0975U L=0.065U
M726_ #198 I_af_57_6 __of_57_6 GND nmos W=0.0975U L=0.065U
M727_keeper #428 #fb427# __of_57_6 Vdd pmos W=0.0975U L=0.065U
M728_keeper #429 #fb427# __of_57_6 GND nmos W=0.0975U L=0.065U
M729_ #200 I_at_58_6 __ot_58_6 GND nmos W=0.0975U L=0.065U
M730_keeper #431 #fb430# __ot_58_6 Vdd pmos W=0.0975U L=0.065U
M731_keeper #432 #fb430# __ot_58_6 GND nmos W=0.0975U L=0.065U
M732_ #202 I_af_58_6 __of_58_6 GND nmos W=0.0975U L=0.065U
M733_keeper #434 #fb433# __of_58_6 Vdd pmos W=0.0975U L=0.065U
M734_keeper #435 #fb433# __of_58_6 GND nmos W=0.0975U L=0.065U
M735_ #204 I_at_59_6 __ot_59_6 GND nmos W=0.0975U L=0.065U
M736_keeper #437 #fb436# __ot_59_6 Vdd pmos W=0.0975U L=0.065U
M737_keeper #438 #fb436# __ot_59_6 GND nmos W=0.0975U L=0.065U
M738_ #206 I_af_59_6 __of_59_6 GND nmos W=0.0975U L=0.065U
M739_keeper #440 #fb439# __of_59_6 Vdd pmos W=0.0975U L=0.065U
M740_keeper #441 #fb439# __of_59_6 GND nmos W=0.0975U L=0.065U
M741_ #208 I_at_510_6 __ot_510_6 GND nmos W=0.0975U L=0.065U
M742_keeper #443 #fb442# __ot_510_6 Vdd pmos W=0.0975U L=0.065U
M743_keeper #444 #fb442# __ot_510_6 GND nmos W=0.0975U L=0.065U
M744_ #210 I_af_510_6 __of_510_6 GND nmos W=0.0975U L=0.065U
M745_keeper #446 #fb445# __of_510_6 Vdd pmos W=0.0975U L=0.065U
M746_keeper #447 #fb445# __of_510_6 GND nmos W=0.0975U L=0.065U
M747_ #212 I_at_511_6 __ot_511_6 GND nmos W=0.0975U L=0.065U
M748_keeper #449 #fb448# __ot_511_6 Vdd pmos W=0.0975U L=0.065U
M749_keeper #450 #fb448# __ot_511_6 GND nmos W=0.0975U L=0.065U
M750_ #214 I_af_511_6 __of_511_6 GND nmos W=0.0975U L=0.065U
M751_keeper #452 #fb451# __of_511_6 Vdd pmos W=0.0975U L=0.065U
M752_keeper #453 #fb451# __of_511_6 GND nmos W=0.0975U L=0.065U
M753_ #216 I_at_512_6 __ot_512_6 GND nmos W=0.0975U L=0.065U
M754_keeper #455 #fb454# __ot_512_6 Vdd pmos W=0.0975U L=0.065U
M755_keeper #456 #fb454# __ot_512_6 GND nmos W=0.0975U L=0.065U
M756_ #218 I_af_512_6 __of_512_6 GND nmos W=0.0975U L=0.065U
M757_keeper #458 #fb457# __of_512_6 Vdd pmos W=0.0975U L=0.065U
M758_keeper #459 #fb457# __of_512_6 GND nmos W=0.0975U L=0.065U
M759_ #220 I_at_513_6 __ot_513_6 GND nmos W=0.0975U L=0.065U
M760_keeper #461 #fb460# __ot_513_6 Vdd pmos W=0.0975U L=0.065U
M761_keeper #462 #fb460# __ot_513_6 GND nmos W=0.0975U L=0.065U
M762_ #222 I_af_513_6 __of_513_6 GND nmos W=0.0975U L=0.065U
M763_keeper #464 #fb463# __of_513_6 Vdd pmos W=0.0975U L=0.065U
M764_keeper #465 #fb463# __of_513_6 GND nmos W=0.0975U L=0.065U
M765_ #224 I_at_514_6 __ot_514_6 GND nmos W=0.0975U L=0.065U
M766_keeper #467 #fb466# __ot_514_6 Vdd pmos W=0.0975U L=0.065U
M767_keeper #468 #fb466# __ot_514_6 GND nmos W=0.0975U L=0.065U
M768_ #226 I_af_514_6 __of_514_6 GND nmos W=0.0975U L=0.065U
M769_keeper #470 #fb469# __of_514_6 Vdd pmos W=0.0975U L=0.065U
M770_keeper #471 #fb469# __of_514_6 GND nmos W=0.0975U L=0.065U
M771_ #228 I_at_515_6 __ot_515_6 GND nmos W=0.0975U L=0.065U
M772_keeper #473 #fb472# __ot_515_6 Vdd pmos W=0.0975U L=0.065U
M773_keeper #474 #fb472# __ot_515_6 GND nmos W=0.0975U L=0.065U
M774_ #230 I_af_515_6 __of_515_6 GND nmos W=0.0975U L=0.065U
M775_keeper #476 #fb475# __of_515_6 Vdd pmos W=0.0975U L=0.065U
M776_keeper #477 #fb475# __of_515_6 GND nmos W=0.0975U L=0.065U
M777_ #232 I_at_516_6 __ot_516_6 GND nmos W=0.0975U L=0.065U
M778_keeper #479 #fb478# __ot_516_6 Vdd pmos W=0.0975U L=0.065U
M779_keeper #480 #fb478# __ot_516_6 GND nmos W=0.0975U L=0.065U
M780_ #234 I_af_516_6 __of_516_6 GND nmos W=0.0975U L=0.065U
M781_keeper #482 #fb481# __of_516_6 Vdd pmos W=0.0975U L=0.065U
M782_keeper #483 #fb481# __of_516_6 GND nmos W=0.0975U L=0.065U
M783_ #236 I_at_517_6 __ot_517_6 GND nmos W=0.0975U L=0.065U
M784_keeper #485 #fb484# __ot_517_6 Vdd pmos W=0.0975U L=0.065U
M785_keeper #486 #fb484# __ot_517_6 GND nmos W=0.0975U L=0.065U
M786_ #238 I_af_517_6 __of_517_6 GND nmos W=0.0975U L=0.065U
M787_keeper #488 #fb487# __of_517_6 Vdd pmos W=0.0975U L=0.065U
M788_keeper #489 #fb487# __of_517_6 GND nmos W=0.0975U L=0.065U
M789_ #240 I_at_518_6 __ot_518_6 GND nmos W=0.0975U L=0.065U
M790_keeper #491 #fb490# __ot_518_6 Vdd pmos W=0.0975U L=0.065U
M791_keeper #492 #fb490# __ot_518_6 GND nmos W=0.0975U L=0.065U
M792_ #242 I_af_518_6 __of_518_6 GND nmos W=0.0975U L=0.065U
M793_keeper #494 #fb493# __of_518_6 Vdd pmos W=0.0975U L=0.065U
M794_keeper #495 #fb493# __of_518_6 GND nmos W=0.0975U L=0.065U
M795_ #244 I_at_519_6 __ot_519_6 GND nmos W=0.0975U L=0.065U
M796_keeper #497 #fb496# __ot_519_6 Vdd pmos W=0.0975U L=0.065U
M797_keeper #498 #fb496# __ot_519_6 GND nmos W=0.0975U L=0.065U
M798_ #246 I_af_519_6 __of_519_6 GND nmos W=0.0975U L=0.065U
M799_keeper #500 #fb499# __of_519_6 Vdd pmos W=0.0975U L=0.065U
M800_keeper #501 #fb499# __of_519_6 GND nmos W=0.0975U L=0.065U
M801_ #248 I_at_520_6 __ot_520_6 GND nmos W=0.0975U L=0.065U
M802_keeper #503 #fb502# __ot_520_6 Vdd pmos W=0.0975U L=0.065U
M803_keeper #504 #fb502# __ot_520_6 GND nmos W=0.0975U L=0.065U
M804_ #250 I_af_520_6 __of_520_6 GND nmos W=0.0975U L=0.065U
M805_keeper #506 #fb505# __of_520_6 Vdd pmos W=0.0975U L=0.065U
M806_keeper #507 #fb505# __of_520_6 GND nmos W=0.0975U L=0.065U
M807_ #252 I_at_521_6 __ot_521_6 GND nmos W=0.0975U L=0.065U
M808_keeper #509 #fb508# __ot_521_6 Vdd pmos W=0.0975U L=0.065U
M809_keeper #510 #fb508# __ot_521_6 GND nmos W=0.0975U L=0.065U
M810_ #254 I_af_521_6 __of_521_6 GND nmos W=0.0975U L=0.065U
M811_keeper #512 #fb511# __of_521_6 Vdd pmos W=0.0975U L=0.065U
M812_keeper #513 #fb511# __of_521_6 GND nmos W=0.0975U L=0.065U
M813_ #256 I_at_522_6 __ot_522_6 GND nmos W=0.0975U L=0.065U
M814_keeper #515 #fb514# __ot_522_6 Vdd pmos W=0.0975U L=0.065U
M815_keeper #516 #fb514# __ot_522_6 GND nmos W=0.0975U L=0.065U
M816_ #258 I_af_522_6 __of_522_6 GND nmos W=0.0975U L=0.065U
M817_keeper #518 #fb517# __of_522_6 Vdd pmos W=0.0975U L=0.065U
M818_keeper #519 #fb517# __of_522_6 GND nmos W=0.0975U L=0.065U
M819_ #260 I_at_523_6 __ot_523_6 GND nmos W=0.0975U L=0.065U
M820_keeper #521 #fb520# __ot_523_6 Vdd pmos W=0.0975U L=0.065U
M821_keeper #522 #fb520# __ot_523_6 GND nmos W=0.0975U L=0.065U
M822_ #262 I_af_523_6 __of_523_6 GND nmos W=0.0975U L=0.065U
M823_keeper #524 #fb523# __of_523_6 Vdd pmos W=0.0975U L=0.065U
M824_keeper #525 #fb523# __of_523_6 GND nmos W=0.0975U L=0.065U
M825_ #264 I_at_524_6 __ot_524_6 GND nmos W=0.0975U L=0.065U
M826_keeper #527 #fb526# __ot_524_6 Vdd pmos W=0.0975U L=0.065U
M827_keeper #528 #fb526# __ot_524_6 GND nmos W=0.0975U L=0.065U
M828_ #266 I_af_524_6 __of_524_6 GND nmos W=0.0975U L=0.065U
M829_keeper #530 #fb529# __of_524_6 Vdd pmos W=0.0975U L=0.065U
M830_keeper #531 #fb529# __of_524_6 GND nmos W=0.0975U L=0.065U
M831_ #268 I_at_525_6 __ot_525_6 GND nmos W=0.0975U L=0.065U
M832_keeper #533 #fb532# __ot_525_6 Vdd pmos W=0.0975U L=0.065U
M833_keeper #534 #fb532# __ot_525_6 GND nmos W=0.0975U L=0.065U
M834_ #270 I_af_525_6 __of_525_6 GND nmos W=0.0975U L=0.065U
M835_keeper #536 #fb535# __of_525_6 Vdd pmos W=0.0975U L=0.065U
M836_keeper #537 #fb535# __of_525_6 GND nmos W=0.0975U L=0.065U
M837_ #272 I_at_526_6 __ot_526_6 GND nmos W=0.0975U L=0.065U
M838_keeper #539 #fb538# __ot_526_6 Vdd pmos W=0.0975U L=0.065U
M839_keeper #540 #fb538# __ot_526_6 GND nmos W=0.0975U L=0.065U
M840_ #274 I_af_526_6 __of_526_6 GND nmos W=0.0975U L=0.065U
M841_keeper #542 #fb541# __of_526_6 Vdd pmos W=0.0975U L=0.065U
M842_keeper #543 #fb541# __of_526_6 GND nmos W=0.0975U L=0.065U
M843_ #276 I_at_527_6 __ot_527_6 GND nmos W=0.0975U L=0.065U
M844_keeper #545 #fb544# __ot_527_6 Vdd pmos W=0.0975U L=0.065U
M845_keeper #546 #fb544# __ot_527_6 GND nmos W=0.0975U L=0.065U
M846_ #278 I_af_527_6 __of_527_6 GND nmos W=0.0975U L=0.065U
M847_keeper #548 #fb547# __of_527_6 Vdd pmos W=0.0975U L=0.065U
M848_keeper #549 #fb547# __of_527_6 GND nmos W=0.0975U L=0.065U
M849_ #280 I_at_528_6 __ot_528_6 GND nmos W=0.0975U L=0.065U
M850_keeper #551 #fb550# __ot_528_6 Vdd pmos W=0.0975U L=0.065U
M851_keeper #552 #fb550# __ot_528_6 GND nmos W=0.0975U L=0.065U
M852_ #282 I_af_528_6 __of_528_6 GND nmos W=0.0975U L=0.065U
M853_keeper #554 #fb553# __of_528_6 Vdd pmos W=0.0975U L=0.065U
M854_keeper #555 #fb553# __of_528_6 GND nmos W=0.0975U L=0.065U
M855_ #284 I_at_529_6 __ot_529_6 GND nmos W=0.0975U L=0.065U
M856_keeper #557 #fb556# __ot_529_6 Vdd pmos W=0.0975U L=0.065U
M857_keeper #558 #fb556# __ot_529_6 GND nmos W=0.0975U L=0.065U
M858_ #286 I_af_529_6 __of_529_6 GND nmos W=0.0975U L=0.065U
M859_keeper #560 #fb559# __of_529_6 Vdd pmos W=0.0975U L=0.065U
M860_keeper #561 #fb559# __of_529_6 GND nmos W=0.0975U L=0.065U
M861_ #288 I_at_530_6 __ot_530_6 GND nmos W=0.0975U L=0.065U
M862_keeper #563 #fb562# __ot_530_6 Vdd pmos W=0.0975U L=0.065U
M863_keeper #564 #fb562# __ot_530_6 GND nmos W=0.0975U L=0.065U
M864_ #290 I_af_530_6 __of_530_6 GND nmos W=0.0975U L=0.065U
M865_keeper #566 #fb565# __of_530_6 Vdd pmos W=0.0975U L=0.065U
M866_keeper #567 #fb565# __of_530_6 GND nmos W=0.0975U L=0.065U
M867_ #292 I_at_531_6 __ot_531_6 GND nmos W=0.0975U L=0.065U
M868_keeper #569 #fb568# __ot_531_6 Vdd pmos W=0.0975U L=0.065U
M869_keeper #570 #fb568# __ot_531_6 GND nmos W=0.0975U L=0.065U
M870_ #294 I_af_531_6 __of_531_6 GND nmos W=0.0975U L=0.065U
M871_keeper #572 #fb571# __of_531_6 Vdd pmos W=0.0975U L=0.065U
M872_keeper #573 #fb571# __of_531_6 GND nmos W=0.0975U L=0.065U
.ends
*---- end of process: ChildDispatch<> -----
*
*---- act defproc: PayloadDispatch<> -----
* raw ports:  reset I.t[0] I.t[1] I.t[2] I.t[3] I.t[4] I.t[5] I.t[6] I.t[7] I.t[8] I.t[9] I.t[10] I.t[11] I.t[12] I.t[13] I.t[14] I.t[15] I.t[16] I.t[17] I.t[18] I.t[19] I.t[20] I.t[21] I.t[22] I.t[23] I.t[24] I.t[25] I.t[26] I.t[27] I.t[28] I.t[29] I.t[30] I.t[31] I.f[0] I.f[1] I.f[2] I.f[3] I.f[4] I.f[5] I.f[6] I.f[7] I.f[8] I.f[9] I.f[10] I.f[11] I.f[12] I.f[13] I.f[14] I.f[15] I.f[16] I.f[17] I.f[18] I.f[19] I.f[20] I.f[21] I.f[22] I.f[23] I.f[24] I.f[25] I.f[26] I.f[27] I.f[28] I.f[29] I.f[30] I.f[31] I.a Ch.t[0] Ch.t[1] Ch.t[2] Ch.t[3] Ch.f[0] Ch.f[1] Ch.f[2] Ch.f[3] Ch.a C0.t[0] C0.t[1] C0.t[2] C0.t[3] C0.t[4] C0.t[5] C0.t[6] C0.t[7] C0.t[8] C0.t[9] C0.t[10] C0.t[11] C0.t[12] C0.t[13] C0.t[14] C0.t[15] C0.t[16] C0.t[17] C0.t[18] C0.t[19] C0.t[20] C0.t[21] C0.t[22] C0.t[23] C0.t[24] C0.t[25] C0.t[26] C0.t[27] C0.t[28] C0.t[29] C0.t[30] C0.t[31] C0.f[0] C0.f[1] C0.f[2] C0.f[3] C0.f[4] C0.f[5] C0.f[6] C0.f[7] C0.f[8] C0.f[9] C0.f[10] C0.f[11] C0.f[12] C0.f[13] C0.f[14] C0.f[15] C0.f[16] C0.f[17] C0.f[18] C0.f[19] C0.f[20] C0.f[21] C0.f[22] C0.f[23] C0.f[24] C0.f[25] C0.f[26] C0.f[27] C0.f[28] C0.f[29] C0.f[30] C0.f[31] C0.a C1.t[0] C1.t[1] C1.t[2] C1.t[3] C1.t[4] C1.t[5] C1.t[6] C1.t[7] C1.t[8] C1.t[9] C1.t[10] C1.t[11] C1.t[12] C1.t[13] C1.t[14] C1.t[15] C1.t[16] C1.t[17] C1.t[18] C1.t[19] C1.t[20] C1.t[21] C1.t[22] C1.t[23] C1.t[24] C1.t[25] C1.t[26] C1.t[27] C1.t[28] C1.t[29] C1.t[30] C1.t[31] C1.f[0] C1.f[1] C1.f[2] C1.f[3] C1.f[4] C1.f[5] C1.f[6] C1.f[7] C1.f[8] C1.f[9] C1.f[10] C1.f[11] C1.f[12] C1.f[13] C1.f[14] C1.f[15] C1.f[16] C1.f[17] C1.f[18] C1.f[19] C1.f[20] C1.f[21] C1.f[22] C1.f[23] C1.f[24] C1.f[25] C1.f[26] C1.f[27] C1.f[28] C1.f[29] C1.f[30] C1.f[31] C1.a C2.t[0] C2.t[1] C2.t[2] C2.t[3] C2.t[4] C2.t[5] C2.t[6] C2.t[7] C2.t[8] C2.t[9] C2.t[10] C2.t[11] C2.t[12] C2.t[13] C2.t[14] C2.t[15] C2.t[16] C2.t[17] C2.t[18] C2.t[19] C2.t[20] C2.t[21] C2.t[22] C2.t[23] C2.t[24] C2.t[25] C2.t[26] C2.t[27] C2.t[28] C2.t[29] C2.t[30] C2.t[31] C2.f[0] C2.f[1] C2.f[2] C2.f[3] C2.f[4] C2.f[5] C2.f[6] C2.f[7] C2.f[8] C2.f[9] C2.f[10] C2.f[11] C2.f[12] C2.f[13] C2.f[14] C2.f[15] C2.f[16] C2.f[17] C2.f[18] C2.f[19] C2.f[20] C2.f[21] C2.f[22] C2.f[23] C2.f[24] C2.f[25] C2.f[26] C2.f[27] C2.f[28] C2.f[29] C2.f[30] C2.f[31] C2.a C3.t[0] C3.t[1] C3.t[2] C3.t[3] C3.t[4] C3.t[5] C3.t[6] C3.t[7] C3.t[8] C3.t[9] C3.t[10] C3.t[11] C3.t[12] C3.t[13] C3.t[14] C3.t[15] C3.t[16] C3.t[17] C3.t[18] C3.t[19] C3.t[20] C3.t[21] C3.t[22] C3.t[23] C3.t[24] C3.t[25] C3.t[26] C3.t[27] C3.t[28] C3.t[29] C3.t[30] C3.t[31] C3.f[0] C3.f[1] C3.f[2] C3.f[3] C3.f[4] C3.f[5] C3.f[6] C3.f[7] C3.f[8] C3.f[9] C3.f[10] C3.f[11] C3.f[12] C3.f[13] C3.f[14] C3.f[15] C3.f[16] C3.f[17] C3.f[18] C3.f[19] C3.f[20] C3.f[21] C3.f[22] C3.f[23] C3.f[24] C3.f[25] C3.f[26] C3.f[27] C3.f[28] C3.f[29] C3.f[30] C3.f[31] C3.a
*
.subckt PayloadDispatch reset I_at_50_6 I_at_51_6 I_at_52_6 I_at_53_6 I_at_54_6 I_at_55_6 I_at_56_6 I_at_57_6 I_at_58_6 I_at_59_6 I_at_510_6 I_at_511_6 I_at_512_6 I_at_513_6 I_at_514_6 I_at_515_6 I_at_516_6 I_at_517_6 I_at_518_6 I_at_519_6 I_at_520_6 I_at_521_6 I_at_522_6 I_at_523_6 I_at_524_6 I_at_525_6 I_at_526_6 I_at_527_6 I_at_528_6 I_at_529_6 I_at_530_6 I_at_531_6 I_af_50_6 I_af_51_6 I_af_52_6 I_af_53_6 I_af_54_6 I_af_55_6 I_af_56_6 I_af_57_6 I_af_58_6 I_af_59_6 I_af_510_6 I_af_511_6 I_af_512_6 I_af_513_6 I_af_514_6 I_af_515_6 I_af_516_6 I_af_517_6 I_af_518_6 I_af_519_6 I_af_520_6 I_af_521_6 I_af_522_6 I_af_523_6 I_af_524_6 I_af_525_6 I_af_526_6 I_af_527_6 I_af_528_6 I_af_529_6 I_af_530_6 I_af_531_6 I_aa Ch_at_50_6 Ch_at_51_6 Ch_at_52_6 Ch_at_53_6 Ch_af_50_6 Ch_af_51_6 Ch_af_52_6 Ch_af_53_6 Ch_aa C0_at_50_6 C0_at_51_6 C0_at_52_6 C0_at_53_6 C0_at_54_6 C0_at_55_6 C0_at_56_6 C0_at_57_6 C0_at_58_6 C0_at_59_6 C0_at_510_6 C0_at_511_6 C0_at_512_6 C0_at_513_6 C0_at_514_6 C0_at_515_6 C0_at_516_6 C0_at_517_6 C0_at_518_6 C0_at_519_6 C0_at_520_6 C0_at_521_6 C0_at_522_6 C0_at_523_6 C0_at_524_6 C0_at_525_6 C0_at_526_6 C0_at_527_6 C0_at_528_6 C0_at_529_6 C0_at_530_6 C0_at_531_6 C0_af_50_6 C0_af_51_6 C0_af_52_6 C0_af_53_6 C0_af_54_6 C0_af_55_6 C0_af_56_6 C0_af_57_6 C0_af_58_6 C0_af_59_6 C0_af_510_6 C0_af_511_6 C0_af_512_6 C0_af_513_6 C0_af_514_6 C0_af_515_6 C0_af_516_6 C0_af_517_6 C0_af_518_6 C0_af_519_6 C0_af_520_6 C0_af_521_6 C0_af_522_6 C0_af_523_6 C0_af_524_6 C0_af_525_6 C0_af_526_6 C0_af_527_6 C0_af_528_6 C0_af_529_6 C0_af_530_6 C0_af_531_6 C0_aa C1_at_50_6 C1_at_51_6 C1_at_52_6 C1_at_53_6 C1_at_54_6 C1_at_55_6 C1_at_56_6 C1_at_57_6 C1_at_58_6 C1_at_59_6 C1_at_510_6 C1_at_511_6 C1_at_512_6 C1_at_513_6 C1_at_514_6 C1_at_515_6 C1_at_516_6 C1_at_517_6 C1_at_518_6 C1_at_519_6 C1_at_520_6 C1_at_521_6 C1_at_522_6 C1_at_523_6 C1_at_524_6 C1_at_525_6 C1_at_526_6 C1_at_527_6 C1_at_528_6 C1_at_529_6 C1_at_530_6 C1_at_531_6 C1_af_50_6 C1_af_51_6 C1_af_52_6 C1_af_53_6 C1_af_54_6 C1_af_55_6 C1_af_56_6 C1_af_57_6 C1_af_58_6 C1_af_59_6 C1_af_510_6 C1_af_511_6 C1_af_512_6 C1_af_513_6 C1_af_514_6 C1_af_515_6 C1_af_516_6 C1_af_517_6 C1_af_518_6 C1_af_519_6 C1_af_520_6 C1_af_521_6 C1_af_522_6 C1_af_523_6 C1_af_524_6 C1_af_525_6 C1_af_526_6 C1_af_527_6 C1_af_528_6 C1_af_529_6 C1_af_530_6 C1_af_531_6 C1_aa C2_at_50_6 C2_at_51_6 C2_at_52_6 C2_at_53_6 C2_at_54_6 C2_at_55_6 C2_at_56_6 C2_at_57_6 C2_at_58_6 C2_at_59_6 C2_at_510_6 C2_at_511_6 C2_at_512_6 C2_at_513_6 C2_at_514_6 C2_at_515_6 C2_at_516_6 C2_at_517_6 C2_at_518_6 C2_at_519_6 C2_at_520_6 C2_at_521_6 C2_at_522_6 C2_at_523_6 C2_at_524_6 C2_at_525_6 C2_at_526_6 C2_at_527_6 C2_at_528_6 C2_at_529_6 C2_at_530_6 C2_at_531_6 C2_af_50_6 C2_af_51_6 C2_af_52_6 C2_af_53_6 C2_af_54_6 C2_af_55_6 C2_af_56_6 C2_af_57_6 C2_af_58_6 C2_af_59_6 C2_af_510_6 C2_af_511_6 C2_af_512_6 C2_af_513_6 C2_af_514_6 C2_af_515_6 C2_af_516_6 C2_af_517_6 C2_af_518_6 C2_af_519_6 C2_af_520_6 C2_af_521_6 C2_af_522_6 C2_af_523_6 C2_af_524_6 C2_af_525_6 C2_af_526_6 C2_af_527_6 C2_af_528_6 C2_af_529_6 C2_af_530_6 C2_af_531_6 C2_aa C3_at_50_6 C3_at_51_6 C3_at_52_6 C3_at_53_6 C3_at_54_6 C3_at_55_6 C3_at_56_6 C3_at_57_6 C3_at_58_6 C3_at_59_6 C3_at_510_6 C3_at_511_6 C3_at_512_6 C3_at_513_6 C3_at_514_6 C3_at_515_6 C3_at_516_6 C3_at_517_6 C3_at_518_6 C3_at_519_6 C3_at_520_6 C3_at_521_6 C3_at_522_6 C3_at_523_6 C3_at_524_6 C3_at_525_6 C3_at_526_6 C3_at_527_6 C3_at_528_6 C3_at_529_6 C3_at_530_6 C3_at_531_6 C3_af_50_6 C3_af_51_6 C3_af_52_6 C3_af_53_6 C3_af_54_6 C3_af_55_6 C3_af_56_6 C3_af_57_6 C3_af_58_6 C3_af_59_6 C3_af_510_6 C3_af_511_6 C3_af_512_6 C3_af_513_6 C3_af_514_6 C3_af_515_6 C3_af_516_6 C3_af_517_6 C3_af_518_6 C3_af_519_6 C3_af_520_6 C3_af_521_6 C3_af_522_6 C3_af_523_6 C3_af_524_6 C3_af_525_6 C3_af_526_6 C3_af_527_6 C3_af_528_6 C3_af_529_6 C3_af_530_6 C3_af_531_6 C3_aa
*.PININFO reset:I I_at_50_6:I I_at_51_6:I I_at_52_6:I I_at_53_6:I I_at_54_6:I I_at_55_6:I I_at_56_6:I I_at_57_6:I I_at_58_6:I I_at_59_6:I I_at_510_6:I I_at_511_6:I I_at_512_6:I I_at_513_6:I I_at_514_6:I I_at_515_6:I I_at_516_6:I I_at_517_6:I I_at_518_6:I I_at_519_6:I I_at_520_6:I I_at_521_6:I I_at_522_6:I I_at_523_6:I I_at_524_6:I I_at_525_6:I I_at_526_6:I I_at_527_6:I I_at_528_6:I I_at_529_6:I I_at_530_6:I I_at_531_6:I I_af_50_6:I I_af_51_6:I I_af_52_6:I I_af_53_6:I I_af_54_6:I I_af_55_6:I I_af_56_6:I I_af_57_6:I I_af_58_6:I I_af_59_6:I I_af_510_6:I I_af_511_6:I I_af_512_6:I I_af_513_6:I I_af_514_6:I I_af_515_6:I I_af_516_6:I I_af_517_6:I I_af_518_6:I I_af_519_6:I I_af_520_6:I I_af_521_6:I I_af_522_6:I I_af_523_6:I I_af_524_6:I I_af_525_6:I I_af_526_6:I I_af_527_6:I I_af_528_6:I I_af_529_6:I I_af_530_6:I I_af_531_6:I I_aa:O Ch_at_50_6:I Ch_at_51_6:I Ch_at_52_6:I Ch_at_53_6:I Ch_af_50_6:I Ch_af_51_6:I Ch_af_52_6:I Ch_af_53_6:I Ch_aa:O C0_at_50_6:O C0_at_51_6:O C0_at_52_6:O C0_at_53_6:O C0_at_54_6:O C0_at_55_6:O C0_at_56_6:O C0_at_57_6:O C0_at_58_6:O C0_at_59_6:O C0_at_510_6:O C0_at_511_6:O C0_at_512_6:O C0_at_513_6:O C0_at_514_6:O C0_at_515_6:O C0_at_516_6:O C0_at_517_6:O C0_at_518_6:O C0_at_519_6:O C0_at_520_6:O C0_at_521_6:O C0_at_522_6:O C0_at_523_6:O C0_at_524_6:O C0_at_525_6:O C0_at_526_6:O C0_at_527_6:O C0_at_528_6:O C0_at_529_6:O C0_at_530_6:O C0_at_531_6:O C0_af_50_6:O C0_af_51_6:O C0_af_52_6:O C0_af_53_6:O C0_af_54_6:O C0_af_55_6:O C0_af_56_6:O C0_af_57_6:O C0_af_58_6:O C0_af_59_6:O C0_af_510_6:O C0_af_511_6:O C0_af_512_6:O C0_af_513_6:O C0_af_514_6:O C0_af_515_6:O C0_af_516_6:O C0_af_517_6:O C0_af_518_6:O C0_af_519_6:O C0_af_520_6:O C0_af_521_6:O C0_af_522_6:O C0_af_523_6:O C0_af_524_6:O C0_af_525_6:O C0_af_526_6:O C0_af_527_6:O C0_af_528_6:O C0_af_529_6:O C0_af_530_6:O C0_af_531_6:O C0_aa:I C1_at_50_6:O C1_at_51_6:O C1_at_52_6:O C1_at_53_6:O C1_at_54_6:O C1_at_55_6:O C1_at_56_6:O C1_at_57_6:O C1_at_58_6:O C1_at_59_6:O C1_at_510_6:O C1_at_511_6:O C1_at_512_6:O C1_at_513_6:O C1_at_514_6:O C1_at_515_6:O C1_at_516_6:O C1_at_517_6:O C1_at_518_6:O C1_at_519_6:O C1_at_520_6:O C1_at_521_6:O C1_at_522_6:O C1_at_523_6:O C1_at_524_6:O C1_at_525_6:O C1_at_526_6:O C1_at_527_6:O C1_at_528_6:O C1_at_529_6:O C1_at_530_6:O C1_at_531_6:O C1_af_50_6:O C1_af_51_6:O C1_af_52_6:O C1_af_53_6:O C1_af_54_6:O C1_af_55_6:O C1_af_56_6:O C1_af_57_6:O C1_af_58_6:O C1_af_59_6:O C1_af_510_6:O C1_af_511_6:O C1_af_512_6:O C1_af_513_6:O C1_af_514_6:O C1_af_515_6:O C1_af_516_6:O C1_af_517_6:O C1_af_518_6:O C1_af_519_6:O C1_af_520_6:O C1_af_521_6:O C1_af_522_6:O C1_af_523_6:O C1_af_524_6:O C1_af_525_6:O C1_af_526_6:O C1_af_527_6:O C1_af_528_6:O C1_af_529_6:O C1_af_530_6:O C1_af_531_6:O C1_aa:I C2_at_50_6:O C2_at_51_6:O C2_at_52_6:O C2_at_53_6:O C2_at_54_6:O C2_at_55_6:O C2_at_56_6:O C2_at_57_6:O C2_at_58_6:O C2_at_59_6:O C2_at_510_6:O C2_at_511_6:O C2_at_512_6:O C2_at_513_6:O C2_at_514_6:O C2_at_515_6:O C2_at_516_6:O C2_at_517_6:O C2_at_518_6:O C2_at_519_6:O C2_at_520_6:O C2_at_521_6:O C2_at_522_6:O C2_at_523_6:O C2_at_524_6:O C2_at_525_6:O C2_at_526_6:O C2_at_527_6:O C2_at_528_6:O C2_at_529_6:O C2_at_530_6:O C2_at_531_6:O C2_af_50_6:O C2_af_51_6:O C2_af_52_6:O C2_af_53_6:O C2_af_54_6:O C2_af_55_6:O C2_af_56_6:O C2_af_57_6:O C2_af_58_6:O C2_af_59_6:O C2_af_510_6:O C2_af_511_6:O C2_af_512_6:O C2_af_513_6:O C2_af_514_6:O C2_af_515_6:O C2_af_516_6:O C2_af_517_6:O C2_af_518_6:O C2_af_519_6:O C2_af_520_6:O C2_af_521_6:O C2_af_522_6:O C2_af_523_6:O C2_af_524_6:O C2_af_525_6:O C2_af_526_6:O C2_af_527_6:O C2_af_528_6:O C2_af_529_6:O C2_af_530_6:O C2_af_531_6:O C2_aa:I C3_at_50_6:O C3_at_51_6:O C3_at_52_6:O C3_at_53_6:O C3_at_54_6:O C3_at_55_6:O C3_at_56_6:O C3_at_57_6:O C3_at_58_6:O C3_at_59_6:O C3_at_510_6:O C3_at_511_6:O C3_at_512_6:O C3_at_513_6:O C3_at_514_6:O C3_at_515_6:O C3_at_516_6:O C3_at_517_6:O C3_at_518_6:O C3_at_519_6:O C3_at_520_6:O C3_at_521_6:O C3_at_522_6:O C3_at_523_6:O C3_at_524_6:O C3_at_525_6:O C3_at_526_6:O C3_at_527_6:O C3_at_528_6:O C3_at_529_6:O C3_at_530_6:O C3_at_531_6:O C3_af_50_6:O C3_af_51_6:O C3_af_52_6:O C3_af_53_6:O C3_af_54_6:O C3_af_55_6:O C3_af_56_6:O C3_af_57_6:O C3_af_58_6:O C3_af_59_6:O C3_af_510_6:O C3_af_511_6:O C3_af_512_6:O C3_af_513_6:O C3_af_514_6:O C3_af_515_6:O C3_af_516_6:O C3_af_517_6:O C3_af_518_6:O C3_af_519_6:O C3_af_520_6:O C3_af_521_6:O C3_af_522_6:O C3_af_523_6:O C3_af_524_6:O C3_af_525_6:O C3_af_526_6:O C3_af_527_6:O C3_af_528_6:O C3_af_529_6:O C3_af_530_6:O C3_af_531_6:O C3_aa:I
*.POWER VDD Vdd
*.POWER GND GND
*.POWER NSUB GND
*.POWER PSUB Vdd
*
* --- node flags ---
*
* __i__a (state-holding): pup_reff=1.6; pdn_reff=2.66667
* cd0_aI_aa (combinational)
* cd1_aI_aa (combinational)
* cd2_aI_aa (combinational)
* cd3_aI_aa (combinational)
* __ch__a (state-holding): pup_reff=1.6; pdn_reff=2.66667
* cd0_aC_aa (combinational)
* cd1_aC_aa (combinational)
* cd2_aC_aa (combinational)
* cd3_aC_aa (combinational)
* I_aa (combinational)
* Ch_aa (combinational)
*
* --- end node flags ---
*
M0_ Vdd cd0_aI_aa #12 Vdd pmos W=0.1625U L=0.065U
M1_ Vdd cd0_aC_aa #23 Vdd pmos W=0.1625U L=0.065U
M2_ Vdd __i__a I_aa Vdd pmos W=0.1625U L=0.065U
M3_ Vdd __ch__a Ch_aa Vdd pmos W=0.1625U L=0.065U
M4_ Vdd __i__a #fb26# Vdd pmos W=0.1625U L=0.13U
M5_ Vdd __ch__a #fb29# Vdd pmos W=0.1625U L=0.13U
M6_keeper Vdd GND #27 Vdd pmos W=0.0975U L=1.235U
M7_keeper Vdd GND #30 Vdd pmos W=0.0975U L=1.235U
M8_ GND cd0_aI_aa #5 GND nmos W=0.0975U L=0.065U
M9_ GND cd0_aC_aa #16 GND nmos W=0.0975U L=0.065U
M10_ GND __i__a I_aa GND nmos W=0.0975U L=0.065U
M11_ GND __ch__a Ch_aa GND nmos W=0.0975U L=0.065U
M12_ GND __i__a #fb26# GND nmos W=0.0975U L=0.13U
M13_ GND __ch__a #fb29# GND nmos W=0.0975U L=0.13U
M14_keeper GND Vdd #28 GND nmos W=0.0975U L=3.055U
M15_keeper GND Vdd #31 GND nmos W=0.0975U L=3.055U
M16_ #3 cd3_aI_aa __i__a GND nmos W=0.0975U L=0.065U
M17_ #10 cd3_aI_aa __i__a Vdd pmos W=0.1625U L=0.065U
M18_keeper #27 #fb26# __i__a Vdd pmos W=0.0975U L=0.065U
M19_keeper #28 #fb26# __i__a GND nmos W=0.0975U L=0.065U
M20_ #4 cd2_aI_aa #3 GND nmos W=0.0975U L=0.065U
M21_ #5 cd1_aI_aa #4 GND nmos W=0.0975U L=0.065U
M22_ #11 cd2_aI_aa #10 Vdd pmos W=0.1625U L=0.065U
M23_ #12 cd1_aI_aa #11 Vdd pmos W=0.1625U L=0.065U
M24_ #14 cd3_aC_aa __ch__a GND nmos W=0.0975U L=0.065U
M25_ #21 cd3_aC_aa __ch__a Vdd pmos W=0.1625U L=0.065U
M26_keeper #30 #fb29# __ch__a Vdd pmos W=0.0975U L=0.065U
M27_keeper #31 #fb29# __ch__a GND nmos W=0.0975U L=0.065U
M28_ #15 cd2_aC_aa #14 GND nmos W=0.0975U L=0.065U
M29_ #16 cd1_aC_aa #15 GND nmos W=0.0975U L=0.065U
M30_ #22 cd2_aC_aa #21 Vdd pmos W=0.1625U L=0.065U
M31_ #23 cd1_aC_aa #22 Vdd pmos W=0.1625U L=0.065U
xcd1 reset Ch_at_52_6 Ch_af_52_6 cd1_aC_aa I_at_50_6 I_at_51_6 I_at_52_6 I_at_53_6 I_at_54_6 I_at_55_6 I_at_56_6 I_at_57_6 I_at_58_6 I_at_59_6 I_at_510_6 I_at_511_6 I_at_512_6 I_at_513_6 I_at_514_6 I_at_515_6 I_at_516_6 I_at_517_6 I_at_518_6 I_at_519_6 I_at_520_6 I_at_521_6 I_at_522_6 I_at_523_6 I_at_524_6 I_at_525_6 I_at_526_6 I_at_527_6 I_at_528_6 I_at_529_6 I_at_530_6 I_at_531_6 I_af_50_6 I_af_51_6 I_af_52_6 I_af_53_6 I_af_54_6 I_af_55_6 I_af_56_6 I_af_57_6 I_af_58_6 I_af_59_6 I_af_510_6 I_af_511_6 I_af_512_6 I_af_513_6 I_af_514_6 I_af_515_6 I_af_516_6 I_af_517_6 I_af_518_6 I_af_519_6 I_af_520_6 I_af_521_6 I_af_522_6 I_af_523_6 I_af_524_6 I_af_525_6 I_af_526_6 I_af_527_6 I_af_528_6 I_af_529_6 I_af_530_6 I_af_531_6 cd1_aI_aa C1_at_50_6 C1_at_51_6 C1_at_52_6 C1_at_53_6 C1_at_54_6 C1_at_55_6 C1_at_56_6 C1_at_57_6 C1_at_58_6 C1_at_59_6 C1_at_510_6 C1_at_511_6 C1_at_512_6 C1_at_513_6 C1_at_514_6 C1_at_515_6 C1_at_516_6 C1_at_517_6 C1_at_518_6 C1_at_519_6 C1_at_520_6 C1_at_521_6 C1_at_522_6 C1_at_523_6 C1_at_524_6 C1_at_525_6 C1_at_526_6 C1_at_527_6 C1_at_528_6 C1_at_529_6 C1_at_530_6 C1_at_531_6 C1_af_50_6 C1_af_51_6 C1_af_52_6 C1_af_53_6 C1_af_54_6 C1_af_55_6 C1_af_56_6 C1_af_57_6 C1_af_58_6 C1_af_59_6 C1_af_510_6 C1_af_511_6 C1_af_512_6 C1_af_513_6 C1_af_514_6 C1_af_515_6 C1_af_516_6 C1_af_517_6 C1_af_518_6 C1_af_519_6 C1_af_520_6 C1_af_521_6 C1_af_522_6 C1_af_523_6 C1_af_524_6 C1_af_525_6 C1_af_526_6 C1_af_527_6 C1_af_528_6 C1_af_529_6 C1_af_530_6 C1_af_531_6 C1_aa ChildDispatch
xcd3 reset Ch_at_50_6 Ch_af_50_6 cd3_aC_aa I_at_50_6 I_at_51_6 I_at_52_6 I_at_53_6 I_at_54_6 I_at_55_6 I_at_56_6 I_at_57_6 I_at_58_6 I_at_59_6 I_at_510_6 I_at_511_6 I_at_512_6 I_at_513_6 I_at_514_6 I_at_515_6 I_at_516_6 I_at_517_6 I_at_518_6 I_at_519_6 I_at_520_6 I_at_521_6 I_at_522_6 I_at_523_6 I_at_524_6 I_at_525_6 I_at_526_6 I_at_527_6 I_at_528_6 I_at_529_6 I_at_530_6 I_at_531_6 I_af_50_6 I_af_51_6 I_af_52_6 I_af_53_6 I_af_54_6 I_af_55_6 I_af_56_6 I_af_57_6 I_af_58_6 I_af_59_6 I_af_510_6 I_af_511_6 I_af_512_6 I_af_513_6 I_af_514_6 I_af_515_6 I_af_516_6 I_af_517_6 I_af_518_6 I_af_519_6 I_af_520_6 I_af_521_6 I_af_522_6 I_af_523_6 I_af_524_6 I_af_525_6 I_af_526_6 I_af_527_6 I_af_528_6 I_af_529_6 I_af_530_6 I_af_531_6 cd3_aI_aa C3_at_50_6 C3_at_51_6 C3_at_52_6 C3_at_53_6 C3_at_54_6 C3_at_55_6 C3_at_56_6 C3_at_57_6 C3_at_58_6 C3_at_59_6 C3_at_510_6 C3_at_511_6 C3_at_512_6 C3_at_513_6 C3_at_514_6 C3_at_515_6 C3_at_516_6 C3_at_517_6 C3_at_518_6 C3_at_519_6 C3_at_520_6 C3_at_521_6 C3_at_522_6 C3_at_523_6 C3_at_524_6 C3_at_525_6 C3_at_526_6 C3_at_527_6 C3_at_528_6 C3_at_529_6 C3_at_530_6 C3_at_531_6 C3_af_50_6 C3_af_51_6 C3_af_52_6 C3_af_53_6 C3_af_54_6 C3_af_55_6 C3_af_56_6 C3_af_57_6 C3_af_58_6 C3_af_59_6 C3_af_510_6 C3_af_511_6 C3_af_512_6 C3_af_513_6 C3_af_514_6 C3_af_515_6 C3_af_516_6 C3_af_517_6 C3_af_518_6 C3_af_519_6 C3_af_520_6 C3_af_521_6 C3_af_522_6 C3_af_523_6 C3_af_524_6 C3_af_525_6 C3_af_526_6 C3_af_527_6 C3_af_528_6 C3_af_529_6 C3_af_530_6 C3_af_531_6 C3_aa ChildDispatch
xcd2 reset Ch_at_51_6 Ch_af_51_6 cd2_aC_aa I_at_50_6 I_at_51_6 I_at_52_6 I_at_53_6 I_at_54_6 I_at_55_6 I_at_56_6 I_at_57_6 I_at_58_6 I_at_59_6 I_at_510_6 I_at_511_6 I_at_512_6 I_at_513_6 I_at_514_6 I_at_515_6 I_at_516_6 I_at_517_6 I_at_518_6 I_at_519_6 I_at_520_6 I_at_521_6 I_at_522_6 I_at_523_6 I_at_524_6 I_at_525_6 I_at_526_6 I_at_527_6 I_at_528_6 I_at_529_6 I_at_530_6 I_at_531_6 I_af_50_6 I_af_51_6 I_af_52_6 I_af_53_6 I_af_54_6 I_af_55_6 I_af_56_6 I_af_57_6 I_af_58_6 I_af_59_6 I_af_510_6 I_af_511_6 I_af_512_6 I_af_513_6 I_af_514_6 I_af_515_6 I_af_516_6 I_af_517_6 I_af_518_6 I_af_519_6 I_af_520_6 I_af_521_6 I_af_522_6 I_af_523_6 I_af_524_6 I_af_525_6 I_af_526_6 I_af_527_6 I_af_528_6 I_af_529_6 I_af_530_6 I_af_531_6 cd2_aI_aa C2_at_50_6 C2_at_51_6 C2_at_52_6 C2_at_53_6 C2_at_54_6 C2_at_55_6 C2_at_56_6 C2_at_57_6 C2_at_58_6 C2_at_59_6 C2_at_510_6 C2_at_511_6 C2_at_512_6 C2_at_513_6 C2_at_514_6 C2_at_515_6 C2_at_516_6 C2_at_517_6 C2_at_518_6 C2_at_519_6 C2_at_520_6 C2_at_521_6 C2_at_522_6 C2_at_523_6 C2_at_524_6 C2_at_525_6 C2_at_526_6 C2_at_527_6 C2_at_528_6 C2_at_529_6 C2_at_530_6 C2_at_531_6 C2_af_50_6 C2_af_51_6 C2_af_52_6 C2_af_53_6 C2_af_54_6 C2_af_55_6 C2_af_56_6 C2_af_57_6 C2_af_58_6 C2_af_59_6 C2_af_510_6 C2_af_511_6 C2_af_512_6 C2_af_513_6 C2_af_514_6 C2_af_515_6 C2_af_516_6 C2_af_517_6 C2_af_518_6 C2_af_519_6 C2_af_520_6 C2_af_521_6 C2_af_522_6 C2_af_523_6 C2_af_524_6 C2_af_525_6 C2_af_526_6 C2_af_527_6 C2_af_528_6 C2_af_529_6 C2_af_530_6 C2_af_531_6 C2_aa ChildDispatch
xcd0 reset Ch_at_53_6 Ch_af_53_6 cd0_aC_aa I_at_50_6 I_at_51_6 I_at_52_6 I_at_53_6 I_at_54_6 I_at_55_6 I_at_56_6 I_at_57_6 I_at_58_6 I_at_59_6 I_at_510_6 I_at_511_6 I_at_512_6 I_at_513_6 I_at_514_6 I_at_515_6 I_at_516_6 I_at_517_6 I_at_518_6 I_at_519_6 I_at_520_6 I_at_521_6 I_at_522_6 I_at_523_6 I_at_524_6 I_at_525_6 I_at_526_6 I_at_527_6 I_at_528_6 I_at_529_6 I_at_530_6 I_at_531_6 I_af_50_6 I_af_51_6 I_af_52_6 I_af_53_6 I_af_54_6 I_af_55_6 I_af_56_6 I_af_57_6 I_af_58_6 I_af_59_6 I_af_510_6 I_af_511_6 I_af_512_6 I_af_513_6 I_af_514_6 I_af_515_6 I_af_516_6 I_af_517_6 I_af_518_6 I_af_519_6 I_af_520_6 I_af_521_6 I_af_522_6 I_af_523_6 I_af_524_6 I_af_525_6 I_af_526_6 I_af_527_6 I_af_528_6 I_af_529_6 I_af_530_6 I_af_531_6 cd0_aI_aa C0_at_50_6 C0_at_51_6 C0_at_52_6 C0_at_53_6 C0_at_54_6 C0_at_55_6 C0_at_56_6 C0_at_57_6 C0_at_58_6 C0_at_59_6 C0_at_510_6 C0_at_511_6 C0_at_512_6 C0_at_513_6 C0_at_514_6 C0_at_515_6 C0_at_516_6 C0_at_517_6 C0_at_518_6 C0_at_519_6 C0_at_520_6 C0_at_521_6 C0_at_522_6 C0_at_523_6 C0_at_524_6 C0_at_525_6 C0_at_526_6 C0_at_527_6 C0_at_528_6 C0_at_529_6 C0_at_530_6 C0_at_531_6 C0_af_50_6 C0_af_51_6 C0_af_52_6 C0_af_53_6 C0_af_54_6 C0_af_55_6 C0_af_56_6 C0_af_57_6 C0_af_58_6 C0_af_59_6 C0_af_510_6 C0_af_511_6 C0_af_512_6 C0_af_513_6 C0_af_514_6 C0_af_515_6 C0_af_516_6 C0_af_517_6 C0_af_518_6 C0_af_519_6 C0_af_520_6 C0_af_521_6 C0_af_522_6 C0_af_523_6 C0_af_524_6 C0_af_525_6 C0_af_526_6 C0_af_527_6 C0_af_528_6 C0_af_529_6 C0_af_530_6 C0_af_531_6 C0_aa ChildDispatch
.ends
*---- end of process: PayloadDispatch<> -----
*
*---- act defproc: Merge<4,f> -----
* raw ports:  I0.t[0] I0.t[1] I0.t[2] I0.t[3] I0.f[0] I0.f[1] I0.f[2] I0.f[3] I0.a I1.t[0] I1.t[1] I1.t[2] I1.t[3] I1.f[0] I1.f[1] I1.f[2] I1.f[3] I1.a O.t[0] O.t[1] O.t[2] O.t[3] O.f[0] O.f[1] O.f[2] O.f[3] O.a
*
.subckt Merge_34_7f_4 I0_at_50_6 I0_at_51_6 I0_at_52_6 I0_at_53_6 I0_af_50_6 I0_af_51_6 I0_af_52_6 I0_af_53_6 I0_aa I1_at_50_6 I1_at_51_6 I1_at_52_6 I1_at_53_6 I1_af_50_6 I1_af_51_6 I1_af_52_6 I1_af_53_6 I1_aa O_at_50_6 O_at_51_6 O_at_52_6 O_at_53_6 O_af_50_6 O_af_51_6 O_af_52_6 O_af_53_6 O_aa
*.PININFO I0_at_50_6:I I0_at_51_6:I I0_at_52_6:I I0_at_53_6:I I0_af_50_6:I I0_af_51_6:I I0_af_52_6:I I0_af_53_6:I I0_aa:O I1_at_50_6:I I1_at_51_6:I I1_at_52_6:I I1_at_53_6:I I1_af_50_6:I I1_af_51_6:I I1_af_52_6:I I1_af_53_6:I I1_aa:O O_at_50_6:O O_at_51_6:O O_at_52_6:O O_at_53_6:O O_af_50_6:O O_af_51_6:O O_af_52_6:O O_af_53_6:O O_aa:I
*.POWER VDD Vdd
*.POWER GND GND
*.POWER NSUB GND
*.POWER PSUB Vdd
*
* --- node flags ---
*
* n__I0__a (state-holding): pup_reff=0.4; pdn_reff=1.33333
* n__I1__a (state-holding): pup_reff=0.4; pdn_reff=1.33333
* n__O__t_50_6 (combinational)
* n__O__f_50_6 (combinational)
* n__O__t_51_6 (combinational)
* n__O__f_51_6 (combinational)
* n__O__t_52_6 (combinational)
* n__O__f_52_6 (combinational)
* n__O__t_53_6 (combinational)
* n__O__f_53_6 (combinational)
* I0_aa (combinational)
* I1_aa (combinational)
* O_at_50_6 (combinational)
* O_af_50_6 (combinational)
* O_at_51_6 (combinational)
* O_af_51_6 (combinational)
* O_at_52_6 (combinational)
* O_af_52_6 (combinational)
* O_at_53_6 (combinational)
* O_af_53_6 (combinational)
*
* --- end node flags ---
*
M0_ Vdd O_aa n__I0__a Vdd pmos W=0.1625U L=0.065U
M1_ Vdd O_aa n__I1__a Vdd pmos W=0.1625U L=0.065U
M2_ Vdd I0_at_50_6 #14 Vdd pmos W=0.1625U L=0.065U
M3_ Vdd I0_af_50_6 #18 Vdd pmos W=0.1625U L=0.065U
M4_ Vdd I0_at_51_6 #22 Vdd pmos W=0.1625U L=0.065U
M5_ Vdd I0_af_51_6 #26 Vdd pmos W=0.1625U L=0.065U
M6_ Vdd I0_at_52_6 #30 Vdd pmos W=0.1625U L=0.065U
M7_ Vdd I0_af_52_6 #34 Vdd pmos W=0.1625U L=0.065U
M8_ Vdd I0_at_53_6 #36 Vdd pmos W=0.1625U L=0.065U
M9_ Vdd I0_af_53_6 #38 Vdd pmos W=0.1625U L=0.065U
M10_ Vdd n__I0__a I0_aa Vdd pmos W=0.1625U L=0.065U
M11_ Vdd n__I1__a I1_aa Vdd pmos W=0.1625U L=0.065U
M12_ Vdd n__O__t_50_6 O_at_50_6 Vdd pmos W=0.1625U L=0.065U
M13_ Vdd n__O__f_50_6 O_af_50_6 Vdd pmos W=0.1625U L=0.065U
M14_ Vdd n__O__t_51_6 O_at_51_6 Vdd pmos W=0.1625U L=0.065U
M15_ Vdd n__O__f_51_6 O_af_51_6 Vdd pmos W=0.1625U L=0.065U
M16_ Vdd n__O__t_52_6 O_at_52_6 Vdd pmos W=0.1625U L=0.065U
M17_ Vdd n__O__f_52_6 O_af_52_6 Vdd pmos W=0.1625U L=0.065U
M18_ Vdd n__O__t_53_6 O_at_53_6 Vdd pmos W=0.1625U L=0.065U
M19_ Vdd n__O__f_53_6 O_af_53_6 Vdd pmos W=0.1625U L=0.065U
M20_ Vdd n__I0__a #fb49# Vdd pmos W=0.1625U L=0.13U
M21_ Vdd n__I1__a #fb52# Vdd pmos W=0.1625U L=0.13U
M22_keeper Vdd GND #50 Vdd pmos W=0.0975U L=0.585U
M23_keeper Vdd GND #53 Vdd pmos W=0.0975U L=0.585U
M24_ GND O_aa #3 GND nmos W=0.0975U L=0.065U
M25_ GND O_aa #8 GND nmos W=0.0975U L=0.065U
M26_ GND I0_at_50_6 n__O__t_50_6 GND nmos W=0.0975U L=0.065U
M27_ GND I1_at_50_6 n__O__t_50_6 GND nmos W=0.0975U L=0.065U
M28_ GND I0_af_50_6 n__O__f_50_6 GND nmos W=0.0975U L=0.065U
M29_ GND I1_af_50_6 n__O__f_50_6 GND nmos W=0.0975U L=0.065U
M30_ GND I0_at_51_6 n__O__t_51_6 GND nmos W=0.0975U L=0.065U
M31_ GND I1_at_51_6 n__O__t_51_6 GND nmos W=0.0975U L=0.065U
M32_ GND I0_af_51_6 n__O__f_51_6 GND nmos W=0.0975U L=0.065U
M33_ GND I1_af_51_6 n__O__f_51_6 GND nmos W=0.0975U L=0.065U
M34_ GND I0_at_52_6 n__O__t_52_6 GND nmos W=0.0975U L=0.065U
M35_ GND I1_at_52_6 n__O__t_52_6 GND nmos W=0.0975U L=0.065U
M36_ GND I0_af_52_6 n__O__f_52_6 GND nmos W=0.0975U L=0.065U
M37_ GND I1_af_52_6 n__O__f_52_6 GND nmos W=0.0975U L=0.065U
M38_ GND I0_at_53_6 n__O__t_53_6 GND nmos W=0.0975U L=0.065U
M39_ GND I1_at_53_6 n__O__t_53_6 GND nmos W=0.0975U L=0.065U
M40_ GND I0_af_53_6 n__O__f_53_6 GND nmos W=0.0975U L=0.065U
M41_ GND I1_af_53_6 n__O__f_53_6 GND nmos W=0.0975U L=0.065U
M42_ GND n__I0__a I0_aa GND nmos W=0.0975U L=0.065U
M43_ GND n__I1__a I1_aa GND nmos W=0.0975U L=0.065U
M44_ GND n__O__t_50_6 O_at_50_6 GND nmos W=0.0975U L=0.065U
M45_ GND n__O__f_50_6 O_af_50_6 GND nmos W=0.0975U L=0.065U
M46_ GND n__O__t_51_6 O_at_51_6 GND nmos W=0.0975U L=0.065U
M47_ GND n__O__f_51_6 O_af_51_6 GND nmos W=0.0975U L=0.065U
M48_ GND n__O__t_52_6 O_at_52_6 GND nmos W=0.0975U L=0.065U
M49_ GND n__O__f_52_6 O_af_52_6 GND nmos W=0.0975U L=0.065U
M50_ GND n__O__t_53_6 O_at_53_6 GND nmos W=0.0975U L=0.065U
M51_ GND n__O__f_53_6 O_af_53_6 GND nmos W=0.0975U L=0.065U
M52_ GND n__I0__a #fb49# GND nmos W=0.0975U L=0.13U
M53_ GND n__I1__a #fb52# GND nmos W=0.0975U L=0.13U
M54_keeper GND Vdd #51 GND nmos W=0.0975U L=0.715U
M55_keeper GND Vdd #54 GND nmos W=0.0975U L=0.715U
M56_ #3 I0_at_53_6 n__I0__a GND nmos W=0.0975U L=0.065U
M57_ #3 I0_af_53_6 n__I0__a GND nmos W=0.0975U L=0.065U
M58_keeper #50 #fb49# n__I0__a Vdd pmos W=0.0975U L=0.065U
M59_keeper #51 #fb49# n__I0__a GND nmos W=0.0975U L=0.065U
M60_ #8 I1_at_53_6 n__I1__a GND nmos W=0.0975U L=0.065U
M61_ #8 I1_af_53_6 n__I1__a GND nmos W=0.0975U L=0.065U
M62_keeper #53 #fb52# n__I1__a Vdd pmos W=0.0975U L=0.065U
M63_keeper #54 #fb52# n__I1__a GND nmos W=0.0975U L=0.065U
M64_ #14 I1_at_50_6 n__O__t_50_6 Vdd pmos W=0.1625U L=0.065U
M65_ #18 I1_af_50_6 n__O__f_50_6 Vdd pmos W=0.1625U L=0.065U
M66_ #22 I1_at_51_6 n__O__t_51_6 Vdd pmos W=0.1625U L=0.065U
M67_ #26 I1_af_51_6 n__O__f_51_6 Vdd pmos W=0.1625U L=0.065U
M68_ #30 I1_at_52_6 n__O__t_52_6 Vdd pmos W=0.1625U L=0.065U
M69_ #34 I1_af_52_6 n__O__f_52_6 Vdd pmos W=0.1625U L=0.065U
M70_ #36 I1_at_53_6 n__O__t_53_6 Vdd pmos W=0.1625U L=0.065U
M71_ #38 I1_af_53_6 n__O__f_53_6 Vdd pmos W=0.1625U L=0.065U
.ends
*---- end of process: Merge<4,f> -----
*
*---- act defproc: HalfAdderP<> -----
* raw ports:  a.t a.f d.t d.f s.t s.f
*
.subckt HalfAdderP a_at a_af d_at d_af s_at s_af
*.PININFO a_at:I a_af:I d_at:O d_af:O s_at:O s_af:O
*.POWER VDD Vdd
*.POWER GND GND
*.POWER NSUB GND
*.POWER PSUB Vdd
*
* --- node flags ---
*
* __dt (state-holding): pup_reff=0.8; pdn_reff=0.666667
* __df (state-holding): pup_reff=0.8; pdn_reff=0.666667
* __st (state-holding): pup_reff=0.8; pdn_reff=0.666667
* __sf (state-holding): pup_reff=0.8; pdn_reff=0.666667
* d_at (combinational)
* d_af (combinational)
* s_at (combinational)
* s_af (combinational)
*
* --- end node flags ---
*
M0_ Vdd a_at #4 Vdd pmos W=0.1625U L=0.065U
M1_ Vdd a_at #7 Vdd pmos W=0.1625U L=0.065U
M2_ Vdd a_at #9 Vdd pmos W=0.1625U L=0.065U
M3_ Vdd a_at #11 Vdd pmos W=0.1625U L=0.065U
M4_ Vdd __dt d_at Vdd pmos W=0.1625U L=0.065U
M5_ Vdd __df d_af Vdd pmos W=0.1625U L=0.065U
M6_ Vdd __st s_at Vdd pmos W=0.1625U L=0.065U
M7_ Vdd __sf s_af Vdd pmos W=0.1625U L=0.065U
M8_ Vdd __dt #fb16# Vdd pmos W=0.1625U L=0.13U
M9_ Vdd __df #fb19# Vdd pmos W=0.1625U L=0.13U
M10_keeper Vdd GND #17 Vdd pmos W=0.0975U L=0.26U
M11_ Vdd __st #fb22# Vdd pmos W=0.1625U L=0.13U
M12_keeper Vdd GND #20 Vdd pmos W=0.0975U L=0.26U
M13_ Vdd __sf #fb25# Vdd pmos W=0.1625U L=0.13U
M14_keeper Vdd GND #23 Vdd pmos W=0.0975U L=0.26U
M15_keeper Vdd GND #26 Vdd pmos W=0.0975U L=0.26U
M16_ GND a_at __dt GND nmos W=0.0975U L=0.065U
M17_ GND a_af __df GND nmos W=0.0975U L=0.065U
M18_ GND a_af __st GND nmos W=0.0975U L=0.065U
M19_ GND a_at __sf GND nmos W=0.0975U L=0.065U
M20_ GND __dt d_at GND nmos W=0.0975U L=0.065U
M21_ GND __df d_af GND nmos W=0.0975U L=0.065U
M22_ GND __st s_at GND nmos W=0.0975U L=0.065U
M23_ GND __sf s_af GND nmos W=0.0975U L=0.065U
M24_ GND __dt #fb16# GND nmos W=0.0975U L=0.13U
M25_ GND __df #fb19# GND nmos W=0.0975U L=0.13U
M26_keeper GND Vdd #18 GND nmos W=0.0975U L=1.495U
M27_ GND __st #fb22# GND nmos W=0.0975U L=0.13U
M28_keeper GND Vdd #21 GND nmos W=0.0975U L=1.495U
M29_ GND __sf #fb25# GND nmos W=0.0975U L=0.13U
M30_keeper GND Vdd #24 GND nmos W=0.0975U L=1.495U
M31_keeper GND Vdd #27 GND nmos W=0.0975U L=1.495U
M32_ #4 a_af __dt Vdd pmos W=0.1625U L=0.065U
M33_keeper #17 #fb16# __dt Vdd pmos W=0.0975U L=0.065U
M34_keeper #18 #fb16# __dt GND nmos W=0.0975U L=0.065U
M35_ #7 a_af __df Vdd pmos W=0.1625U L=0.065U
M36_keeper #20 #fb19# __df Vdd pmos W=0.0975U L=0.065U
M37_keeper #21 #fb19# __df GND nmos W=0.0975U L=0.065U
M38_ #9 a_af __st Vdd pmos W=0.1625U L=0.065U
M39_keeper #23 #fb22# __st Vdd pmos W=0.0975U L=0.065U
M40_keeper #24 #fb22# __st GND nmos W=0.0975U L=0.065U
M41_ #11 a_af __sf Vdd pmos W=0.1625U L=0.065U
M42_keeper #26 #fb25# __sf Vdd pmos W=0.0975U L=0.065U
M43_keeper #27 #fb25# __sf GND nmos W=0.0975U L=0.065U
.ends
*---- end of process: HalfAdderP<> -----
*
*---- act defproc: FullAdderP<> -----
* raw ports:  a.t a.f c.t c.f d.t d.f s.t s.f
*
.subckt FullAdderP a_at a_af c_at c_af d_at d_af s_at s_af
*.PININFO a_at:I a_af:I c_at:I c_af:I d_at:O d_af:O s_at:O s_af:O
*.POWER VDD Vdd
*.POWER GND GND
*.POWER NSUB GND
*.POWER PSUB Vdd
*
* --- node flags ---
*
* __dt (state-holding): pup_reff=1.6; pdn_reff=0.666667
* __df (state-holding): pup_reff=1.6; pdn_reff=1.33333
* __st (state-holding): pup_reff=0.8; pdn_reff=1.33333
* __sf (state-holding): pup_reff=0.8; pdn_reff=1.33333
* d_at (combinational)
* d_af (combinational)
* s_at (combinational)
* s_af (combinational)
*
* --- end node flags ---
*
M0_ Vdd a_at #7 Vdd pmos W=0.1625U L=0.065U
M1_ Vdd a_at #14 Vdd pmos W=0.1625U L=0.065U
M2_ Vdd c_at #18 Vdd pmos W=0.1625U L=0.065U
M3_ Vdd c_at #21 Vdd pmos W=0.1625U L=0.065U
M4_ Vdd __dt d_at Vdd pmos W=0.1625U L=0.065U
M5_ Vdd __df d_af Vdd pmos W=0.1625U L=0.065U
M6_ Vdd __st s_at Vdd pmos W=0.1625U L=0.065U
M7_ Vdd __sf s_af Vdd pmos W=0.1625U L=0.065U
M8_ Vdd __dt #fb26# Vdd pmos W=0.1625U L=0.13U
M9_ Vdd __df #fb29# Vdd pmos W=0.1625U L=0.13U
M10_keeper Vdd GND #27 Vdd pmos W=0.0975U L=0.26U
M11_ Vdd __st #fb32# Vdd pmos W=0.1625U L=0.13U
M12_keeper Vdd GND #30 Vdd pmos W=0.0975U L=0.585U
M13_ Vdd __sf #fb35# Vdd pmos W=0.1625U L=0.13U
M14_keeper Vdd GND #33 Vdd pmos W=0.0975U L=0.585U
M15_keeper Vdd GND #36 Vdd pmos W=0.0975U L=0.585U
M16_ GND a_at __dt GND nmos W=0.0975U L=0.065U
M17_ GND c_at __dt GND nmos W=0.0975U L=0.065U
M18_ GND a_af #11 GND nmos W=0.0975U L=0.065U
M19_ GND c_at #16 GND nmos W=0.0975U L=0.065U
M20_ GND c_af #17 GND nmos W=0.0975U L=0.065U
M21_ GND c_af #20 GND nmos W=0.0975U L=0.065U
M22_ GND a_af #20 GND nmos W=0.0975U L=0.065U
M23_ GND __dt d_at GND nmos W=0.0975U L=0.065U
M24_ GND __df d_af GND nmos W=0.0975U L=0.065U
M25_ GND __st s_at GND nmos W=0.0975U L=0.065U
M26_ GND __sf s_af GND nmos W=0.0975U L=0.065U
M27_ GND __dt #fb26# GND nmos W=0.0975U L=0.13U
M28_ GND __df #fb29# GND nmos W=0.0975U L=0.13U
M29_keeper GND Vdd #28 GND nmos W=0.0975U L=3.055U
M30_ GND __st #fb32# GND nmos W=0.0975U L=0.13U
M31_keeper GND Vdd #31 GND nmos W=0.0975U L=3.055U
M32_ GND __sf #fb35# GND nmos W=0.0975U L=0.13U
M33_keeper GND Vdd #34 GND nmos W=0.0975U L=1.495U
M34_keeper GND Vdd #37 GND nmos W=0.0975U L=1.495U
M35_ #5 c_af __dt Vdd pmos W=0.1625U L=0.065U
M36_keeper #27 #fb26# __dt Vdd pmos W=0.0975U L=0.065U
M37_keeper #28 #fb26# __dt GND nmos W=0.0975U L=0.065U
M38_ #6 c_at #5 Vdd pmos W=0.1625U L=0.065U
M39_ #7 a_af #6 Vdd pmos W=0.1625U L=0.065U
M40_ #11 c_af __df GND nmos W=0.0975U L=0.065U
M41_ #12 c_af __df Vdd pmos W=0.1625U L=0.065U
M42_keeper #30 #fb29# __df Vdd pmos W=0.0975U L=0.065U
M43_keeper #31 #fb29# __df GND nmos W=0.0975U L=0.065U
M44_ #13 c_at #12 Vdd pmos W=0.1625U L=0.065U
M45_ #14 a_af #13 Vdd pmos W=0.1625U L=0.065U
M46_ #16 a_at __st GND nmos W=0.0975U L=0.065U
M47_ #17 a_af __st GND nmos W=0.0975U L=0.065U
M48_ #18 c_af __st Vdd pmos W=0.1625U L=0.065U
M49_keeper #33 #fb32# __st Vdd pmos W=0.0975U L=0.065U
M50_keeper #34 #fb32# __st GND nmos W=0.0975U L=0.065U
M51_ #20 c_at __sf GND nmos W=0.0975U L=0.065U
M52_ #20 a_at __sf GND nmos W=0.0975U L=0.065U
M53_ #21 c_af __sf Vdd pmos W=0.1625U L=0.065U
M54_keeper #36 #fb35# __sf Vdd pmos W=0.0975U L=0.065U
M55_keeper #37 #fb35# __sf GND nmos W=0.0975U L=0.065U
.ends
*---- end of process: FullAdderP<> -----
*
*---- act defproc: CounterDec<> -----
* raw ports:  I.t[0] I.t[1] I.t[2] I.t[3] I.t[4] I.t[5] I.t[6] I.t[7] I.f[0] I.f[1] I.f[2] I.f[3] I.f[4] I.f[5] I.f[6] I.f[7] O.t[0] O.t[1] O.t[2] O.t[3] O.t[4] O.t[5] O.t[6] O.t[7] O.f[0] O.f[1] O.f[2] O.f[3] O.f[4] O.f[5] O.f[6] O.f[7]
*
.subckt CounterDec I_at_50_6 I_at_51_6 I_at_52_6 I_at_53_6 I_at_54_6 I_at_55_6 I_at_56_6 I_at_57_6 I_af_50_6 I_af_51_6 I_af_52_6 I_af_53_6 I_af_54_6 I_af_55_6 I_af_56_6 I_af_57_6 O_at_50_6 O_at_51_6 O_at_52_6 O_at_53_6 O_at_54_6 O_at_55_6 O_at_56_6 O_at_57_6 O_af_50_6 O_af_51_6 O_af_52_6 O_af_53_6 O_af_54_6 O_af_55_6 O_af_56_6 O_af_57_6
*.PININFO I_at_50_6:I I_at_51_6:I I_at_52_6:I I_at_53_6:I I_at_54_6:I I_at_55_6:I I_at_56_6:I I_at_57_6:I I_af_50_6:I I_af_51_6:I I_af_52_6:I I_af_53_6:I I_af_54_6:I I_af_55_6:I I_af_56_6:I I_af_57_6:I O_at_50_6:O O_at_51_6:O O_at_52_6:O O_at_53_6:O O_at_54_6:O O_at_55_6:O O_at_56_6:O O_at_57_6:O O_af_50_6:O O_af_51_6:O O_af_52_6:O O_af_53_6:O O_af_54_6:O O_af_55_6:O O_af_56_6:O O_af_57_6:O
*.POWER VDD Vdd
*.POWER GND GND
*.POWER NSUB GND
*.POWER PSUB Vdd
xha I_at_50_6 I_af_50_6 ha_ad_at ha_ad_af O_at_50_6 O_af_50_6 HalfAdderP
xfa1 I_at_51_6 I_af_51_6 ha_ad_at ha_ad_af fa1_ad_at fa1_ad_af O_at_51_6 O_af_51_6 FullAdderP
xfa5 I_at_55_6 I_af_55_6 fa4_ad_at fa4_ad_af fa5_ad_at fa5_ad_af O_at_55_6 O_af_55_6 FullAdderP
xfa7 I_at_57_6 I_af_57_6 fa6_ad_at fa6_ad_af fa7_ad_at fa7_ad_af O_at_57_6 O_af_57_6 FullAdderP
xfa6 I_at_56_6 I_af_56_6 fa5_ad_at fa5_ad_af fa6_ad_at fa6_ad_af O_at_56_6 O_af_56_6 FullAdderP
xfa2 I_at_52_6 I_af_52_6 fa1_ad_at fa1_ad_af fa2_ad_at fa2_ad_af O_at_52_6 O_af_52_6 FullAdderP
xfa3 I_at_53_6 I_af_53_6 fa2_ad_at fa2_ad_af fa3_ad_at fa3_ad_af O_at_53_6 O_af_53_6 FullAdderP
xfa4 I_at_54_6 I_af_54_6 fa3_ad_at fa3_ad_af fa4_ad_at fa4_ad_af O_at_54_6 O_af_54_6 FullAdderP
.ends
*---- end of process: CounterDec<> -----
*
*---- act defproc: ChildServer<> -----
* raw ports:  reset I.t[0] I.t[1] I.t[2] I.t[3] I.f[0] I.f[1] I.f[2] I.f[3] I.a Cnt.req Cnt.t[0] Cnt.t[1] Cnt.t[2] Cnt.t[3] Cnt.t[4] Cnt.t[5] Cnt.t[6] Cnt.t[7] Cnt.f[0] Cnt.f[1] Cnt.f[2] Cnt.f[3] Cnt.f[4] Cnt.f[5] Cnt.f[6] Cnt.f[7] R.req R.t[0] R.t[1] R.t[2] R.t[3] R.t[4] R.t[5] R.t[6] R.t[7] R.f[0] R.f[1] R.f[2] R.f[3] R.f[4] R.f[5] R.f[6] R.f[7] Od.t[0] Od.t[1] Od.t[2] Od.t[3] Od.f[0] Od.f[1] Od.f[2] Od.f[3] Od.a Oc.t[0] Oc.t[1] Oc.t[2] Oc.t[3] Oc.f[0] Oc.f[1] Oc.f[2] Oc.f[3] Oc.a W.t[0] W.t[1] W.t[2] W.t[3] W.t[4] W.t[5] W.t[6] W.t[7] W.f[0] W.f[1] W.f[2] W.f[3] W.f[4] W.f[5] W.f[6] W.f[7] W.a A.req A.a
*
.subckt ChildServer reset I_at_50_6 I_at_51_6 I_at_52_6 I_at_53_6 I_af_50_6 I_af_51_6 I_af_52_6 I_af_53_6 I_aa Cnt_areq Cnt_at_50_6 Cnt_at_51_6 Cnt_at_52_6 Cnt_at_53_6 Cnt_at_54_6 Cnt_at_55_6 Cnt_at_56_6 Cnt_at_57_6 Cnt_af_50_6 Cnt_af_51_6 Cnt_af_52_6 Cnt_af_53_6 Cnt_af_54_6 Cnt_af_55_6 Cnt_af_56_6 Cnt_af_57_6 R_areq R_at_50_6 R_at_51_6 R_at_52_6 R_at_53_6 R_at_54_6 R_at_55_6 R_at_56_6 R_at_57_6 R_af_50_6 R_af_51_6 R_af_52_6 R_af_53_6 R_af_54_6 R_af_55_6 R_af_56_6 R_af_57_6 Od_at_50_6 Od_at_51_6 Od_at_52_6 Od_at_53_6 Od_af_50_6 Od_af_51_6 Od_af_52_6 Od_af_53_6 Od_aa Oc_at_50_6 Oc_at_51_6 Oc_at_52_6 Oc_at_53_6 Oc_af_50_6 Oc_af_51_6 Oc_af_52_6 Oc_af_53_6 Oc_aa W_at_50_6 W_at_51_6 W_at_52_6 W_at_53_6 W_at_54_6 W_at_55_6 W_at_56_6 W_at_57_6 W_af_50_6 W_af_51_6 W_af_52_6 W_af_53_6 W_af_54_6 W_af_55_6 W_af_56_6 W_af_57_6 W_aa A_areq A_aa
*.PININFO reset:I I_at_50_6:I I_at_51_6:I I_at_52_6:I I_at_53_6:I I_af_50_6:I I_af_51_6:I I_af_52_6:I I_af_53_6:I I_aa:O Cnt_areq:O Cnt_at_50_6:I Cnt_at_51_6:I Cnt_at_52_6:I Cnt_at_53_6:I Cnt_at_54_6:I Cnt_at_55_6:I Cnt_at_56_6:I Cnt_at_57_6:I Cnt_af_50_6:I Cnt_af_51_6:I Cnt_af_52_6:I Cnt_af_53_6:I Cnt_af_54_6:I Cnt_af_55_6:I Cnt_af_56_6:I Cnt_af_57_6:I R_areq:O R_at_50_6:I R_at_51_6:I R_at_52_6:I R_at_53_6:I R_at_54_6:I R_at_55_6:I R_at_56_6:I R_at_57_6:I R_af_50_6:I R_af_51_6:I R_af_52_6:I R_af_53_6:I R_af_54_6:I R_af_55_6:I R_af_56_6:I R_af_57_6:I Od_at_50_6:O Od_at_51_6:O Od_at_52_6:O Od_at_53_6:O Od_af_50_6:O Od_af_51_6:O Od_af_52_6:O Od_af_53_6:O Od_aa:I Oc_at_50_6:O Oc_at_51_6:O Oc_at_52_6:O Oc_at_53_6:O Oc_af_50_6:O Oc_af_51_6:O Oc_af_52_6:O Oc_af_53_6:O Oc_aa:I W_at_50_6:O W_at_51_6:O W_at_52_6:O W_at_53_6:O W_at_54_6:O W_at_55_6:O W_at_56_6:O W_at_57_6:O W_af_50_6:O W_af_51_6:O W_af_52_6:O W_af_53_6:O W_af_54_6:O W_af_55_6:O W_af_56_6:O W_af_57_6:O W_aa:I A_areq:I A_aa:O
*.POWER VDD Vdd
*.POWER GND GND
*.POWER NSUB GND
*.POWER PSUB Vdd
*
* --- node flags ---
*
* R_areq (state-holding): pup_reff=2.8; pdn_reff=0.666667
* __ar (combinational)
* s (state-holding): pup_reff=6.8; pdn_reff=6
* A_aa (state-holding): pup_reff=0.8; pdn_reff=1.33333
* p0 (combinational)
* __rr (combinational)
* __rt_57_6 (combinational)
* __q_57_6 (combinational)
* __rf_57_6 (combinational)
* q_57_6 (state-holding): pup_reff=0.4; pdn_reff=0.666667
* __rt_56_6 (combinational)
* __q_56_6 (combinational)
* __rf_56_6 (combinational)
* q_56_6 (state-holding): pup_reff=0.4; pdn_reff=0.666667
* __rt_55_6 (combinational)
* __q_55_6 (combinational)
* __rf_55_6 (combinational)
* q_55_6 (state-holding): pup_reff=0.4; pdn_reff=0.666667
* __rt_54_6 (combinational)
* __q_54_6 (combinational)
* __rf_54_6 (combinational)
* q_54_6 (state-holding): pup_reff=0.4; pdn_reff=0.666667
* __rt_53_6 (combinational)
* __q_53_6 (combinational)
* __rf_53_6 (combinational)
* q_53_6 (state-holding): pup_reff=0.4; pdn_reff=0.666667
* __rt_52_6 (combinational)
* __q_52_6 (combinational)
* __rf_52_6 (combinational)
* q_52_6 (state-holding): pup_reff=0.4; pdn_reff=0.666667
* __rt_51_6 (combinational)
* __q_51_6 (combinational)
* __rf_51_6 (combinational)
* q_51_6 (state-holding): pup_reff=0.4; pdn_reff=0.666667
* __rt_50_6 (combinational)
* __q_50_6 (combinational)
* __rf_50_6 (combinational)
* q_50_6 (state-holding): pup_reff=0.4; pdn_reff=0.666667
* b_53_6 (state-holding): pup_reff=1.2; pdn_reff=2
* __b_53_6 (combinational)
* b_52_6 (state-holding): pup_reff=1.2; pdn_reff=2
* __b_52_6 (combinational)
* b_51_6 (state-holding): pup_reff=1.2; pdn_reff=2
* __b_51_6 (combinational)
* b_50_6 (state-holding): pup_reff=1.2; pdn_reff=2
* __b_50_6 (combinational)
* j (state-holding): pup_reff=7.2; pdn_reff=6
* __s (combinational)
* __it_53_6 (combinational)
* __if_53_6 (combinational)
* __it_52_6 (combinational)
* __if_52_6 (combinational)
* __it_51_6 (combinational)
* __if_51_6 (combinational)
* __it_50_6 (combinational)
* __if_50_6 (combinational)
* __p0 (state-holding): pup_reff=1.2; pdn_reff=1.33333
* __oca (combinational)
* __oda (combinational)
* __wa (combinational)
* __r (combinational)
* p1 (state-holding): pup_reff=4; pdn_reff=0.666667
* __j (combinational)
* __ia (state-holding): pup_reff=0.4; pdn_reff=2
* Cnt_areq (state-holding): pup_reff=0.4; pdn_reff=2
* __p1 (combinational)
* dec_aI_at_50_6 (state-holding): pup_reff=1.6; pdn_reff=0.666667
* I_aa (combinational)
* dec_aI_af_50_6 (state-holding): pup_reff=1.6; pdn_reff=0.666667
* dec_aI_at_51_6 (state-holding): pup_reff=1.6; pdn_reff=0.666667
* dec_aI_af_51_6 (state-holding): pup_reff=1.6; pdn_reff=0.666667
* dec_aI_at_52_6 (state-holding): pup_reff=1.6; pdn_reff=0.666667
* dec_aI_af_52_6 (state-holding): pup_reff=1.6; pdn_reff=0.666667
* dec_aI_at_53_6 (state-holding): pup_reff=1.6; pdn_reff=0.666667
* dec_aI_af_53_6 (state-holding): pup_reff=1.6; pdn_reff=0.666667
* dec_aI_at_54_6 (state-holding): pup_reff=1.6; pdn_reff=0.666667
* dec_aI_af_54_6 (state-holding): pup_reff=1.6; pdn_reff=0.666667
* dec_aI_at_55_6 (state-holding): pup_reff=1.6; pdn_reff=0.666667
* dec_aI_af_55_6 (state-holding): pup_reff=1.6; pdn_reff=0.666667
* dec_aI_at_56_6 (state-holding): pup_reff=1.6; pdn_reff=0.666667
* dec_aI_af_56_6 (state-holding): pup_reff=1.6; pdn_reff=0.666667
* dec_aI_at_57_6 (state-holding): pup_reff=1.6; pdn_reff=0.666667
* dec_aI_af_57_6 (state-holding): pup_reff=1.6; pdn_reff=0.666667
* Od_at_50_6 (state-holding): pup_reff=1.6; pdn_reff=0.666667
* Od_af_50_6 (state-holding): pup_reff=1.6; pdn_reff=0.666667
* Oc_at_50_6 (state-holding): pup_reff=1.6; pdn_reff=0.666667
* Oc_af_50_6 (state-holding): pup_reff=1.6; pdn_reff=0.666667
* Od_at_51_6 (state-holding): pup_reff=1.6; pdn_reff=0.666667
* Od_af_51_6 (state-holding): pup_reff=1.6; pdn_reff=0.666667
* Oc_at_51_6 (state-holding): pup_reff=1.6; pdn_reff=0.666667
* Oc_af_51_6 (state-holding): pup_reff=1.6; pdn_reff=0.666667
* Od_at_52_6 (state-holding): pup_reff=1.6; pdn_reff=0.666667
* Od_af_52_6 (state-holding): pup_reff=1.6; pdn_reff=0.666667
* Oc_at_52_6 (state-holding): pup_reff=1.6; pdn_reff=0.666667
* Oc_af_52_6 (state-holding): pup_reff=1.6; pdn_reff=0.666667
* Od_at_53_6 (state-holding): pup_reff=1.6; pdn_reff=0.666667
* Od_af_53_6 (state-holding): pup_reff=1.6; pdn_reff=0.666667
* Oc_at_53_6 (state-holding): pup_reff=1.6; pdn_reff=0.666667
* Oc_af_53_6 (state-holding): pup_reff=1.6; pdn_reff=0.666667
* __wt_50_6 (combinational)
* dec_aO_at_50_6 (combinational)
* __wf_50_6 (combinational)
* dec_aO_af_50_6 (combinational)
* W_at_50_6 (combinational)
* W_af_50_6 (combinational)
* __wt_51_6 (combinational)
* dec_aO_at_51_6 (combinational)
* __wf_51_6 (combinational)
* dec_aO_af_51_6 (combinational)
* W_at_51_6 (combinational)
* W_af_51_6 (combinational)
* __wt_52_6 (combinational)
* dec_aO_at_52_6 (combinational)
* __wf_52_6 (combinational)
* dec_aO_af_52_6 (combinational)
* W_at_52_6 (combinational)
* W_af_52_6 (combinational)
* __wt_53_6 (combinational)
* dec_aO_at_53_6 (combinational)
* __wf_53_6 (combinational)
* dec_aO_af_53_6 (combinational)
* W_at_53_6 (combinational)
* W_af_53_6 (combinational)
* __wt_54_6 (combinational)
* dec_aO_at_54_6 (combinational)
* __wf_54_6 (combinational)
* dec_aO_af_54_6 (combinational)
* W_at_54_6 (combinational)
* W_af_54_6 (combinational)
* __wt_55_6 (combinational)
* dec_aO_at_55_6 (combinational)
* __wf_55_6 (combinational)
* dec_aO_af_55_6 (combinational)
* W_at_55_6 (combinational)
* W_af_55_6 (combinational)
* __wt_56_6 (combinational)
* dec_aO_at_56_6 (combinational)
* __wf_56_6 (combinational)
* dec_aO_af_56_6 (combinational)
* W_at_56_6 (combinational)
* W_af_56_6 (combinational)
* __wt_57_6 (combinational)
* dec_aO_at_57_6 (combinational)
* __wf_57_6 (combinational)
* dec_aO_af_57_6 (combinational)
* W_at_57_6 (combinational)
* W_af_57_6 (combinational)
*
* --- end node flags ---
*
M0_ Vdd __ar #8 Vdd pmos W=0.1625U L=0.065U
M1_ Vdd __rr #17 Vdd pmos W=0.1625U L=0.065U
M2_ Vdd __s #104 Vdd pmos W=0.1625U L=0.065U
M3_ Vdd __oca #156 Vdd pmos W=0.1625U L=0.065U
M4_ Vdd __r __p0 Vdd pmos W=0.1625U L=0.065U
M5_ Vdd A_aa #163 Vdd pmos W=0.1625U L=0.065U
M6_ Vdd j __ia Vdd pmos W=0.1625U L=0.065U
M7_ Vdd __p1 Cnt_areq Vdd pmos W=0.1625U L=0.065U
M8_ Vdd __wa #179 Vdd pmos W=0.1625U L=0.065U
M9_ Vdd __rt_50_6 q_50_6 Vdd pmos W=0.1625U L=0.065U
M10_ Vdd __p0 #184 Vdd pmos W=0.1625U L=0.065U
M11_ Vdd __p0 #189 Vdd pmos W=0.1625U L=0.065U
M12_ Vdd __rt_51_6 q_51_6 Vdd pmos W=0.1625U L=0.065U
M13_ Vdd __p0 #193 Vdd pmos W=0.1625U L=0.065U
M14_ Vdd __p0 #197 Vdd pmos W=0.1625U L=0.065U
M15_ Vdd __rt_52_6 q_52_6 Vdd pmos W=0.1625U L=0.065U
M16_ Vdd __p0 #201 Vdd pmos W=0.1625U L=0.065U
M17_ Vdd __p0 #205 Vdd pmos W=0.1625U L=0.065U
M18_ Vdd __rt_53_6 q_53_6 Vdd pmos W=0.1625U L=0.065U
M19_ Vdd __p0 #209 Vdd pmos W=0.1625U L=0.065U
M20_ Vdd __p0 #213 Vdd pmos W=0.1625U L=0.065U
M21_ Vdd __rt_54_6 q_54_6 Vdd pmos W=0.1625U L=0.065U
M22_ Vdd __p0 #217 Vdd pmos W=0.1625U L=0.065U
M23_ Vdd __p0 #221 Vdd pmos W=0.1625U L=0.065U
M24_ Vdd __rt_55_6 q_55_6 Vdd pmos W=0.1625U L=0.065U
M25_ Vdd __p0 #225 Vdd pmos W=0.1625U L=0.065U
M26_ Vdd __p0 #229 Vdd pmos W=0.1625U L=0.065U
M27_ Vdd __rt_56_6 q_56_6 Vdd pmos W=0.1625U L=0.065U
M28_ Vdd __p0 #233 Vdd pmos W=0.1625U L=0.065U
M29_ Vdd __p0 #237 Vdd pmos W=0.1625U L=0.065U
M30_ Vdd __rt_57_6 q_57_6 Vdd pmos W=0.1625U L=0.065U
M31_ Vdd __p0 #241 Vdd pmos W=0.1625U L=0.065U
M32_ Vdd __p0 #245 Vdd pmos W=0.1625U L=0.065U
M33_ Vdd __p0 #247 Vdd pmos W=0.1625U L=0.065U
M34_ Vdd __p0 #253 Vdd pmos W=0.1625U L=0.065U
M35_ Vdd __p0 #257 Vdd pmos W=0.1625U L=0.065U
M36_ Vdd __p0 #261 Vdd pmos W=0.1625U L=0.065U
M37_ Vdd __p0 #265 Vdd pmos W=0.1625U L=0.065U
M38_ Vdd __p0 #267 Vdd pmos W=0.1625U L=0.065U
M39_ Vdd __p0 #273 Vdd pmos W=0.1625U L=0.065U
M40_ Vdd __p0 #277 Vdd pmos W=0.1625U L=0.065U
M41_ Vdd __p0 #281 Vdd pmos W=0.1625U L=0.065U
M42_ Vdd __p0 #285 Vdd pmos W=0.1625U L=0.065U
M43_ Vdd __p0 #287 Vdd pmos W=0.1625U L=0.065U
M44_ Vdd __p0 #293 Vdd pmos W=0.1625U L=0.065U
M45_ Vdd __p0 #297 Vdd pmos W=0.1625U L=0.065U
M46_ Vdd __p0 #301 Vdd pmos W=0.1625U L=0.065U
M47_ Vdd __p0 #305 Vdd pmos W=0.1625U L=0.065U
M48_ Vdd __p0 #307 Vdd pmos W=0.1625U L=0.065U
M49_ Vdd __p0 #313 Vdd pmos W=0.1625U L=0.065U
M50_ Vdd __p0 #317 Vdd pmos W=0.1625U L=0.065U
M51_ Vdd __p0 #321 Vdd pmos W=0.1625U L=0.065U
M52_ Vdd __p0 #325 Vdd pmos W=0.1625U L=0.065U
M53_ Vdd Cnt_at_50_6 #327 Vdd pmos W=0.1625U L=0.065U
M54_ Vdd Cnt_af_50_6 #331 Vdd pmos W=0.1625U L=0.065U
M55_ Vdd __wt_50_6 W_at_50_6 Vdd pmos W=0.1625U L=0.065U
M56_ Vdd __wf_50_6 W_af_50_6 Vdd pmos W=0.1625U L=0.065U
M57_ Vdd Cnt_at_51_6 #337 Vdd pmos W=0.1625U L=0.065U
M58_ Vdd Cnt_af_51_6 #341 Vdd pmos W=0.1625U L=0.065U
M59_ Vdd __wt_51_6 W_at_51_6 Vdd pmos W=0.1625U L=0.065U
M60_ Vdd __wf_51_6 W_af_51_6 Vdd pmos W=0.1625U L=0.065U
M61_ Vdd Cnt_at_52_6 #347 Vdd pmos W=0.1625U L=0.065U
M62_ Vdd Cnt_af_52_6 #351 Vdd pmos W=0.1625U L=0.065U
M63_ Vdd __wt_52_6 W_at_52_6 Vdd pmos W=0.1625U L=0.065U
M64_ Vdd __wf_52_6 W_af_52_6 Vdd pmos W=0.1625U L=0.065U
M65_ Vdd Cnt_at_53_6 #357 Vdd pmos W=0.1625U L=0.065U
M66_ Vdd Cnt_af_53_6 #361 Vdd pmos W=0.1625U L=0.065U
M67_ Vdd __wt_53_6 W_at_53_6 Vdd pmos W=0.1625U L=0.065U
M68_ Vdd __wf_53_6 W_af_53_6 Vdd pmos W=0.1625U L=0.065U
M69_ Vdd Cnt_at_54_6 #367 Vdd pmos W=0.1625U L=0.065U
M70_ Vdd Cnt_af_54_6 #371 Vdd pmos W=0.1625U L=0.065U
M71_ Vdd __wt_54_6 W_at_54_6 Vdd pmos W=0.1625U L=0.065U
M72_ Vdd __wf_54_6 W_af_54_6 Vdd pmos W=0.1625U L=0.065U
M73_ Vdd Cnt_at_55_6 #377 Vdd pmos W=0.1625U L=0.065U
M74_ Vdd Cnt_af_55_6 #381 Vdd pmos W=0.1625U L=0.065U
M75_ Vdd __wt_55_6 W_at_55_6 Vdd pmos W=0.1625U L=0.065U
M76_ Vdd __wf_55_6 W_af_55_6 Vdd pmos W=0.1625U L=0.065U
M77_ Vdd Cnt_at_56_6 #387 Vdd pmos W=0.1625U L=0.065U
M78_ Vdd Cnt_af_56_6 #391 Vdd pmos W=0.1625U L=0.065U
M79_ Vdd __wt_56_6 W_at_56_6 Vdd pmos W=0.1625U L=0.065U
M80_ Vdd __wf_56_6 W_af_56_6 Vdd pmos W=0.1625U L=0.065U
M81_ Vdd Cnt_at_57_6 #397 Vdd pmos W=0.1625U L=0.065U
M82_ Vdd Cnt_af_57_6 #401 Vdd pmos W=0.1625U L=0.065U
M83_ Vdd __wt_57_6 W_at_57_6 Vdd pmos W=0.1625U L=0.065U
M84_ Vdd __wf_57_6 W_af_57_6 Vdd pmos W=0.1625U L=0.065U
M85_ Vdd A_areq __ar Vdd pmos W=0.1625U L=0.065U
M86_ Vdd R_areq __rr Vdd pmos W=0.1625U L=0.065U
M87_ Vdd s __s Vdd pmos W=0.1625U L=0.065U
M88_ Vdd j __j Vdd pmos W=0.1625U L=0.065U
M89_ Vdd p1 __p1 Vdd pmos W=0.1625U L=0.065U
M90_ Vdd reset __r Vdd pmos W=0.1625U L=0.065U
M91_ Vdd Oc_aa __oca Vdd pmos W=0.1625U L=0.065U
M92_ Vdd Od_aa __oda Vdd pmos W=0.1625U L=0.065U
M93_ Vdd W_aa __wa Vdd pmos W=0.1625U L=0.065U
M94_ Vdd R_at_50_6 __rt_50_6 Vdd pmos W=0.1625U L=0.065U
M95_ Vdd R_af_50_6 __rf_50_6 Vdd pmos W=0.1625U L=0.065U
M96_ Vdd q_50_6 __q_50_6 Vdd pmos W=0.1625U L=0.065U
M97_ Vdd R_at_51_6 __rt_51_6 Vdd pmos W=0.1625U L=0.065U
M98_ Vdd R_af_51_6 __rf_51_6 Vdd pmos W=0.1625U L=0.065U
M99_ Vdd q_51_6 __q_51_6 Vdd pmos W=0.1625U L=0.065U
M100_ Vdd R_at_52_6 __rt_52_6 Vdd pmos W=0.1625U L=0.065U
M101_ Vdd R_af_52_6 __rf_52_6 Vdd pmos W=0.1625U L=0.065U
M102_ Vdd q_52_6 __q_52_6 Vdd pmos W=0.1625U L=0.065U
M103_ Vdd R_at_53_6 __rt_53_6 Vdd pmos W=0.1625U L=0.065U
M104_ Vdd R_af_53_6 __rf_53_6 Vdd pmos W=0.1625U L=0.065U
M105_ Vdd q_53_6 __q_53_6 Vdd pmos W=0.1625U L=0.065U
M106_ Vdd R_at_54_6 __rt_54_6 Vdd pmos W=0.1625U L=0.065U
M107_ Vdd R_af_54_6 __rf_54_6 Vdd pmos W=0.1625U L=0.065U
M108_ Vdd q_54_6 __q_54_6 Vdd pmos W=0.1625U L=0.065U
M109_ Vdd R_at_55_6 __rt_55_6 Vdd pmos W=0.1625U L=0.065U
M110_ Vdd R_af_55_6 __rf_55_6 Vdd pmos W=0.1625U L=0.065U
M111_ Vdd q_55_6 __q_55_6 Vdd pmos W=0.1625U L=0.065U
M112_ Vdd R_at_56_6 __rt_56_6 Vdd pmos W=0.1625U L=0.065U
M113_ Vdd R_af_56_6 __rf_56_6 Vdd pmos W=0.1625U L=0.065U
M114_ Vdd q_56_6 __q_56_6 Vdd pmos W=0.1625U L=0.065U
M115_ Vdd R_at_57_6 __rt_57_6 Vdd pmos W=0.1625U L=0.065U
M116_ Vdd R_af_57_6 __rf_57_6 Vdd pmos W=0.1625U L=0.065U
M117_ Vdd q_57_6 __q_57_6 Vdd pmos W=0.1625U L=0.065U
M118_ Vdd I_at_50_6 __it_50_6 Vdd pmos W=0.1625U L=0.065U
M119_ Vdd I_af_50_6 __if_50_6 Vdd pmos W=0.1625U L=0.065U
M120_ Vdd b_50_6 __b_50_6 Vdd pmos W=0.1625U L=0.065U
M121_ Vdd I_at_51_6 __it_51_6 Vdd pmos W=0.1625U L=0.065U
M122_ Vdd I_af_51_6 __if_51_6 Vdd pmos W=0.1625U L=0.065U
M123_ Vdd b_51_6 __b_51_6 Vdd pmos W=0.1625U L=0.065U
M124_ Vdd I_at_52_6 __it_52_6 Vdd pmos W=0.1625U L=0.065U
M125_ Vdd I_af_52_6 __if_52_6 Vdd pmos W=0.1625U L=0.065U
M126_ Vdd b_52_6 __b_52_6 Vdd pmos W=0.1625U L=0.065U
M127_ Vdd I_at_53_6 __it_53_6 Vdd pmos W=0.1625U L=0.065U
M128_ Vdd I_af_53_6 __if_53_6 Vdd pmos W=0.1625U L=0.065U
M129_ Vdd b_53_6 __b_53_6 Vdd pmos W=0.1625U L=0.065U
M130_ Vdd __p0 p0 Vdd pmos W=0.1625U L=0.065U
M131_ Vdd __ia I_aa Vdd pmos W=0.1625U L=0.065U
M132_ Vdd R_areq #fb407# Vdd pmos W=0.1625U L=0.13U
M133_ Vdd s #fb410# Vdd pmos W=0.1625U L=0.13U
M134_keeper Vdd GND #408 Vdd pmos W=0.0975U L=0.26U
M135_ Vdd A_aa #fb413# Vdd pmos W=0.1625U L=0.13U
M136_keeper Vdd GND #411 Vdd pmos W=0.0975U L=2.86U
M137_ Vdd q_57_6 #fb416# Vdd pmos W=0.1625U L=0.13U
M138_keeper Vdd GND #414 Vdd pmos W=0.0975U L=0.585U
M139_ Vdd q_56_6 #fb419# Vdd pmos W=0.1625U L=0.13U
M140_keeper Vdd GND #417 Vdd pmos W=0.0975U L=0.26U
M141_ Vdd q_55_6 #fb422# Vdd pmos W=0.1625U L=0.13U
M142_keeper Vdd GND #420 Vdd pmos W=0.0975U L=0.26U
M143_ Vdd q_54_6 #fb425# Vdd pmos W=0.1625U L=0.13U
M144_keeper Vdd GND #423 Vdd pmos W=0.0975U L=0.26U
M145_ Vdd q_53_6 #fb428# Vdd pmos W=0.1625U L=0.13U
M146_keeper Vdd GND #426 Vdd pmos W=0.0975U L=0.26U
M147_ Vdd q_52_6 #fb431# Vdd pmos W=0.1625U L=0.13U
M148_keeper Vdd GND #429 Vdd pmos W=0.0975U L=0.26U
M149_ Vdd q_51_6 #fb434# Vdd pmos W=0.1625U L=0.13U
M150_keeper Vdd GND #432 Vdd pmos W=0.0975U L=0.26U
M151_ Vdd q_50_6 #fb437# Vdd pmos W=0.1625U L=0.13U
M152_keeper Vdd GND #435 Vdd pmos W=0.0975U L=0.26U
M153_ Vdd b_53_6 #fb440# Vdd pmos W=0.1625U L=0.13U
M154_keeper Vdd GND #438 Vdd pmos W=0.0975U L=0.26U
M155_ Vdd b_52_6 #fb443# Vdd pmos W=0.1625U L=0.13U
M156_keeper Vdd GND #441 Vdd pmos W=0.0975U L=0.91U
M157_ Vdd b_51_6 #fb446# Vdd pmos W=0.1625U L=0.13U
M158_keeper Vdd GND #444 Vdd pmos W=0.0975U L=0.91U
M159_ Vdd b_50_6 #fb449# Vdd pmos W=0.1625U L=0.13U
M160_keeper Vdd GND #447 Vdd pmos W=0.0975U L=0.91U
M161_ Vdd j #fb452# Vdd pmos W=0.1625U L=0.13U
M162_keeper Vdd GND #450 Vdd pmos W=0.0975U L=0.91U
M163_ Vdd __p0 #fb455# Vdd pmos W=0.1625U L=0.13U
M164_keeper Vdd GND #453 Vdd pmos W=0.0975U L=2.86U
M165_ Vdd p1 #fb458# Vdd pmos W=0.1625U L=0.13U
M166_keeper Vdd GND #456 Vdd pmos W=0.0975U L=0.585U
M167_ Vdd __ia #fb461# Vdd pmos W=0.1625U L=0.13U
M168_keeper Vdd GND #459 Vdd pmos W=0.0975U L=0.26U
M169_ Vdd Cnt_areq #fb464# Vdd pmos W=0.1625U L=0.13U
M170_keeper Vdd GND #462 Vdd pmos W=0.0975U L=0.91U
M171_ Vdd dec_aI_at_50_6 #fb467# Vdd pmos W=0.1625U L=0.13U
M172_keeper Vdd GND #465 Vdd pmos W=0.0975U L=0.91U
M173_ Vdd dec_aI_af_50_6 #fb470# Vdd pmos W=0.1625U L=0.13U
M174_keeper Vdd GND #468 Vdd pmos W=0.0975U L=0.26U
M175_ Vdd dec_aI_at_51_6 #fb473# Vdd pmos W=0.1625U L=0.13U
M176_keeper Vdd GND #471 Vdd pmos W=0.0975U L=0.26U
M177_ Vdd dec_aI_af_51_6 #fb476# Vdd pmos W=0.1625U L=0.13U
M178_keeper Vdd GND #474 Vdd pmos W=0.0975U L=0.26U
M179_ Vdd dec_aI_at_52_6 #fb479# Vdd pmos W=0.1625U L=0.13U
M180_keeper Vdd GND #477 Vdd pmos W=0.0975U L=0.26U
M181_ Vdd dec_aI_af_52_6 #fb482# Vdd pmos W=0.1625U L=0.13U
M182_keeper Vdd GND #480 Vdd pmos W=0.0975U L=0.26U
M183_ Vdd dec_aI_at_53_6 #fb485# Vdd pmos W=0.1625U L=0.13U
M184_keeper Vdd GND #483 Vdd pmos W=0.0975U L=0.26U
M185_ Vdd dec_aI_af_53_6 #fb488# Vdd pmos W=0.1625U L=0.13U
M186_keeper Vdd GND #486 Vdd pmos W=0.0975U L=0.26U
M187_ Vdd dec_aI_at_54_6 #fb491# Vdd pmos W=0.1625U L=0.13U
M188_keeper Vdd GND #489 Vdd pmos W=0.0975U L=0.26U
M189_ Vdd dec_aI_af_54_6 #fb494# Vdd pmos W=0.1625U L=0.13U
M190_keeper Vdd GND #492 Vdd pmos W=0.0975U L=0.26U
M191_ Vdd dec_aI_at_55_6 #fb497# Vdd pmos W=0.1625U L=0.13U
M192_keeper Vdd GND #495 Vdd pmos W=0.0975U L=0.26U
M193_ Vdd dec_aI_af_55_6 #fb500# Vdd pmos W=0.1625U L=0.13U
M194_keeper Vdd GND #498 Vdd pmos W=0.0975U L=0.26U
M195_ Vdd dec_aI_at_56_6 #fb503# Vdd pmos W=0.1625U L=0.13U
M196_keeper Vdd GND #501 Vdd pmos W=0.0975U L=0.26U
M197_ Vdd dec_aI_af_56_6 #fb506# Vdd pmos W=0.1625U L=0.13U
M198_keeper Vdd GND #504 Vdd pmos W=0.0975U L=0.26U
M199_ Vdd dec_aI_at_57_6 #fb509# Vdd pmos W=0.1625U L=0.13U
M200_keeper Vdd GND #507 Vdd pmos W=0.0975U L=0.26U
M201_ Vdd dec_aI_af_57_6 #fb512# Vdd pmos W=0.1625U L=0.13U
M202_keeper Vdd GND #510 Vdd pmos W=0.0975U L=0.26U
M203_ Vdd Od_at_50_6 #fb515# Vdd pmos W=0.1625U L=0.13U
M204_keeper Vdd GND #513 Vdd pmos W=0.0975U L=0.26U
M205_ Vdd Od_af_50_6 #fb518# Vdd pmos W=0.1625U L=0.13U
M206_keeper Vdd GND #516 Vdd pmos W=0.0975U L=0.26U
M207_ Vdd Oc_at_50_6 #fb521# Vdd pmos W=0.1625U L=0.13U
M208_keeper Vdd GND #519 Vdd pmos W=0.0975U L=0.26U
M209_ Vdd Oc_af_50_6 #fb524# Vdd pmos W=0.1625U L=0.13U
M210_keeper Vdd GND #522 Vdd pmos W=0.0975U L=0.26U
M211_ Vdd Od_at_51_6 #fb527# Vdd pmos W=0.1625U L=0.13U
M212_keeper Vdd GND #525 Vdd pmos W=0.0975U L=0.26U
M213_ Vdd Od_af_51_6 #fb530# Vdd pmos W=0.1625U L=0.13U
M214_keeper Vdd GND #528 Vdd pmos W=0.0975U L=0.26U
M215_ Vdd Oc_at_51_6 #fb533# Vdd pmos W=0.1625U L=0.13U
M216_keeper Vdd GND #531 Vdd pmos W=0.0975U L=0.26U
M217_ Vdd Oc_af_51_6 #fb536# Vdd pmos W=0.1625U L=0.13U
M218_keeper Vdd GND #534 Vdd pmos W=0.0975U L=0.26U
M219_ Vdd Od_at_52_6 #fb539# Vdd pmos W=0.1625U L=0.13U
M220_keeper Vdd GND #537 Vdd pmos W=0.0975U L=0.26U
M221_ Vdd Od_af_52_6 #fb542# Vdd pmos W=0.1625U L=0.13U
M222_keeper Vdd GND #540 Vdd pmos W=0.0975U L=0.26U
M223_ Vdd Oc_at_52_6 #fb545# Vdd pmos W=0.1625U L=0.13U
M224_keeper Vdd GND #543 Vdd pmos W=0.0975U L=0.26U
M225_ Vdd Oc_af_52_6 #fb548# Vdd pmos W=0.1625U L=0.13U
M226_keeper Vdd GND #546 Vdd pmos W=0.0975U L=0.26U
M227_ Vdd Od_at_53_6 #fb551# Vdd pmos W=0.1625U L=0.13U
M228_keeper Vdd GND #549 Vdd pmos W=0.0975U L=0.26U
M229_ Vdd Od_af_53_6 #fb554# Vdd pmos W=0.1625U L=0.13U
M230_keeper Vdd GND #552 Vdd pmos W=0.0975U L=0.26U
M231_ Vdd Oc_at_53_6 #fb557# Vdd pmos W=0.1625U L=0.13U
M232_keeper Vdd GND #555 Vdd pmos W=0.0975U L=0.26U
M233_ Vdd Oc_af_53_6 #fb560# Vdd pmos W=0.1625U L=0.13U
M234_keeper Vdd GND #558 Vdd pmos W=0.0975U L=0.26U
M235_keeper Vdd GND #561 Vdd pmos W=0.0975U L=0.26U
M236_ GND s R_areq GND nmos W=0.0975U L=0.065U
M237_ GND reset R_areq GND nmos W=0.0975U L=0.065U
M238_ GND p0 #74 GND nmos W=0.0975U L=0.065U
M239_ GND A_aa s GND nmos W=0.0975U L=0.065U
M240_ GND reset s GND nmos W=0.0975U L=0.065U
M241_ GND __s #137 GND nmos W=0.0975U L=0.065U
M242_ GND A_aa j GND nmos W=0.0975U L=0.065U
M243_ GND reset j GND nmos W=0.0975U L=0.065U
M244_ GND j #154 GND nmos W=0.0975U L=0.065U
M245_ GND A_aa p1 GND nmos W=0.0975U L=0.065U
M246_ GND reset p1 GND nmos W=0.0975U L=0.065U
M247_ GND j #174 GND nmos W=0.0975U L=0.065U
M248_ GND __j #178 GND nmos W=0.0975U L=0.065U
M249_ GND __wa #180 GND nmos W=0.0975U L=0.065U
M250_ GND R_af_50_6 q_50_6 GND nmos W=0.0975U L=0.065U
M251_ GND reset q_50_6 GND nmos W=0.0975U L=0.065U
M252_ GND __p0 dec_aI_at_50_6 GND nmos W=0.0975U L=0.065U
M253_ GND __p0 dec_aI_af_50_6 GND nmos W=0.0975U L=0.065U
M254_ GND R_af_51_6 q_51_6 GND nmos W=0.0975U L=0.065U
M255_ GND reset q_51_6 GND nmos W=0.0975U L=0.065U
M256_ GND __p0 dec_aI_at_51_6 GND nmos W=0.0975U L=0.065U
M257_ GND __p0 dec_aI_af_51_6 GND nmos W=0.0975U L=0.065U
M258_ GND R_af_52_6 q_52_6 GND nmos W=0.0975U L=0.065U
M259_ GND reset q_52_6 GND nmos W=0.0975U L=0.065U
M260_ GND __p0 dec_aI_at_52_6 GND nmos W=0.0975U L=0.065U
M261_ GND __p0 dec_aI_af_52_6 GND nmos W=0.0975U L=0.065U
M262_ GND R_af_53_6 q_53_6 GND nmos W=0.0975U L=0.065U
M263_ GND reset q_53_6 GND nmos W=0.0975U L=0.065U
M264_ GND __p0 dec_aI_at_53_6 GND nmos W=0.0975U L=0.065U
M265_ GND __p0 dec_aI_af_53_6 GND nmos W=0.0975U L=0.065U
M266_ GND R_af_54_6 q_54_6 GND nmos W=0.0975U L=0.065U
M267_ GND reset q_54_6 GND nmos W=0.0975U L=0.065U
M268_ GND __p0 dec_aI_at_54_6 GND nmos W=0.0975U L=0.065U
M269_ GND __p0 dec_aI_af_54_6 GND nmos W=0.0975U L=0.065U
M270_ GND R_af_55_6 q_55_6 GND nmos W=0.0975U L=0.065U
M271_ GND reset q_55_6 GND nmos W=0.0975U L=0.065U
M272_ GND __p0 dec_aI_at_55_6 GND nmos W=0.0975U L=0.065U
M273_ GND __p0 dec_aI_af_55_6 GND nmos W=0.0975U L=0.065U
M274_ GND R_af_56_6 q_56_6 GND nmos W=0.0975U L=0.065U
M275_ GND reset q_56_6 GND nmos W=0.0975U L=0.065U
M276_ GND __p0 dec_aI_at_56_6 GND nmos W=0.0975U L=0.065U
M277_ GND __p0 dec_aI_af_56_6 GND nmos W=0.0975U L=0.065U
M278_ GND R_af_57_6 q_57_6 GND nmos W=0.0975U L=0.065U
M279_ GND reset q_57_6 GND nmos W=0.0975U L=0.065U
M280_ GND __p0 dec_aI_at_57_6 GND nmos W=0.0975U L=0.065U
M281_ GND __p0 dec_aI_af_57_6 GND nmos W=0.0975U L=0.065U
M282_ GND p0 #249 GND nmos W=0.0975U L=0.065U
M283_ GND reset b_50_6 GND nmos W=0.0975U L=0.065U
M284_ GND __p0 Od_at_50_6 GND nmos W=0.0975U L=0.065U
M285_ GND __p0 Od_af_50_6 GND nmos W=0.0975U L=0.065U
M286_ GND __p0 Oc_at_50_6 GND nmos W=0.0975U L=0.065U
M287_ GND __p0 Oc_af_50_6 GND nmos W=0.0975U L=0.065U
M288_ GND p0 #269 GND nmos W=0.0975U L=0.065U
M289_ GND reset b_51_6 GND nmos W=0.0975U L=0.065U
M290_ GND __p0 Od_at_51_6 GND nmos W=0.0975U L=0.065U
M291_ GND __p0 Od_af_51_6 GND nmos W=0.0975U L=0.065U
M292_ GND __p0 Oc_at_51_6 GND nmos W=0.0975U L=0.065U
M293_ GND __p0 Oc_af_51_6 GND nmos W=0.0975U L=0.065U
M294_ GND p0 #289 GND nmos W=0.0975U L=0.065U
M295_ GND reset b_52_6 GND nmos W=0.0975U L=0.065U
M296_ GND __p0 Od_at_52_6 GND nmos W=0.0975U L=0.065U
M297_ GND __p0 Od_af_52_6 GND nmos W=0.0975U L=0.065U
M298_ GND __p0 Oc_at_52_6 GND nmos W=0.0975U L=0.065U
M299_ GND __p0 Oc_af_52_6 GND nmos W=0.0975U L=0.065U
M300_ GND p0 #309 GND nmos W=0.0975U L=0.065U
M301_ GND reset b_53_6 GND nmos W=0.0975U L=0.065U
M302_ GND __p0 Od_at_53_6 GND nmos W=0.0975U L=0.065U
M303_ GND __p0 Od_af_53_6 GND nmos W=0.0975U L=0.065U
M304_ GND __p0 Oc_at_53_6 GND nmos W=0.0975U L=0.065U
M305_ GND __p0 Oc_af_53_6 GND nmos W=0.0975U L=0.065U
M306_ GND Cnt_at_50_6 __wt_50_6 GND nmos W=0.0975U L=0.065U
M307_ GND dec_aO_at_50_6 __wt_50_6 GND nmos W=0.0975U L=0.065U
M308_ GND Cnt_af_50_6 __wf_50_6 GND nmos W=0.0975U L=0.065U
M309_ GND dec_aO_af_50_6 __wf_50_6 GND nmos W=0.0975U L=0.065U
M310_ GND __wt_50_6 W_at_50_6 GND nmos W=0.0975U L=0.065U
M311_ GND __wf_50_6 W_af_50_6 GND nmos W=0.0975U L=0.065U
M312_ GND Cnt_at_51_6 __wt_51_6 GND nmos W=0.0975U L=0.065U
M313_ GND dec_aO_at_51_6 __wt_51_6 GND nmos W=0.0975U L=0.065U
M314_ GND Cnt_af_51_6 __wf_51_6 GND nmos W=0.0975U L=0.065U
M315_ GND dec_aO_af_51_6 __wf_51_6 GND nmos W=0.0975U L=0.065U
M316_ GND __wt_51_6 W_at_51_6 GND nmos W=0.0975U L=0.065U
M317_ GND __wf_51_6 W_af_51_6 GND nmos W=0.0975U L=0.065U
M318_ GND Cnt_at_52_6 __wt_52_6 GND nmos W=0.0975U L=0.065U
M319_ GND dec_aO_at_52_6 __wt_52_6 GND nmos W=0.0975U L=0.065U
M320_ GND Cnt_af_52_6 __wf_52_6 GND nmos W=0.0975U L=0.065U
M321_ GND dec_aO_af_52_6 __wf_52_6 GND nmos W=0.0975U L=0.065U
M322_ GND __wt_52_6 W_at_52_6 GND nmos W=0.0975U L=0.065U
M323_ GND __wf_52_6 W_af_52_6 GND nmos W=0.0975U L=0.065U
M324_ GND Cnt_at_53_6 __wt_53_6 GND nmos W=0.0975U L=0.065U
M325_ GND dec_aO_at_53_6 __wt_53_6 GND nmos W=0.0975U L=0.065U
M326_ GND Cnt_af_53_6 __wf_53_6 GND nmos W=0.0975U L=0.065U
M327_ GND dec_aO_af_53_6 __wf_53_6 GND nmos W=0.0975U L=0.065U
M328_ GND __wt_53_6 W_at_53_6 GND nmos W=0.0975U L=0.065U
M329_ GND __wf_53_6 W_af_53_6 GND nmos W=0.0975U L=0.065U
M330_ GND Cnt_at_54_6 __wt_54_6 GND nmos W=0.0975U L=0.065U
M331_ GND dec_aO_at_54_6 __wt_54_6 GND nmos W=0.0975U L=0.065U
M332_ GND Cnt_af_54_6 __wf_54_6 GND nmos W=0.0975U L=0.065U
M333_ GND dec_aO_af_54_6 __wf_54_6 GND nmos W=0.0975U L=0.065U
M334_ GND __wt_54_6 W_at_54_6 GND nmos W=0.0975U L=0.065U
M335_ GND __wf_54_6 W_af_54_6 GND nmos W=0.0975U L=0.065U
M336_ GND Cnt_at_55_6 __wt_55_6 GND nmos W=0.0975U L=0.065U
M337_ GND dec_aO_at_55_6 __wt_55_6 GND nmos W=0.0975U L=0.065U
M338_ GND Cnt_af_55_6 __wf_55_6 GND nmos W=0.0975U L=0.065U
M339_ GND dec_aO_af_55_6 __wf_55_6 GND nmos W=0.0975U L=0.065U
M340_ GND __wt_55_6 W_at_55_6 GND nmos W=0.0975U L=0.065U
M341_ GND __wf_55_6 W_af_55_6 GND nmos W=0.0975U L=0.065U
M342_ GND Cnt_at_56_6 __wt_56_6 GND nmos W=0.0975U L=0.065U
M343_ GND dec_aO_at_56_6 __wt_56_6 GND nmos W=0.0975U L=0.065U
M344_ GND Cnt_af_56_6 __wf_56_6 GND nmos W=0.0975U L=0.065U
M345_ GND dec_aO_af_56_6 __wf_56_6 GND nmos W=0.0975U L=0.065U
M346_ GND __wt_56_6 W_at_56_6 GND nmos W=0.0975U L=0.065U
M347_ GND __wf_56_6 W_af_56_6 GND nmos W=0.0975U L=0.065U
M348_ GND Cnt_at_57_6 __wt_57_6 GND nmos W=0.0975U L=0.065U
M349_ GND dec_aO_at_57_6 __wt_57_6 GND nmos W=0.0975U L=0.065U
M350_ GND Cnt_af_57_6 __wf_57_6 GND nmos W=0.0975U L=0.065U
M351_ GND dec_aO_af_57_6 __wf_57_6 GND nmos W=0.0975U L=0.065U
M352_ GND __wt_57_6 W_at_57_6 GND nmos W=0.0975U L=0.065U
M353_ GND __wf_57_6 W_af_57_6 GND nmos W=0.0975U L=0.065U
M354_ GND A_areq __ar GND nmos W=0.0975U L=0.065U
M355_ GND R_areq __rr GND nmos W=0.0975U L=0.065U
M356_ GND s __s GND nmos W=0.0975U L=0.065U
M357_ GND j __j GND nmos W=0.0975U L=0.065U
M358_ GND p1 __p1 GND nmos W=0.0975U L=0.065U
M359_ GND reset __r GND nmos W=0.0975U L=0.065U
M360_ GND Oc_aa __oca GND nmos W=0.0975U L=0.065U
M361_ GND Od_aa __oda GND nmos W=0.0975U L=0.065U
M362_ GND W_aa __wa GND nmos W=0.0975U L=0.065U
M363_ GND R_at_50_6 __rt_50_6 GND nmos W=0.0975U L=0.065U
M364_ GND R_af_50_6 __rf_50_6 GND nmos W=0.0975U L=0.065U
M365_ GND q_50_6 __q_50_6 GND nmos W=0.0975U L=0.065U
M366_ GND R_at_51_6 __rt_51_6 GND nmos W=0.0975U L=0.065U
M367_ GND R_af_51_6 __rf_51_6 GND nmos W=0.0975U L=0.065U
M368_ GND q_51_6 __q_51_6 GND nmos W=0.0975U L=0.065U
M369_ GND R_at_52_6 __rt_52_6 GND nmos W=0.0975U L=0.065U
M370_ GND R_af_52_6 __rf_52_6 GND nmos W=0.0975U L=0.065U
M371_ GND q_52_6 __q_52_6 GND nmos W=0.0975U L=0.065U
M372_ GND R_at_53_6 __rt_53_6 GND nmos W=0.0975U L=0.065U
M373_ GND R_af_53_6 __rf_53_6 GND nmos W=0.0975U L=0.065U
M374_ GND q_53_6 __q_53_6 GND nmos W=0.0975U L=0.065U
M375_ GND R_at_54_6 __rt_54_6 GND nmos W=0.0975U L=0.065U
M376_ GND R_af_54_6 __rf_54_6 GND nmos W=0.0975U L=0.065U
M377_ GND q_54_6 __q_54_6 GND nmos W=0.0975U L=0.065U
M378_ GND R_at_55_6 __rt_55_6 GND nmos W=0.0975U L=0.065U
M379_ GND R_af_55_6 __rf_55_6 GND nmos W=0.0975U L=0.065U
M380_ GND q_55_6 __q_55_6 GND nmos W=0.0975U L=0.065U
M381_ GND R_at_56_6 __rt_56_6 GND nmos W=0.0975U L=0.065U
M382_ GND R_af_56_6 __rf_56_6 GND nmos W=0.0975U L=0.065U
M383_ GND q_56_6 __q_56_6 GND nmos W=0.0975U L=0.065U
M384_ GND R_at_57_6 __rt_57_6 GND nmos W=0.0975U L=0.065U
M385_ GND R_af_57_6 __rf_57_6 GND nmos W=0.0975U L=0.065U
M386_ GND q_57_6 __q_57_6 GND nmos W=0.0975U L=0.065U
M387_ GND I_at_50_6 __it_50_6 GND nmos W=0.0975U L=0.065U
M388_ GND I_af_50_6 __if_50_6 GND nmos W=0.0975U L=0.065U
M389_ GND b_50_6 __b_50_6 GND nmos W=0.0975U L=0.065U
M390_ GND I_at_51_6 __it_51_6 GND nmos W=0.0975U L=0.065U
M391_ GND I_af_51_6 __if_51_6 GND nmos W=0.0975U L=0.065U
M392_ GND b_51_6 __b_51_6 GND nmos W=0.0975U L=0.065U
M393_ GND I_at_52_6 __it_52_6 GND nmos W=0.0975U L=0.065U
M394_ GND I_af_52_6 __if_52_6 GND nmos W=0.0975U L=0.065U
M395_ GND b_52_6 __b_52_6 GND nmos W=0.0975U L=0.065U
M396_ GND I_at_53_6 __it_53_6 GND nmos W=0.0975U L=0.065U
M397_ GND I_af_53_6 __if_53_6 GND nmos W=0.0975U L=0.065U
M398_ GND b_53_6 __b_53_6 GND nmos W=0.0975U L=0.065U
M399_ GND __p0 p0 GND nmos W=0.0975U L=0.065U
M400_ GND __ia I_aa GND nmos W=0.0975U L=0.065U
M401_ GND R_areq #fb407# GND nmos W=0.0975U L=0.13U
M402_ GND s #fb410# GND nmos W=0.0975U L=0.13U
M403_keeper GND Vdd #409 GND nmos W=0.0975U L=5.395U
M404_ GND A_aa #fb413# GND nmos W=0.0975U L=0.13U
M405_keeper GND Vdd #412 GND nmos W=0.0975U L=13.195U
M406_ GND q_57_6 #fb416# GND nmos W=0.0975U L=0.13U
M407_keeper GND Vdd #415 GND nmos W=0.0975U L=1.495U
M408_ GND q_56_6 #fb419# GND nmos W=0.0975U L=0.13U
M409_keeper GND Vdd #418 GND nmos W=0.0975U L=0.715U
M410_ GND q_55_6 #fb422# GND nmos W=0.0975U L=0.13U
M411_keeper GND Vdd #421 GND nmos W=0.0975U L=0.715U
M412_ GND q_54_6 #fb425# GND nmos W=0.0975U L=0.13U
M413_keeper GND Vdd #424 GND nmos W=0.0975U L=0.715U
M414_ GND q_53_6 #fb428# GND nmos W=0.0975U L=0.13U
M415_keeper GND Vdd #427 GND nmos W=0.0975U L=0.715U
M416_ GND q_52_6 #fb431# GND nmos W=0.0975U L=0.13U
M417_keeper GND Vdd #430 GND nmos W=0.0975U L=0.715U
M418_ GND q_51_6 #fb434# GND nmos W=0.0975U L=0.13U
M419_keeper GND Vdd #433 GND nmos W=0.0975U L=0.715U
M420_ GND q_50_6 #fb437# GND nmos W=0.0975U L=0.13U
M421_keeper GND Vdd #436 GND nmos W=0.0975U L=0.715U
M422_ GND b_53_6 #fb440# GND nmos W=0.0975U L=0.13U
M423_keeper GND Vdd #439 GND nmos W=0.0975U L=0.715U
M424_ GND b_52_6 #fb443# GND nmos W=0.0975U L=0.13U
M425_keeper GND Vdd #442 GND nmos W=0.0975U L=2.275U
M426_ GND b_51_6 #fb446# GND nmos W=0.0975U L=0.13U
M427_keeper GND Vdd #445 GND nmos W=0.0975U L=2.275U
M428_ GND b_50_6 #fb449# GND nmos W=0.0975U L=0.13U
M429_keeper GND Vdd #448 GND nmos W=0.0975U L=2.275U
M430_ GND j #fb452# GND nmos W=0.0975U L=0.13U
M431_keeper GND Vdd #451 GND nmos W=0.0975U L=2.275U
M432_ GND __p0 #fb455# GND nmos W=0.0975U L=0.13U
M433_keeper GND Vdd #454 GND nmos W=0.0975U L=13.975U
M434_ GND p1 #fb458# GND nmos W=0.0975U L=0.13U
M435_keeper GND Vdd #457 GND nmos W=0.0975U L=2.275U
M436_ GND __ia #fb461# GND nmos W=0.0975U L=0.13U
M437_keeper GND Vdd #460 GND nmos W=0.0975U L=7.735U
M438_ GND Cnt_areq #fb464# GND nmos W=0.0975U L=0.13U
M439_keeper GND Vdd #463 GND nmos W=0.0975U L=0.715U
M440_ GND dec_aI_at_50_6 #fb467# GND nmos W=0.0975U L=0.13U
M441_keeper GND Vdd #466 GND nmos W=0.0975U L=0.715U
M442_ GND dec_aI_af_50_6 #fb470# GND nmos W=0.0975U L=0.13U
M443_keeper GND Vdd #469 GND nmos W=0.0975U L=3.055U
M444_ GND dec_aI_at_51_6 #fb473# GND nmos W=0.0975U L=0.13U
M445_keeper GND Vdd #472 GND nmos W=0.0975U L=3.055U
M446_ GND dec_aI_af_51_6 #fb476# GND nmos W=0.0975U L=0.13U
M447_keeper GND Vdd #475 GND nmos W=0.0975U L=3.055U
M448_ GND dec_aI_at_52_6 #fb479# GND nmos W=0.0975U L=0.13U
M449_keeper GND Vdd #478 GND nmos W=0.0975U L=3.055U
M450_ GND dec_aI_af_52_6 #fb482# GND nmos W=0.0975U L=0.13U
M451_keeper GND Vdd #481 GND nmos W=0.0975U L=3.055U
M452_ GND dec_aI_at_53_6 #fb485# GND nmos W=0.0975U L=0.13U
M453_keeper GND Vdd #484 GND nmos W=0.0975U L=3.055U
M454_ GND dec_aI_af_53_6 #fb488# GND nmos W=0.0975U L=0.13U
M455_keeper GND Vdd #487 GND nmos W=0.0975U L=3.055U
M456_ GND dec_aI_at_54_6 #fb491# GND nmos W=0.0975U L=0.13U
M457_keeper GND Vdd #490 GND nmos W=0.0975U L=3.055U
M458_ GND dec_aI_af_54_6 #fb494# GND nmos W=0.0975U L=0.13U
M459_keeper GND Vdd #493 GND nmos W=0.0975U L=3.055U
M460_ GND dec_aI_at_55_6 #fb497# GND nmos W=0.0975U L=0.13U
M461_keeper GND Vdd #496 GND nmos W=0.0975U L=3.055U
M462_ GND dec_aI_af_55_6 #fb500# GND nmos W=0.0975U L=0.13U
M463_keeper GND Vdd #499 GND nmos W=0.0975U L=3.055U
M464_ GND dec_aI_at_56_6 #fb503# GND nmos W=0.0975U L=0.13U
M465_keeper GND Vdd #502 GND nmos W=0.0975U L=3.055U
M466_ GND dec_aI_af_56_6 #fb506# GND nmos W=0.0975U L=0.13U
M467_keeper GND Vdd #505 GND nmos W=0.0975U L=3.055U
M468_ GND dec_aI_at_57_6 #fb509# GND nmos W=0.0975U L=0.13U
M469_keeper GND Vdd #508 GND nmos W=0.0975U L=3.055U
M470_ GND dec_aI_af_57_6 #fb512# GND nmos W=0.0975U L=0.13U
M471_keeper GND Vdd #511 GND nmos W=0.0975U L=3.055U
M472_ GND Od_at_50_6 #fb515# GND nmos W=0.0975U L=0.13U
M473_keeper GND Vdd #514 GND nmos W=0.0975U L=3.055U
M474_ GND Od_af_50_6 #fb518# GND nmos W=0.0975U L=0.13U
M475_keeper GND Vdd #517 GND nmos W=0.0975U L=3.055U
M476_ GND Oc_at_50_6 #fb521# GND nmos W=0.0975U L=0.13U
M477_keeper GND Vdd #520 GND nmos W=0.0975U L=3.055U
M478_ GND Oc_af_50_6 #fb524# GND nmos W=0.0975U L=0.13U
M479_keeper GND Vdd #523 GND nmos W=0.0975U L=3.055U
M480_ GND Od_at_51_6 #fb527# GND nmos W=0.0975U L=0.13U
M481_keeper GND Vdd #526 GND nmos W=0.0975U L=3.055U
M482_ GND Od_af_51_6 #fb530# GND nmos W=0.0975U L=0.13U
M483_keeper GND Vdd #529 GND nmos W=0.0975U L=3.055U
M484_ GND Oc_at_51_6 #fb533# GND nmos W=0.0975U L=0.13U
M485_keeper GND Vdd #532 GND nmos W=0.0975U L=3.055U
M486_ GND Oc_af_51_6 #fb536# GND nmos W=0.0975U L=0.13U
M487_keeper GND Vdd #535 GND nmos W=0.0975U L=3.055U
M488_ GND Od_at_52_6 #fb539# GND nmos W=0.0975U L=0.13U
M489_keeper GND Vdd #538 GND nmos W=0.0975U L=3.055U
M490_ GND Od_af_52_6 #fb542# GND nmos W=0.0975U L=0.13U
M491_keeper GND Vdd #541 GND nmos W=0.0975U L=3.055U
M492_ GND Oc_at_52_6 #fb545# GND nmos W=0.0975U L=0.13U
M493_keeper GND Vdd #544 GND nmos W=0.0975U L=3.055U
M494_ GND Oc_af_52_6 #fb548# GND nmos W=0.0975U L=0.13U
M495_keeper GND Vdd #547 GND nmos W=0.0975U L=3.055U
M496_ GND Od_at_53_6 #fb551# GND nmos W=0.0975U L=0.13U
M497_keeper GND Vdd #550 GND nmos W=0.0975U L=3.055U
M498_ GND Od_af_53_6 #fb554# GND nmos W=0.0975U L=0.13U
M499_keeper GND Vdd #553 GND nmos W=0.0975U L=3.055U
M500_ GND Oc_at_53_6 #fb557# GND nmos W=0.0975U L=0.13U
M501_keeper GND Vdd #556 GND nmos W=0.0975U L=3.055U
M502_ GND Oc_af_53_6 #fb560# GND nmos W=0.0975U L=0.13U
M503_keeper GND Vdd #559 GND nmos W=0.0975U L=3.055U
M504_keeper GND Vdd #562 GND nmos W=0.0975U L=3.055U
M505_ #3 W_aa R_areq Vdd pmos W=0.1625U L=0.065U
M506_keeper #408 #fb407# R_areq Vdd pmos W=0.0975U L=0.065U
M507_keeper #409 #fb407# R_areq GND nmos W=0.0975U L=0.065U
M508_ #4 Od_aa #3 Vdd pmos W=0.1625U L=0.065U
M509_ #5 Oc_aa #4 Vdd pmos W=0.1625U L=0.065U
M510_ #6 p0 #5 Vdd pmos W=0.1625U L=0.065U
M511_ #7 A_aa #6 Vdd pmos W=0.1625U L=0.065U
M512_ #8 s #7 Vdd pmos W=0.1625U L=0.065U
M513_ #68 __q_50_6 s Vdd pmos W=0.1625U L=0.065U
M514_ #71 q_50_6 s Vdd pmos W=0.1625U L=0.065U
M515_ #96 b_50_6 s GND nmos W=0.0975U L=0.065U
M516_ #99 __b_50_6 s GND nmos W=0.0975U L=0.065U
M517_keeper #411 #fb410# s Vdd pmos W=0.0975U L=0.065U
M518_keeper #412 #fb410# s GND nmos W=0.0975U L=0.065U
M519_ #179 __p1 A_aa Vdd pmos W=0.1625U L=0.065U
M520_ #180 __ar A_aa GND nmos W=0.0975U L=0.065U
M521_keeper #414 #fb413# A_aa Vdd pmos W=0.0975U L=0.065U
M522_keeper #415 #fb413# A_aa GND nmos W=0.0975U L=0.065U
M523_ #17 __rt_57_6 #26 Vdd pmos W=0.1625U L=0.065U
M524_ #17 __rf_57_6 #29 Vdd pmos W=0.1625U L=0.065U
M525_ #62 __q_51_6 #19 Vdd pmos W=0.1625U L=0.065U
M526_ #65 q_51_6 #19 Vdd pmos W=0.1625U L=0.065U
M527_ #19 __rt_50_6 #68 Vdd pmos W=0.1625U L=0.065U
M528_ #19 __rf_50_6 #71 Vdd pmos W=0.1625U L=0.065U
M529_ #56 __q_52_6 #20 Vdd pmos W=0.1625U L=0.065U
M530_ #59 q_52_6 #20 Vdd pmos W=0.1625U L=0.065U
M531_ #20 __rt_51_6 #62 Vdd pmos W=0.1625U L=0.065U
M532_ #20 __rf_51_6 #65 Vdd pmos W=0.1625U L=0.065U
M533_ #50 __q_53_6 #21 Vdd pmos W=0.1625U L=0.065U
M534_ #53 q_53_6 #21 Vdd pmos W=0.1625U L=0.065U
M535_ #21 __rt_52_6 #56 Vdd pmos W=0.1625U L=0.065U
M536_ #21 __rf_52_6 #59 Vdd pmos W=0.1625U L=0.065U
M537_ #44 __q_54_6 #22 Vdd pmos W=0.1625U L=0.065U
M538_ #47 q_54_6 #22 Vdd pmos W=0.1625U L=0.065U
M539_ #22 __rt_53_6 #50 Vdd pmos W=0.1625U L=0.065U
M540_ #22 __rf_53_6 #53 Vdd pmos W=0.1625U L=0.065U
M541_ #38 __q_55_6 #23 Vdd pmos W=0.1625U L=0.065U
M542_ #41 q_55_6 #23 Vdd pmos W=0.1625U L=0.065U
M543_ #23 __rt_54_6 #44 Vdd pmos W=0.1625U L=0.065U
M544_ #23 __rf_54_6 #47 Vdd pmos W=0.1625U L=0.065U
M545_ #32 __q_56_6 #24 Vdd pmos W=0.1625U L=0.065U
M546_ #35 q_56_6 #24 Vdd pmos W=0.1625U L=0.065U
M547_ #24 __rt_55_6 #38 Vdd pmos W=0.1625U L=0.065U
M548_ #24 __rf_55_6 #41 Vdd pmos W=0.1625U L=0.065U
M549_ #26 __q_57_6 #25 Vdd pmos W=0.1625U L=0.065U
M550_ #29 q_57_6 #25 Vdd pmos W=0.1625U L=0.065U
M551_ #25 __rt_56_6 #32 Vdd pmos W=0.1625U L=0.065U
M552_ #25 __rf_56_6 #35 Vdd pmos W=0.1625U L=0.065U
M553_keeper #417 #fb416# q_57_6 Vdd pmos W=0.0975U L=0.065U
M554_keeper #418 #fb416# q_57_6 GND nmos W=0.0975U L=0.065U
M555_keeper #420 #fb419# q_56_6 Vdd pmos W=0.0975U L=0.065U
M556_keeper #421 #fb419# q_56_6 GND nmos W=0.0975U L=0.065U
M557_keeper #423 #fb422# q_55_6 Vdd pmos W=0.0975U L=0.065U
M558_keeper #424 #fb422# q_55_6 GND nmos W=0.0975U L=0.065U
M559_keeper #426 #fb425# q_54_6 Vdd pmos W=0.0975U L=0.065U
M560_keeper #427 #fb425# q_54_6 GND nmos W=0.0975U L=0.065U
M561_keeper #429 #fb428# q_53_6 Vdd pmos W=0.0975U L=0.065U
M562_keeper #430 #fb428# q_53_6 GND nmos W=0.0975U L=0.065U
M563_keeper #432 #fb431# q_52_6 Vdd pmos W=0.0975U L=0.065U
M564_keeper #433 #fb431# q_52_6 GND nmos W=0.0975U L=0.065U
M565_keeper #435 #fb434# q_51_6 Vdd pmos W=0.0975U L=0.065U
M566_keeper #436 #fb434# q_51_6 GND nmos W=0.0975U L=0.065U
M567_keeper #438 #fb437# q_50_6 Vdd pmos W=0.0975U L=0.065U
M568_keeper #439 #fb437# q_50_6 GND nmos W=0.0975U L=0.065U
M569_ #74 I_at_53_6 #78 GND nmos W=0.0975U L=0.065U
M570_ #74 I_af_53_6 #81 GND nmos W=0.0975U L=0.065U
M571_ #90 b_51_6 #75 GND nmos W=0.0975U L=0.065U
M572_ #93 __b_51_6 #75 GND nmos W=0.0975U L=0.065U
M573_ #75 I_at_50_6 #96 GND nmos W=0.0975U L=0.065U
M574_ #75 I_af_50_6 #99 GND nmos W=0.0975U L=0.065U
M575_ #84 b_52_6 #76 GND nmos W=0.0975U L=0.065U
M576_ #87 __b_52_6 #76 GND nmos W=0.0975U L=0.065U
M577_ #76 I_at_51_6 #90 GND nmos W=0.0975U L=0.065U
M578_ #76 I_af_51_6 #93 GND nmos W=0.0975U L=0.065U
M579_ #78 b_53_6 #77 GND nmos W=0.0975U L=0.065U
M580_ #81 __b_53_6 #77 GND nmos W=0.0975U L=0.065U
M581_ #77 I_at_52_6 #84 GND nmos W=0.0975U L=0.065U
M582_ #77 I_af_52_6 #87 GND nmos W=0.0975U L=0.065U
M583_ #306 __it_53_6 b_53_6 Vdd pmos W=0.1625U L=0.065U
M584_ #308 I_af_53_6 b_53_6 GND nmos W=0.0975U L=0.065U
M585_keeper #441 #fb440# b_53_6 Vdd pmos W=0.0975U L=0.065U
M586_keeper #442 #fb440# b_53_6 GND nmos W=0.0975U L=0.065U
M587_ #286 __it_52_6 b_52_6 Vdd pmos W=0.1625U L=0.065U
M588_ #288 I_af_52_6 b_52_6 GND nmos W=0.0975U L=0.065U
M589_keeper #444 #fb443# b_52_6 Vdd pmos W=0.0975U L=0.065U
M590_keeper #445 #fb443# b_52_6 GND nmos W=0.0975U L=0.065U
M591_ #266 __it_51_6 b_51_6 Vdd pmos W=0.1625U L=0.065U
M592_ #268 I_af_51_6 b_51_6 GND nmos W=0.0975U L=0.065U
M593_keeper #447 #fb446# b_51_6 Vdd pmos W=0.0975U L=0.065U
M594_keeper #448 #fb446# b_51_6 GND nmos W=0.0975U L=0.065U
M595_ #246 __it_50_6 b_50_6 Vdd pmos W=0.1625U L=0.065U
M596_ #248 I_af_50_6 b_50_6 GND nmos W=0.0975U L=0.065U
M597_keeper #450 #fb449# b_50_6 Vdd pmos W=0.0975U L=0.065U
M598_keeper #451 #fb449# b_50_6 GND nmos W=0.0975U L=0.065U
M599_ #134 R_af_50_6 j Vdd pmos W=0.1625U L=0.065U
M600_ #150 __if_50_6 j GND nmos W=0.0975U L=0.065U
M601_keeper #453 #fb452# j Vdd pmos W=0.0975U L=0.065U
M602_keeper #454 #fb452# j GND nmos W=0.0975U L=0.065U
M603_ #104 A_aa #103 Vdd pmos W=0.1625U L=0.065U
M604_ #103 R_at_57_6 #113 Vdd pmos W=0.1625U L=0.065U
M605_ #131 R_af_51_6 #106 Vdd pmos W=0.1625U L=0.065U
M606_ #106 R_at_50_6 #134 Vdd pmos W=0.1625U L=0.065U
M607_ #128 R_af_52_6 #107 Vdd pmos W=0.1625U L=0.065U
M608_ #107 R_at_51_6 #131 Vdd pmos W=0.1625U L=0.065U
M609_ #125 R_af_53_6 #108 Vdd pmos W=0.1625U L=0.065U
M610_ #108 R_at_52_6 #128 Vdd pmos W=0.1625U L=0.065U
M611_ #122 R_af_54_6 #109 Vdd pmos W=0.1625U L=0.065U
M612_ #109 R_at_53_6 #125 Vdd pmos W=0.1625U L=0.065U
M613_ #119 R_af_55_6 #110 Vdd pmos W=0.1625U L=0.065U
M614_ #110 R_at_54_6 #122 Vdd pmos W=0.1625U L=0.065U
M615_ #116 R_af_56_6 #111 Vdd pmos W=0.1625U L=0.065U
M616_ #111 R_at_55_6 #119 Vdd pmos W=0.1625U L=0.065U
M617_ #113 R_af_57_6 #112 Vdd pmos W=0.1625U L=0.065U
M618_ #112 R_at_56_6 #116 Vdd pmos W=0.1625U L=0.065U
M619_ #137 __it_53_6 #141 GND nmos W=0.0975U L=0.065U
M620_ #147 __if_51_6 #138 GND nmos W=0.0975U L=0.065U
M621_ #138 __it_50_6 #150 GND nmos W=0.0975U L=0.065U
M622_ #144 __if_52_6 #139 GND nmos W=0.0975U L=0.065U
M623_ #139 __it_51_6 #147 GND nmos W=0.0975U L=0.065U
M624_ #141 __if_53_6 #140 GND nmos W=0.0975U L=0.065U
M625_ #140 __it_52_6 #144 GND nmos W=0.0975U L=0.065U
M626_ #154 q_57_6 __p0 GND nmos W=0.0975U L=0.065U
M627_ #154 q_56_6 __p0 GND nmos W=0.0975U L=0.065U
M628_ #154 q_55_6 __p0 GND nmos W=0.0975U L=0.065U
M629_ #154 q_54_6 __p0 GND nmos W=0.0975U L=0.065U
M630_ #154 q_53_6 __p0 GND nmos W=0.0975U L=0.065U
M631_ #154 q_52_6 __p0 GND nmos W=0.0975U L=0.065U
M632_ #154 q_51_6 __p0 GND nmos W=0.0975U L=0.065U
M633_ #154 q_50_6 __p0 GND nmos W=0.0975U L=0.065U
M634_ #155 __wa __p0 Vdd pmos W=0.1625U L=0.065U
M635_keeper #456 #fb455# __p0 Vdd pmos W=0.0975U L=0.065U
M636_keeper #457 #fb455# __p0 GND nmos W=0.0975U L=0.065U
M637_ #156 __oda #155 Vdd pmos W=0.1625U L=0.065U
M638_ #165 q_50_6 p1 Vdd pmos W=0.1625U L=0.065U
M639_keeper #459 #fb458# p1 Vdd pmos W=0.0975U L=0.065U
M640_keeper #460 #fb458# p1 GND nmos W=0.0975U L=0.065U
M641_ #163 __j #162 Vdd pmos W=0.1625U L=0.065U
M642_ #162 q_57_6 #171 Vdd pmos W=0.1625U L=0.065U
M643_ #166 q_51_6 #165 Vdd pmos W=0.1625U L=0.065U
M644_ #167 q_52_6 #166 Vdd pmos W=0.1625U L=0.065U
M645_ #168 q_53_6 #167 Vdd pmos W=0.1625U L=0.065U
M646_ #169 q_54_6 #168 Vdd pmos W=0.1625U L=0.065U
M647_ #170 q_55_6 #169 Vdd pmos W=0.1625U L=0.065U
M648_ #171 q_56_6 #170 Vdd pmos W=0.1625U L=0.065U
M649_ #173 __s __ia GND nmos W=0.0975U L=0.065U
M650_keeper #462 #fb461# __ia Vdd pmos W=0.0975U L=0.065U
M651_keeper #463 #fb461# __ia GND nmos W=0.0975U L=0.065U
M652_ #174 p0 #173 GND nmos W=0.0975U L=0.065U
M653_ #177 __p1 Cnt_areq GND nmos W=0.0975U L=0.065U
M654_keeper #465 #fb464# Cnt_areq Vdd pmos W=0.0975U L=0.065U
M655_keeper #466 #fb464# Cnt_areq GND nmos W=0.0975U L=0.065U
M656_ #178 __s #177 GND nmos W=0.0975U L=0.065U
M657_ #182 __q_50_6 dec_aI_at_50_6 Vdd pmos W=0.1625U L=0.065U
M658_keeper #468 #fb467# dec_aI_at_50_6 Vdd pmos W=0.0975U L=0.065U
M659_keeper #469 #fb467# dec_aI_at_50_6 GND nmos W=0.0975U L=0.065U
M660_ #183 I_aa #182 Vdd pmos W=0.1625U L=0.065U
M661_ #184 j #183 Vdd pmos W=0.1625U L=0.065U
M662_ #187 q_50_6 dec_aI_af_50_6 Vdd pmos W=0.1625U L=0.065U
M663_keeper #471 #fb470# dec_aI_af_50_6 Vdd pmos W=0.0975U L=0.065U
M664_keeper #472 #fb470# dec_aI_af_50_6 GND nmos W=0.0975U L=0.065U
M665_ #188 I_aa #187 Vdd pmos W=0.1625U L=0.065U
M666_ #189 j #188 Vdd pmos W=0.1625U L=0.065U
M667_ #191 __q_51_6 dec_aI_at_51_6 Vdd pmos W=0.1625U L=0.065U
M668_keeper #474 #fb473# dec_aI_at_51_6 Vdd pmos W=0.0975U L=0.065U
M669_keeper #475 #fb473# dec_aI_at_51_6 GND nmos W=0.0975U L=0.065U
M670_ #192 I_aa #191 Vdd pmos W=0.1625U L=0.065U
M671_ #193 j #192 Vdd pmos W=0.1625U L=0.065U
M672_ #195 q_51_6 dec_aI_af_51_6 Vdd pmos W=0.1625U L=0.065U
M673_keeper #477 #fb476# dec_aI_af_51_6 Vdd pmos W=0.0975U L=0.065U
M674_keeper #478 #fb476# dec_aI_af_51_6 GND nmos W=0.0975U L=0.065U
M675_ #196 I_aa #195 Vdd pmos W=0.1625U L=0.065U
M676_ #197 j #196 Vdd pmos W=0.1625U L=0.065U
M677_ #199 __q_52_6 dec_aI_at_52_6 Vdd pmos W=0.1625U L=0.065U
M678_keeper #480 #fb479# dec_aI_at_52_6 Vdd pmos W=0.0975U L=0.065U
M679_keeper #481 #fb479# dec_aI_at_52_6 GND nmos W=0.0975U L=0.065U
M680_ #200 I_aa #199 Vdd pmos W=0.1625U L=0.065U
M681_ #201 j #200 Vdd pmos W=0.1625U L=0.065U
M682_ #203 q_52_6 dec_aI_af_52_6 Vdd pmos W=0.1625U L=0.065U
M683_keeper #483 #fb482# dec_aI_af_52_6 Vdd pmos W=0.0975U L=0.065U
M684_keeper #484 #fb482# dec_aI_af_52_6 GND nmos W=0.0975U L=0.065U
M685_ #204 I_aa #203 Vdd pmos W=0.1625U L=0.065U
M686_ #205 j #204 Vdd pmos W=0.1625U L=0.065U
M687_ #207 __q_53_6 dec_aI_at_53_6 Vdd pmos W=0.1625U L=0.065U
M688_keeper #486 #fb485# dec_aI_at_53_6 Vdd pmos W=0.0975U L=0.065U
M689_keeper #487 #fb485# dec_aI_at_53_6 GND nmos W=0.0975U L=0.065U
M690_ #208 I_aa #207 Vdd pmos W=0.1625U L=0.065U
M691_ #209 j #208 Vdd pmos W=0.1625U L=0.065U
M692_ #211 q_53_6 dec_aI_af_53_6 Vdd pmos W=0.1625U L=0.065U
M693_keeper #489 #fb488# dec_aI_af_53_6 Vdd pmos W=0.0975U L=0.065U
M694_keeper #490 #fb488# dec_aI_af_53_6 GND nmos W=0.0975U L=0.065U
M695_ #212 I_aa #211 Vdd pmos W=0.1625U L=0.065U
M696_ #213 j #212 Vdd pmos W=0.1625U L=0.065U
M697_ #215 __q_54_6 dec_aI_at_54_6 Vdd pmos W=0.1625U L=0.065U
M698_keeper #492 #fb491# dec_aI_at_54_6 Vdd pmos W=0.0975U L=0.065U
M699_keeper #493 #fb491# dec_aI_at_54_6 GND nmos W=0.0975U L=0.065U
M700_ #216 I_aa #215 Vdd pmos W=0.1625U L=0.065U
M701_ #217 j #216 Vdd pmos W=0.1625U L=0.065U
M702_ #219 q_54_6 dec_aI_af_54_6 Vdd pmos W=0.1625U L=0.065U
M703_keeper #495 #fb494# dec_aI_af_54_6 Vdd pmos W=0.0975U L=0.065U
M704_keeper #496 #fb494# dec_aI_af_54_6 GND nmos W=0.0975U L=0.065U
M705_ #220 I_aa #219 Vdd pmos W=0.1625U L=0.065U
M706_ #221 j #220 Vdd pmos W=0.1625U L=0.065U
M707_ #223 __q_55_6 dec_aI_at_55_6 Vdd pmos W=0.1625U L=0.065U
M708_keeper #498 #fb497# dec_aI_at_55_6 Vdd pmos W=0.0975U L=0.065U
M709_keeper #499 #fb497# dec_aI_at_55_6 GND nmos W=0.0975U L=0.065U
M710_ #224 I_aa #223 Vdd pmos W=0.1625U L=0.065U
M711_ #225 j #224 Vdd pmos W=0.1625U L=0.065U
M712_ #227 q_55_6 dec_aI_af_55_6 Vdd pmos W=0.1625U L=0.065U
M713_keeper #501 #fb500# dec_aI_af_55_6 Vdd pmos W=0.0975U L=0.065U
M714_keeper #502 #fb500# dec_aI_af_55_6 GND nmos W=0.0975U L=0.065U
M715_ #228 I_aa #227 Vdd pmos W=0.1625U L=0.065U
M716_ #229 j #228 Vdd pmos W=0.1625U L=0.065U
M717_ #231 __q_56_6 dec_aI_at_56_6 Vdd pmos W=0.1625U L=0.065U
M718_keeper #504 #fb503# dec_aI_at_56_6 Vdd pmos W=0.0975U L=0.065U
M719_keeper #505 #fb503# dec_aI_at_56_6 GND nmos W=0.0975U L=0.065U
M720_ #232 I_aa #231 Vdd pmos W=0.1625U L=0.065U
M721_ #233 j #232 Vdd pmos W=0.1625U L=0.065U
M722_ #235 q_56_6 dec_aI_af_56_6 Vdd pmos W=0.1625U L=0.065U
M723_keeper #507 #fb506# dec_aI_af_56_6 Vdd pmos W=0.0975U L=0.065U
M724_keeper #508 #fb506# dec_aI_af_56_6 GND nmos W=0.0975U L=0.065U
M725_ #236 I_aa #235 Vdd pmos W=0.1625U L=0.065U
M726_ #237 j #236 Vdd pmos W=0.1625U L=0.065U
M727_ #239 __q_57_6 dec_aI_at_57_6 Vdd pmos W=0.1625U L=0.065U
M728_keeper #510 #fb509# dec_aI_at_57_6 Vdd pmos W=0.0975U L=0.065U
M729_keeper #511 #fb509# dec_aI_at_57_6 GND nmos W=0.0975U L=0.065U
M730_ #240 I_aa #239 Vdd pmos W=0.1625U L=0.065U
M731_ #241 j #240 Vdd pmos W=0.1625U L=0.065U
M732_ #243 q_57_6 dec_aI_af_57_6 Vdd pmos W=0.1625U L=0.065U
M733_keeper #513 #fb512# dec_aI_af_57_6 Vdd pmos W=0.0975U L=0.065U
M734_keeper #514 #fb512# dec_aI_af_57_6 GND nmos W=0.0975U L=0.065U
M735_ #244 I_aa #243 Vdd pmos W=0.1625U L=0.065U
M736_ #245 j #244 Vdd pmos W=0.1625U L=0.065U
M737_ #247 __s #246 Vdd pmos W=0.1625U L=0.065U
M738_ #249 s #248 GND nmos W=0.0975U L=0.065U
M739_ #251 __b_50_6 Od_at_50_6 Vdd pmos W=0.1625U L=0.065U
M740_keeper #516 #fb515# Od_at_50_6 Vdd pmos W=0.0975U L=0.065U
M741_keeper #517 #fb515# Od_at_50_6 GND nmos W=0.0975U L=0.065U
M742_ #252 I_aa #251 Vdd pmos W=0.1625U L=0.065U
M743_ #253 j #252 Vdd pmos W=0.1625U L=0.065U
M744_ #255 b_50_6 Od_af_50_6 Vdd pmos W=0.1625U L=0.065U
M745_keeper #519 #fb518# Od_af_50_6 Vdd pmos W=0.0975U L=0.065U
M746_keeper #520 #fb518# Od_af_50_6 GND nmos W=0.0975U L=0.065U
M747_ #256 I_aa #255 Vdd pmos W=0.1625U L=0.065U
M748_ #257 j #256 Vdd pmos W=0.1625U L=0.065U
M749_ #259 __b_50_6 Oc_at_50_6 Vdd pmos W=0.1625U L=0.065U
M750_keeper #522 #fb521# Oc_at_50_6 Vdd pmos W=0.0975U L=0.065U
M751_keeper #523 #fb521# Oc_at_50_6 GND nmos W=0.0975U L=0.065U
M752_ #260 I_aa #259 Vdd pmos W=0.1625U L=0.065U
M753_ #261 j #260 Vdd pmos W=0.1625U L=0.065U
M754_ #263 b_50_6 Oc_af_50_6 Vdd pmos W=0.1625U L=0.065U
M755_keeper #525 #fb524# Oc_af_50_6 Vdd pmos W=0.0975U L=0.065U
M756_keeper #526 #fb524# Oc_af_50_6 GND nmos W=0.0975U L=0.065U
M757_ #264 I_aa #263 Vdd pmos W=0.1625U L=0.065U
M758_ #265 j #264 Vdd pmos W=0.1625U L=0.065U
M759_ #267 __s #266 Vdd pmos W=0.1625U L=0.065U
M760_ #269 s #268 GND nmos W=0.0975U L=0.065U
M761_ #271 __b_51_6 Od_at_51_6 Vdd pmos W=0.1625U L=0.065U
M762_keeper #528 #fb527# Od_at_51_6 Vdd pmos W=0.0975U L=0.065U
M763_keeper #529 #fb527# Od_at_51_6 GND nmos W=0.0975U L=0.065U
M764_ #272 I_aa #271 Vdd pmos W=0.1625U L=0.065U
M765_ #273 j #272 Vdd pmos W=0.1625U L=0.065U
M766_ #275 b_51_6 Od_af_51_6 Vdd pmos W=0.1625U L=0.065U
M767_keeper #531 #fb530# Od_af_51_6 Vdd pmos W=0.0975U L=0.065U
M768_keeper #532 #fb530# Od_af_51_6 GND nmos W=0.0975U L=0.065U
M769_ #276 I_aa #275 Vdd pmos W=0.1625U L=0.065U
M770_ #277 j #276 Vdd pmos W=0.1625U L=0.065U
M771_ #279 __b_51_6 Oc_at_51_6 Vdd pmos W=0.1625U L=0.065U
M772_keeper #534 #fb533# Oc_at_51_6 Vdd pmos W=0.0975U L=0.065U
M773_keeper #535 #fb533# Oc_at_51_6 GND nmos W=0.0975U L=0.065U
M774_ #280 I_aa #279 Vdd pmos W=0.1625U L=0.065U
M775_ #281 j #280 Vdd pmos W=0.1625U L=0.065U
M776_ #283 b_51_6 Oc_af_51_6 Vdd pmos W=0.1625U L=0.065U
M777_keeper #537 #fb536# Oc_af_51_6 Vdd pmos W=0.0975U L=0.065U
M778_keeper #538 #fb536# Oc_af_51_6 GND nmos W=0.0975U L=0.065U
M779_ #284 I_aa #283 Vdd pmos W=0.1625U L=0.065U
M780_ #285 j #284 Vdd pmos W=0.1625U L=0.065U
M781_ #287 __s #286 Vdd pmos W=0.1625U L=0.065U
M782_ #289 s #288 GND nmos W=0.0975U L=0.065U
M783_ #291 __b_52_6 Od_at_52_6 Vdd pmos W=0.1625U L=0.065U
M784_keeper #540 #fb539# Od_at_52_6 Vdd pmos W=0.0975U L=0.065U
M785_keeper #541 #fb539# Od_at_52_6 GND nmos W=0.0975U L=0.065U
M786_ #292 I_aa #291 Vdd pmos W=0.1625U L=0.065U
M787_ #293 j #292 Vdd pmos W=0.1625U L=0.065U
M788_ #295 b_52_6 Od_af_52_6 Vdd pmos W=0.1625U L=0.065U
M789_keeper #543 #fb542# Od_af_52_6 Vdd pmos W=0.0975U L=0.065U
M790_keeper #544 #fb542# Od_af_52_6 GND nmos W=0.0975U L=0.065U
M791_ #296 I_aa #295 Vdd pmos W=0.1625U L=0.065U
M792_ #297 j #296 Vdd pmos W=0.1625U L=0.065U
M793_ #299 __b_52_6 Oc_at_52_6 Vdd pmos W=0.1625U L=0.065U
M794_keeper #546 #fb545# Oc_at_52_6 Vdd pmos W=0.0975U L=0.065U
M795_keeper #547 #fb545# Oc_at_52_6 GND nmos W=0.0975U L=0.065U
M796_ #300 I_aa #299 Vdd pmos W=0.1625U L=0.065U
M797_ #301 j #300 Vdd pmos W=0.1625U L=0.065U
M798_ #303 b_52_6 Oc_af_52_6 Vdd pmos W=0.1625U L=0.065U
M799_keeper #549 #fb548# Oc_af_52_6 Vdd pmos W=0.0975U L=0.065U
M800_keeper #550 #fb548# Oc_af_52_6 GND nmos W=0.0975U L=0.065U
M801_ #304 I_aa #303 Vdd pmos W=0.1625U L=0.065U
M802_ #305 j #304 Vdd pmos W=0.1625U L=0.065U
M803_ #307 __s #306 Vdd pmos W=0.1625U L=0.065U
M804_ #309 s #308 GND nmos W=0.0975U L=0.065U
M805_ #311 __b_53_6 Od_at_53_6 Vdd pmos W=0.1625U L=0.065U
M806_keeper #552 #fb551# Od_at_53_6 Vdd pmos W=0.0975U L=0.065U
M807_keeper #553 #fb551# Od_at_53_6 GND nmos W=0.0975U L=0.065U
M808_ #312 I_aa #311 Vdd pmos W=0.1625U L=0.065U
M809_ #313 j #312 Vdd pmos W=0.1625U L=0.065U
M810_ #315 b_53_6 Od_af_53_6 Vdd pmos W=0.1625U L=0.065U
M811_keeper #555 #fb554# Od_af_53_6 Vdd pmos W=0.0975U L=0.065U
M812_keeper #556 #fb554# Od_af_53_6 GND nmos W=0.0975U L=0.065U
M813_ #316 I_aa #315 Vdd pmos W=0.1625U L=0.065U
M814_ #317 j #316 Vdd pmos W=0.1625U L=0.065U
M815_ #319 __b_53_6 Oc_at_53_6 Vdd pmos W=0.1625U L=0.065U
M816_keeper #558 #fb557# Oc_at_53_6 Vdd pmos W=0.0975U L=0.065U
M817_keeper #559 #fb557# Oc_at_53_6 GND nmos W=0.0975U L=0.065U
M818_ #320 I_aa #319 Vdd pmos W=0.1625U L=0.065U
M819_ #321 j #320 Vdd pmos W=0.1625U L=0.065U
M820_ #323 b_53_6 Oc_af_53_6 Vdd pmos W=0.1625U L=0.065U
M821_keeper #561 #fb560# Oc_af_53_6 Vdd pmos W=0.0975U L=0.065U
M822_keeper #562 #fb560# Oc_af_53_6 GND nmos W=0.0975U L=0.065U
M823_ #324 I_aa #323 Vdd pmos W=0.1625U L=0.065U
M824_ #325 j #324 Vdd pmos W=0.1625U L=0.065U
M825_ #327 dec_aO_at_50_6 __wt_50_6 Vdd pmos W=0.1625U L=0.065U
M826_ #331 dec_aO_af_50_6 __wf_50_6 Vdd pmos W=0.1625U L=0.065U
M827_ #337 dec_aO_at_51_6 __wt_51_6 Vdd pmos W=0.1625U L=0.065U
M828_ #341 dec_aO_af_51_6 __wf_51_6 Vdd pmos W=0.1625U L=0.065U
M829_ #347 dec_aO_at_52_6 __wt_52_6 Vdd pmos W=0.1625U L=0.065U
M830_ #351 dec_aO_af_52_6 __wf_52_6 Vdd pmos W=0.1625U L=0.065U
M831_ #357 dec_aO_at_53_6 __wt_53_6 Vdd pmos W=0.1625U L=0.065U
M832_ #361 dec_aO_af_53_6 __wf_53_6 Vdd pmos W=0.1625U L=0.065U
M833_ #367 dec_aO_at_54_6 __wt_54_6 Vdd pmos W=0.1625U L=0.065U
M834_ #371 dec_aO_af_54_6 __wf_54_6 Vdd pmos W=0.1625U L=0.065U
M835_ #377 dec_aO_at_55_6 __wt_55_6 Vdd pmos W=0.1625U L=0.065U
M836_ #381 dec_aO_af_55_6 __wf_55_6 Vdd pmos W=0.1625U L=0.065U
M837_ #387 dec_aO_at_56_6 __wt_56_6 Vdd pmos W=0.1625U L=0.065U
M838_ #391 dec_aO_af_56_6 __wf_56_6 Vdd pmos W=0.1625U L=0.065U
M839_ #397 dec_aO_at_57_6 __wt_57_6 Vdd pmos W=0.1625U L=0.065U
M840_ #401 dec_aO_af_57_6 __wf_57_6 Vdd pmos W=0.1625U L=0.065U
xdec dec_aI_at_50_6 dec_aI_at_51_6 dec_aI_at_52_6 dec_aI_at_53_6 dec_aI_at_54_6 dec_aI_at_55_6 dec_aI_at_56_6 dec_aI_at_57_6 dec_aI_af_50_6 dec_aI_af_51_6 dec_aI_af_52_6 dec_aI_af_53_6 dec_aI_af_54_6 dec_aI_af_55_6 dec_aI_af_56_6 dec_aI_af_57_6 dec_aO_at_50_6 dec_aO_at_51_6 dec_aO_at_52_6 dec_aO_at_53_6 dec_aO_at_54_6 dec_aO_at_55_6 dec_aO_at_56_6 dec_aO_at_57_6 dec_aO_af_50_6 dec_aO_af_51_6 dec_aO_af_52_6 dec_aO_af_53_6 dec_aO_af_54_6 dec_aO_af_55_6 dec_aO_af_56_6 dec_aO_af_57_6 CounterDec
.ends
*---- end of process: ChildServer<> -----
*
*---- act defproc: Merge<8,f> -----
* raw ports:  I0.t[0] I0.t[1] I0.t[2] I0.t[3] I0.t[4] I0.t[5] I0.t[6] I0.t[7] I0.f[0] I0.f[1] I0.f[2] I0.f[3] I0.f[4] I0.f[5] I0.f[6] I0.f[7] I0.a I1.t[0] I1.t[1] I1.t[2] I1.t[3] I1.t[4] I1.t[5] I1.t[6] I1.t[7] I1.f[0] I1.f[1] I1.f[2] I1.f[3] I1.f[4] I1.f[5] I1.f[6] I1.f[7] I1.a O.t[0] O.t[1] O.t[2] O.t[3] O.t[4] O.t[5] O.t[6] O.t[7] O.f[0] O.f[1] O.f[2] O.f[3] O.f[4] O.f[5] O.f[6] O.f[7] O.a
*
.subckt Merge_38_7f_4 I0_at_50_6 I0_at_51_6 I0_at_52_6 I0_at_53_6 I0_at_54_6 I0_at_55_6 I0_at_56_6 I0_at_57_6 I0_af_50_6 I0_af_51_6 I0_af_52_6 I0_af_53_6 I0_af_54_6 I0_af_55_6 I0_af_56_6 I0_af_57_6 I0_aa I1_at_50_6 I1_at_51_6 I1_at_52_6 I1_at_53_6 I1_at_54_6 I1_at_55_6 I1_at_56_6 I1_at_57_6 I1_af_50_6 I1_af_51_6 I1_af_52_6 I1_af_53_6 I1_af_54_6 I1_af_55_6 I1_af_56_6 I1_af_57_6 I1_aa O_at_50_6 O_at_51_6 O_at_52_6 O_at_53_6 O_at_54_6 O_at_55_6 O_at_56_6 O_at_57_6 O_af_50_6 O_af_51_6 O_af_52_6 O_af_53_6 O_af_54_6 O_af_55_6 O_af_56_6 O_af_57_6 O_aa
*.PININFO I0_at_50_6:I I0_at_51_6:I I0_at_52_6:I I0_at_53_6:I I0_at_54_6:I I0_at_55_6:I I0_at_56_6:I I0_at_57_6:I I0_af_50_6:I I0_af_51_6:I I0_af_52_6:I I0_af_53_6:I I0_af_54_6:I I0_af_55_6:I I0_af_56_6:I I0_af_57_6:I I0_aa:O I1_at_50_6:I I1_at_51_6:I I1_at_52_6:I I1_at_53_6:I I1_at_54_6:I I1_at_55_6:I I1_at_56_6:I I1_at_57_6:I I1_af_50_6:I I1_af_51_6:I I1_af_52_6:I I1_af_53_6:I I1_af_54_6:I I1_af_55_6:I I1_af_56_6:I I1_af_57_6:I I1_aa:O O_at_50_6:O O_at_51_6:O O_at_52_6:O O_at_53_6:O O_at_54_6:O O_at_55_6:O O_at_56_6:O O_at_57_6:O O_af_50_6:O O_af_51_6:O O_af_52_6:O O_af_53_6:O O_af_54_6:O O_af_55_6:O O_af_56_6:O O_af_57_6:O O_aa:I
*.POWER VDD Vdd
*.POWER GND GND
*.POWER NSUB GND
*.POWER PSUB Vdd
*
* --- node flags ---
*
* n__I0__a (state-holding): pup_reff=0.4; pdn_reff=1.33333
* n__I1__a (state-holding): pup_reff=0.4; pdn_reff=1.33333
* n__O__t_50_6 (combinational)
* n__O__f_50_6 (combinational)
* n__O__t_51_6 (combinational)
* n__O__f_51_6 (combinational)
* n__O__t_52_6 (combinational)
* n__O__f_52_6 (combinational)
* n__O__t_53_6 (combinational)
* n__O__f_53_6 (combinational)
* n__O__t_54_6 (combinational)
* n__O__f_54_6 (combinational)
* n__O__t_55_6 (combinational)
* n__O__f_55_6 (combinational)
* n__O__t_56_6 (combinational)
* n__O__f_56_6 (combinational)
* n__O__t_57_6 (combinational)
* n__O__f_57_6 (combinational)
* I0_aa (combinational)
* I1_aa (combinational)
* O_at_50_6 (combinational)
* O_af_50_6 (combinational)
* O_at_51_6 (combinational)
* O_af_51_6 (combinational)
* O_at_52_6 (combinational)
* O_af_52_6 (combinational)
* O_at_53_6 (combinational)
* O_af_53_6 (combinational)
* O_at_54_6 (combinational)
* O_af_54_6 (combinational)
* O_at_55_6 (combinational)
* O_af_55_6 (combinational)
* O_at_56_6 (combinational)
* O_af_56_6 (combinational)
* O_at_57_6 (combinational)
* O_af_57_6 (combinational)
*
* --- end node flags ---
*
M0_ Vdd O_aa n__I0__a Vdd pmos W=0.1625U L=0.065U
M1_ Vdd O_aa n__I1__a Vdd pmos W=0.1625U L=0.065U
M2_ Vdd I0_at_50_6 #14 Vdd pmos W=0.1625U L=0.065U
M3_ Vdd I0_af_50_6 #18 Vdd pmos W=0.1625U L=0.065U
M4_ Vdd I0_at_51_6 #22 Vdd pmos W=0.1625U L=0.065U
M5_ Vdd I0_af_51_6 #26 Vdd pmos W=0.1625U L=0.065U
M6_ Vdd I0_at_52_6 #30 Vdd pmos W=0.1625U L=0.065U
M7_ Vdd I0_af_52_6 #34 Vdd pmos W=0.1625U L=0.065U
M8_ Vdd I0_at_53_6 #38 Vdd pmos W=0.1625U L=0.065U
M9_ Vdd I0_af_53_6 #42 Vdd pmos W=0.1625U L=0.065U
M10_ Vdd I0_at_54_6 #46 Vdd pmos W=0.1625U L=0.065U
M11_ Vdd I0_af_54_6 #50 Vdd pmos W=0.1625U L=0.065U
M12_ Vdd I0_at_55_6 #54 Vdd pmos W=0.1625U L=0.065U
M13_ Vdd I0_af_55_6 #58 Vdd pmos W=0.1625U L=0.065U
M14_ Vdd I0_at_56_6 #62 Vdd pmos W=0.1625U L=0.065U
M15_ Vdd I0_af_56_6 #66 Vdd pmos W=0.1625U L=0.065U
M16_ Vdd I0_at_57_6 #68 Vdd pmos W=0.1625U L=0.065U
M17_ Vdd I0_af_57_6 #70 Vdd pmos W=0.1625U L=0.065U
M18_ Vdd n__I0__a I0_aa Vdd pmos W=0.1625U L=0.065U
M19_ Vdd n__I1__a I1_aa Vdd pmos W=0.1625U L=0.065U
M20_ Vdd n__O__t_50_6 O_at_50_6 Vdd pmos W=0.1625U L=0.065U
M21_ Vdd n__O__f_50_6 O_af_50_6 Vdd pmos W=0.1625U L=0.065U
M22_ Vdd n__O__t_51_6 O_at_51_6 Vdd pmos W=0.1625U L=0.065U
M23_ Vdd n__O__f_51_6 O_af_51_6 Vdd pmos W=0.1625U L=0.065U
M24_ Vdd n__O__t_52_6 O_at_52_6 Vdd pmos W=0.1625U L=0.065U
M25_ Vdd n__O__f_52_6 O_af_52_6 Vdd pmos W=0.1625U L=0.065U
M26_ Vdd n__O__t_53_6 O_at_53_6 Vdd pmos W=0.1625U L=0.065U
M27_ Vdd n__O__f_53_6 O_af_53_6 Vdd pmos W=0.1625U L=0.065U
M28_ Vdd n__O__t_54_6 O_at_54_6 Vdd pmos W=0.1625U L=0.065U
M29_ Vdd n__O__f_54_6 O_af_54_6 Vdd pmos W=0.1625U L=0.065U
M30_ Vdd n__O__t_55_6 O_at_55_6 Vdd pmos W=0.1625U L=0.065U
M31_ Vdd n__O__f_55_6 O_af_55_6 Vdd pmos W=0.1625U L=0.065U
M32_ Vdd n__O__t_56_6 O_at_56_6 Vdd pmos W=0.1625U L=0.065U
M33_ Vdd n__O__f_56_6 O_af_56_6 Vdd pmos W=0.1625U L=0.065U
M34_ Vdd n__O__t_57_6 O_at_57_6 Vdd pmos W=0.1625U L=0.065U
M35_ Vdd n__O__f_57_6 O_af_57_6 Vdd pmos W=0.1625U L=0.065U
M36_ Vdd n__I0__a #fb89# Vdd pmos W=0.1625U L=0.13U
M37_ Vdd n__I1__a #fb92# Vdd pmos W=0.1625U L=0.13U
M38_keeper Vdd GND #90 Vdd pmos W=0.0975U L=0.585U
M39_keeper Vdd GND #93 Vdd pmos W=0.0975U L=0.585U
M40_ GND O_aa #3 GND nmos W=0.0975U L=0.065U
M41_ GND O_aa #8 GND nmos W=0.0975U L=0.065U
M42_ GND I0_at_50_6 n__O__t_50_6 GND nmos W=0.0975U L=0.065U
M43_ GND I1_at_50_6 n__O__t_50_6 GND nmos W=0.0975U L=0.065U
M44_ GND I0_af_50_6 n__O__f_50_6 GND nmos W=0.0975U L=0.065U
M45_ GND I1_af_50_6 n__O__f_50_6 GND nmos W=0.0975U L=0.065U
M46_ GND I0_at_51_6 n__O__t_51_6 GND nmos W=0.0975U L=0.065U
M47_ GND I1_at_51_6 n__O__t_51_6 GND nmos W=0.0975U L=0.065U
M48_ GND I0_af_51_6 n__O__f_51_6 GND nmos W=0.0975U L=0.065U
M49_ GND I1_af_51_6 n__O__f_51_6 GND nmos W=0.0975U L=0.065U
M50_ GND I0_at_52_6 n__O__t_52_6 GND nmos W=0.0975U L=0.065U
M51_ GND I1_at_52_6 n__O__t_52_6 GND nmos W=0.0975U L=0.065U
M52_ GND I0_af_52_6 n__O__f_52_6 GND nmos W=0.0975U L=0.065U
M53_ GND I1_af_52_6 n__O__f_52_6 GND nmos W=0.0975U L=0.065U
M54_ GND I0_at_53_6 n__O__t_53_6 GND nmos W=0.0975U L=0.065U
M55_ GND I1_at_53_6 n__O__t_53_6 GND nmos W=0.0975U L=0.065U
M56_ GND I0_af_53_6 n__O__f_53_6 GND nmos W=0.0975U L=0.065U
M57_ GND I1_af_53_6 n__O__f_53_6 GND nmos W=0.0975U L=0.065U
M58_ GND I0_at_54_6 n__O__t_54_6 GND nmos W=0.0975U L=0.065U
M59_ GND I1_at_54_6 n__O__t_54_6 GND nmos W=0.0975U L=0.065U
M60_ GND I0_af_54_6 n__O__f_54_6 GND nmos W=0.0975U L=0.065U
M61_ GND I1_af_54_6 n__O__f_54_6 GND nmos W=0.0975U L=0.065U
M62_ GND I0_at_55_6 n__O__t_55_6 GND nmos W=0.0975U L=0.065U
M63_ GND I1_at_55_6 n__O__t_55_6 GND nmos W=0.0975U L=0.065U
M64_ GND I0_af_55_6 n__O__f_55_6 GND nmos W=0.0975U L=0.065U
M65_ GND I1_af_55_6 n__O__f_55_6 GND nmos W=0.0975U L=0.065U
M66_ GND I0_at_56_6 n__O__t_56_6 GND nmos W=0.0975U L=0.065U
M67_ GND I1_at_56_6 n__O__t_56_6 GND nmos W=0.0975U L=0.065U
M68_ GND I0_af_56_6 n__O__f_56_6 GND nmos W=0.0975U L=0.065U
M69_ GND I1_af_56_6 n__O__f_56_6 GND nmos W=0.0975U L=0.065U
M70_ GND I0_at_57_6 n__O__t_57_6 GND nmos W=0.0975U L=0.065U
M71_ GND I1_at_57_6 n__O__t_57_6 GND nmos W=0.0975U L=0.065U
M72_ GND I0_af_57_6 n__O__f_57_6 GND nmos W=0.0975U L=0.065U
M73_ GND I1_af_57_6 n__O__f_57_6 GND nmos W=0.0975U L=0.065U
M74_ GND n__I0__a I0_aa GND nmos W=0.0975U L=0.065U
M75_ GND n__I1__a I1_aa GND nmos W=0.0975U L=0.065U
M76_ GND n__O__t_50_6 O_at_50_6 GND nmos W=0.0975U L=0.065U
M77_ GND n__O__f_50_6 O_af_50_6 GND nmos W=0.0975U L=0.065U
M78_ GND n__O__t_51_6 O_at_51_6 GND nmos W=0.0975U L=0.065U
M79_ GND n__O__f_51_6 O_af_51_6 GND nmos W=0.0975U L=0.065U
M80_ GND n__O__t_52_6 O_at_52_6 GND nmos W=0.0975U L=0.065U
M81_ GND n__O__f_52_6 O_af_52_6 GND nmos W=0.0975U L=0.065U
M82_ GND n__O__t_53_6 O_at_53_6 GND nmos W=0.0975U L=0.065U
M83_ GND n__O__f_53_6 O_af_53_6 GND nmos W=0.0975U L=0.065U
M84_ GND n__O__t_54_6 O_at_54_6 GND nmos W=0.0975U L=0.065U
M85_ GND n__O__f_54_6 O_af_54_6 GND nmos W=0.0975U L=0.065U
M86_ GND n__O__t_55_6 O_at_55_6 GND nmos W=0.0975U L=0.065U
M87_ GND n__O__f_55_6 O_af_55_6 GND nmos W=0.0975U L=0.065U
M88_ GND n__O__t_56_6 O_at_56_6 GND nmos W=0.0975U L=0.065U
M89_ GND n__O__f_56_6 O_af_56_6 GND nmos W=0.0975U L=0.065U
M90_ GND n__O__t_57_6 O_at_57_6 GND nmos W=0.0975U L=0.065U
M91_ GND n__O__f_57_6 O_af_57_6 GND nmos W=0.0975U L=0.065U
M92_ GND n__I0__a #fb89# GND nmos W=0.0975U L=0.13U
M93_ GND n__I1__a #fb92# GND nmos W=0.0975U L=0.13U
M94_keeper GND Vdd #91 GND nmos W=0.0975U L=0.715U
M95_keeper GND Vdd #94 GND nmos W=0.0975U L=0.715U
M96_ #3 I0_at_57_6 n__I0__a GND nmos W=0.0975U L=0.065U
M97_ #3 I0_af_57_6 n__I0__a GND nmos W=0.0975U L=0.065U
M98_keeper #90 #fb89# n__I0__a Vdd pmos W=0.0975U L=0.065U
M99_keeper #91 #fb89# n__I0__a GND nmos W=0.0975U L=0.065U
M100_ #8 I1_at_57_6 n__I1__a GND nmos W=0.0975U L=0.065U
M101_ #8 I1_af_57_6 n__I1__a GND nmos W=0.0975U L=0.065U
M102_keeper #93 #fb92# n__I1__a Vdd pmos W=0.0975U L=0.065U
M103_keeper #94 #fb92# n__I1__a GND nmos W=0.0975U L=0.065U
M104_ #14 I1_at_50_6 n__O__t_50_6 Vdd pmos W=0.1625U L=0.065U
M105_ #18 I1_af_50_6 n__O__f_50_6 Vdd pmos W=0.1625U L=0.065U
M106_ #22 I1_at_51_6 n__O__t_51_6 Vdd pmos W=0.1625U L=0.065U
M107_ #26 I1_af_51_6 n__O__f_51_6 Vdd pmos W=0.1625U L=0.065U
M108_ #30 I1_at_52_6 n__O__t_52_6 Vdd pmos W=0.1625U L=0.065U
M109_ #34 I1_af_52_6 n__O__f_52_6 Vdd pmos W=0.1625U L=0.065U
M110_ #38 I1_at_53_6 n__O__t_53_6 Vdd pmos W=0.1625U L=0.065U
M111_ #42 I1_af_53_6 n__O__f_53_6 Vdd pmos W=0.1625U L=0.065U
M112_ #46 I1_at_54_6 n__O__t_54_6 Vdd pmos W=0.1625U L=0.065U
M113_ #50 I1_af_54_6 n__O__f_54_6 Vdd pmos W=0.1625U L=0.065U
M114_ #54 I1_at_55_6 n__O__t_55_6 Vdd pmos W=0.1625U L=0.065U
M115_ #58 I1_af_55_6 n__O__f_55_6 Vdd pmos W=0.1625U L=0.065U
M116_ #62 I1_at_56_6 n__O__t_56_6 Vdd pmos W=0.1625U L=0.065U
M117_ #66 I1_af_56_6 n__O__f_56_6 Vdd pmos W=0.1625U L=0.065U
M118_ #68 I1_at_57_6 n__O__t_57_6 Vdd pmos W=0.1625U L=0.065U
M119_ #70 I1_af_57_6 n__O__f_57_6 Vdd pmos W=0.1625U L=0.065U
.ends
*---- end of process: Merge<8,f> -----
*
*---- act defproc: QVar<> -----
* raw ports:  reset W0.t[0] W0.t[1] W0.t[2] W0.t[3] W0.t[4] W0.t[5] W0.t[6] W0.t[7] W0.f[0] W0.f[1] W0.f[2] W0.f[3] W0.f[4] W0.f[5] W0.f[6] W0.f[7] W0.a W1.t[0] W1.t[1] W1.t[2] W1.t[3] W1.t[4] W1.t[5] W1.t[6] W1.t[7] W1.f[0] W1.f[1] W1.f[2] W1.f[3] W1.f[4] W1.f[5] W1.f[6] W1.f[7] W1.a R.req R.t[0] R.t[1] R.t[2] R.t[3] R.t[4] R.t[5] R.t[6] R.t[7] R.f[0] R.f[1] R.f[2] R.f[3] R.f[4] R.f[5] R.f[6] R.f[7]
*
.subckt QVar reset W0_at_50_6 W0_at_51_6 W0_at_52_6 W0_at_53_6 W0_at_54_6 W0_at_55_6 W0_at_56_6 W0_at_57_6 W0_af_50_6 W0_af_51_6 W0_af_52_6 W0_af_53_6 W0_af_54_6 W0_af_55_6 W0_af_56_6 W0_af_57_6 W0_aa W1_at_50_6 W1_at_51_6 W1_at_52_6 W1_at_53_6 W1_at_54_6 W1_at_55_6 W1_at_56_6 W1_at_57_6 W1_af_50_6 W1_af_51_6 W1_af_52_6 W1_af_53_6 W1_af_54_6 W1_af_55_6 W1_af_56_6 W1_af_57_6 W1_aa R_areq R_at_50_6 R_at_51_6 R_at_52_6 R_at_53_6 R_at_54_6 R_at_55_6 R_at_56_6 R_at_57_6 R_af_50_6 R_af_51_6 R_af_52_6 R_af_53_6 R_af_54_6 R_af_55_6 R_af_56_6 R_af_57_6
*.PININFO reset:I W0_at_50_6:I W0_at_51_6:I W0_at_52_6:I W0_at_53_6:I W0_at_54_6:I W0_at_55_6:I W0_at_56_6:I W0_at_57_6:I W0_af_50_6:I W0_af_51_6:I W0_af_52_6:I W0_af_53_6:I W0_af_54_6:I W0_af_55_6:I W0_af_56_6:I W0_af_57_6:I W0_aa:O W1_at_50_6:I W1_at_51_6:I W1_at_52_6:I W1_at_53_6:I W1_at_54_6:I W1_at_55_6:I W1_at_56_6:I W1_at_57_6:I W1_af_50_6:I W1_af_51_6:I W1_af_52_6:I W1_af_53_6:I W1_af_54_6:I W1_af_55_6:I W1_af_56_6:I W1_af_57_6:I W1_aa:O R_areq:I R_at_50_6:O R_at_51_6:O R_at_52_6:O R_at_53_6:O R_at_54_6:O R_at_55_6:O R_at_56_6:O R_at_57_6:O R_af_50_6:O R_af_51_6:O R_af_52_6:O R_af_53_6:O R_af_54_6:O R_af_55_6:O R_af_56_6:O R_af_57_6:O
*.POWER VDD Vdd
*.POWER GND GND
*.POWER NSUB GND
*.POWER PSUB Vdd
xreg reset reg_aW_at_50_6 reg_aW_at_51_6 reg_aW_at_52_6 reg_aW_at_53_6 reg_aW_at_54_6 reg_aW_at_55_6 reg_aW_at_56_6 reg_aW_at_57_6 reg_aW_af_50_6 reg_aW_af_51_6 reg_aW_af_52_6 reg_aW_af_53_6 reg_aW_af_54_6 reg_aW_af_55_6 reg_aW_af_56_6 reg_aW_af_57_6 reg_aW_aa R_areq R_at_50_6 R_at_51_6 R_at_52_6 R_at_53_6 R_at_54_6 R_at_55_6 R_at_56_6 R_at_57_6 R_af_50_6 R_af_51_6 R_af_52_6 R_af_53_6 R_af_54_6 R_af_55_6 R_af_56_6 R_af_57_6 Reg8
xmerge W0_at_50_6 W0_at_51_6 W0_at_52_6 W0_at_53_6 W0_at_54_6 W0_at_55_6 W0_at_56_6 W0_at_57_6 W0_af_50_6 W0_af_51_6 W0_af_52_6 W0_af_53_6 W0_af_54_6 W0_af_55_6 W0_af_56_6 W0_af_57_6 W0_aa W1_at_50_6 W1_at_51_6 W1_at_52_6 W1_at_53_6 W1_at_54_6 W1_at_55_6 W1_at_56_6 W1_at_57_6 W1_af_50_6 W1_af_51_6 W1_af_52_6 W1_af_53_6 W1_af_54_6 W1_af_55_6 W1_af_56_6 W1_af_57_6 W1_aa reg_aW_at_50_6 reg_aW_at_51_6 reg_aW_at_52_6 reg_aW_at_53_6 reg_aW_at_54_6 reg_aW_at_55_6 reg_aW_at_56_6 reg_aW_at_57_6 reg_aW_af_50_6 reg_aW_af_51_6 reg_aW_af_52_6 reg_aW_af_53_6 reg_aW_af_54_6 reg_aW_af_55_6 reg_aW_af_56_6 reg_aW_af_57_6 reg_aW_aa Merge_38_7f_4
.ends
*---- end of process: QVar<> -----
*
*---- act defproc: SUpdate<> -----
* raw ports:  reset I.t[0] I.t[1] I.t[2] I.t[3] I.f[0] I.f[1] I.f[2] I.f[3] I.a Od0.t[0] Od0.t[1] Od0.t[2] Od0.t[3] Od0.f[0] Od0.f[1] Od0.f[2] Od0.f[3] Od0.a Od1.t[0] Od1.t[1] Od1.t[2] Od1.t[3] Od1.f[0] Od1.f[1] Od1.f[2] Od1.f[3] Od1.a Od2.t[0] Od2.t[1] Od2.t[2] Od2.t[3] Od2.f[0] Od2.f[1] Od2.f[2] Od2.f[3] Od2.a Od3.t[0] Od3.t[1] Od3.t[2] Od3.t[3] Od3.f[0] Od3.f[1] Od3.f[2] Od3.f[3] Od3.a W0.t[0] W0.t[1] W0.t[2] W0.t[3] W0.t[4] W0.t[5] W0.t[6] W0.t[7] W0.f[0] W0.f[1] W0.f[2] W0.f[3] W0.f[4] W0.f[5] W0.f[6] W0.f[7] W0.a W1.t[0] W1.t[1] W1.t[2] W1.t[3] W1.t[4] W1.t[5] W1.t[6] W1.t[7] W1.f[0] W1.f[1] W1.f[2] W1.f[3] W1.f[4] W1.f[5] W1.f[6] W1.f[7] W1.a W2.t[0] W2.t[1] W2.t[2] W2.t[3] W2.t[4] W2.t[5] W2.t[6] W2.t[7] W2.f[0] W2.f[1] W2.f[2] W2.f[3] W2.f[4] W2.f[5] W2.f[6] W2.f[7] W2.a W3.t[0] W3.t[1] W3.t[2] W3.t[3] W3.t[4] W3.t[5] W3.t[6] W3.t[7] W3.f[0] W3.f[1] W3.f[2] W3.f[3] W3.f[4] W3.f[5] W3.f[6] W3.f[7] W3.a Ch.t[0] Ch.t[1] Ch.t[2] Ch.t[3] Ch.f[0] Ch.f[1] Ch.f[2] Ch.f[3] Ch.a A.req A.a
*
.subckt SUpdate reset I_at_50_6 I_at_51_6 I_at_52_6 I_at_53_6 I_af_50_6 I_af_51_6 I_af_52_6 I_af_53_6 I_aa Od0_at_50_6 Od0_at_51_6 Od0_at_52_6 Od0_at_53_6 Od0_af_50_6 Od0_af_51_6 Od0_af_52_6 Od0_af_53_6 Od0_aa Od1_at_50_6 Od1_at_51_6 Od1_at_52_6 Od1_at_53_6 Od1_af_50_6 Od1_af_51_6 Od1_af_52_6 Od1_af_53_6 Od1_aa Od2_at_50_6 Od2_at_51_6 Od2_at_52_6 Od2_at_53_6 Od2_af_50_6 Od2_af_51_6 Od2_af_52_6 Od2_af_53_6 Od2_aa Od3_at_50_6 Od3_at_51_6 Od3_at_52_6 Od3_at_53_6 Od3_af_50_6 Od3_af_51_6 Od3_af_52_6 Od3_af_53_6 Od3_aa W0_at_50_6 W0_at_51_6 W0_at_52_6 W0_at_53_6 W0_at_54_6 W0_at_55_6 W0_at_56_6 W0_at_57_6 W0_af_50_6 W0_af_51_6 W0_af_52_6 W0_af_53_6 W0_af_54_6 W0_af_55_6 W0_af_56_6 W0_af_57_6 W0_aa W1_at_50_6 W1_at_51_6 W1_at_52_6 W1_at_53_6 W1_at_54_6 W1_at_55_6 W1_at_56_6 W1_at_57_6 W1_af_50_6 W1_af_51_6 W1_af_52_6 W1_af_53_6 W1_af_54_6 W1_af_55_6 W1_af_56_6 W1_af_57_6 W1_aa W2_at_50_6 W2_at_51_6 W2_at_52_6 W2_at_53_6 W2_at_54_6 W2_at_55_6 W2_at_56_6 W2_at_57_6 W2_af_50_6 W2_af_51_6 W2_af_52_6 W2_af_53_6 W2_af_54_6 W2_af_55_6 W2_af_56_6 W2_af_57_6 W2_aa W3_at_50_6 W3_at_51_6 W3_at_52_6 W3_at_53_6 W3_at_54_6 W3_at_55_6 W3_at_56_6 W3_at_57_6 W3_af_50_6 W3_af_51_6 W3_af_52_6 W3_af_53_6 W3_af_54_6 W3_af_55_6 W3_af_56_6 W3_af_57_6 W3_aa Ch_at_50_6 Ch_at_51_6 Ch_at_52_6 Ch_at_53_6 Ch_af_50_6 Ch_af_51_6 Ch_af_52_6 Ch_af_53_6 Ch_aa A_areq A_aa
*.PININFO reset:I I_at_50_6:I I_at_51_6:I I_at_52_6:I I_at_53_6:I I_af_50_6:I I_af_51_6:I I_af_52_6:I I_af_53_6:I I_aa:O Od0_at_50_6:O Od0_at_51_6:O Od0_at_52_6:O Od0_at_53_6:O Od0_af_50_6:O Od0_af_51_6:O Od0_af_52_6:O Od0_af_53_6:O Od0_aa:I Od1_at_50_6:O Od1_at_51_6:O Od1_at_52_6:O Od1_at_53_6:O Od1_af_50_6:O Od1_af_51_6:O Od1_af_52_6:O Od1_af_53_6:O Od1_aa:I Od2_at_50_6:O Od2_at_51_6:O Od2_at_52_6:O Od2_at_53_6:O Od2_af_50_6:O Od2_af_51_6:O Od2_af_52_6:O Od2_af_53_6:O Od2_aa:I Od3_at_50_6:O Od3_at_51_6:O Od3_at_52_6:O Od3_at_53_6:O Od3_af_50_6:O Od3_af_51_6:O Od3_af_52_6:O Od3_af_53_6:O Od3_aa:I W0_at_50_6:O W0_at_51_6:O W0_at_52_6:O W0_at_53_6:O W0_at_54_6:O W0_at_55_6:O W0_at_56_6:O W0_at_57_6:O W0_af_50_6:O W0_af_51_6:O W0_af_52_6:O W0_af_53_6:O W0_af_54_6:O W0_af_55_6:O W0_af_56_6:O W0_af_57_6:O W0_aa:I W1_at_50_6:O W1_at_51_6:O W1_at_52_6:O W1_at_53_6:O W1_at_54_6:O W1_at_55_6:O W1_at_56_6:O W1_at_57_6:O W1_af_50_6:O W1_af_51_6:O W1_af_52_6:O W1_af_53_6:O W1_af_54_6:O W1_af_55_6:O W1_af_56_6:O W1_af_57_6:O W1_aa:I W2_at_50_6:O W2_at_51_6:O W2_at_52_6:O W2_at_53_6:O W2_at_54_6:O W2_at_55_6:O W2_at_56_6:O W2_at_57_6:O W2_af_50_6:O W2_af_51_6:O W2_af_52_6:O W2_af_53_6:O W2_af_54_6:O W2_af_55_6:O W2_af_56_6:O W2_af_57_6:O W2_aa:I W3_at_50_6:O W3_at_51_6:O W3_at_52_6:O W3_at_53_6:O W3_at_54_6:O W3_at_55_6:O W3_at_56_6:O W3_at_57_6:O W3_af_50_6:O W3_af_51_6:O W3_af_52_6:O W3_af_53_6:O W3_af_54_6:O W3_af_55_6:O W3_af_56_6:O W3_af_57_6:O W3_aa:I Ch_at_50_6:O Ch_at_51_6:O Ch_at_52_6:O Ch_at_53_6:O Ch_af_50_6:O Ch_af_51_6:O Ch_af_52_6:O Ch_af_53_6:O Ch_aa:I A_areq:I A_aa:O
*.POWER VDD Vdd
*.POWER GND GND
*.POWER NSUB GND
*.POWER PSUB Vdd
*
* --- node flags ---
*
* __p0 (state-holding): pup_reff=2.4; pdn_reff=4
* __ia (state-holding): pup_reff=2.8; pdn_reff=2.66667
* __s (combinational)
* __r (combinational)
* p1 (state-holding): pup_reff=1.2; pdn_reff=4
* __ar (combinational)
* __it_53_6 (combinational)
* __it_52_6 (combinational)
* __it_51_6 (combinational)
* __it_50_6 (combinational)
* __wa_50_6 (combinational)
* __wa_51_6 (combinational)
* __wa_52_6 (combinational)
* __wa_53_6 (combinational)
* __cha (combinational)
* k (state-holding): pup_reff=3.6; pdn_reff=5.33333
* __p1 (combinational)
* __b_53_6 (combinational)
* __if_53_6 (combinational)
* b_53_6 (state-holding): pup_reff=1.2; pdn_reff=2
* __b_52_6 (combinational)
* __if_52_6 (combinational)
* b_52_6 (state-holding): pup_reff=1.2; pdn_reff=2
* __b_51_6 (combinational)
* __if_51_6 (combinational)
* b_51_6 (state-holding): pup_reff=1.2; pdn_reff=2
* __b_50_6 (combinational)
* __if_50_6 (combinational)
* b_50_6 (state-holding): pup_reff=1.2; pdn_reff=2
* p0 (combinational)
* A_aa (state-holding): pup_reff=1.2; pdn_reff=1.33333
* s (state-holding): pup_reff=2.4; pdn_reff=3.33333
* Od0_at_50_6 (state-holding): pup_reff=-1; pdn_reff=0.666667
* Od0_af_50_6 (state-holding): pup_reff=0.8; pdn_reff=0.666667
* I_aa (combinational)
* Od0_at_51_6 (state-holding): pup_reff=-1; pdn_reff=0.666667
* Od0_af_51_6 (state-holding): pup_reff=0.8; pdn_reff=0.666667
* Od0_at_52_6 (state-holding): pup_reff=-1; pdn_reff=0.666667
* Od0_af_52_6 (state-holding): pup_reff=0.8; pdn_reff=0.666667
* Od0_at_53_6 (state-holding): pup_reff=-1; pdn_reff=0.666667
* Od0_af_53_6 (state-holding): pup_reff=0.8; pdn_reff=0.666667
* Od1_at_50_6 (state-holding): pup_reff=-1; pdn_reff=0.666667
* Od1_af_50_6 (state-holding): pup_reff=0.8; pdn_reff=0.666667
* Od1_at_51_6 (state-holding): pup_reff=-1; pdn_reff=0.666667
* Od1_af_51_6 (state-holding): pup_reff=0.8; pdn_reff=0.666667
* Od1_at_52_6 (state-holding): pup_reff=-1; pdn_reff=0.666667
* Od1_af_52_6 (state-holding): pup_reff=0.8; pdn_reff=0.666667
* Od1_at_53_6 (state-holding): pup_reff=-1; pdn_reff=0.666667
* Od1_af_53_6 (state-holding): pup_reff=0.8; pdn_reff=0.666667
* Od2_at_50_6 (state-holding): pup_reff=-1; pdn_reff=0.666667
* Od2_af_50_6 (state-holding): pup_reff=0.8; pdn_reff=0.666667
* Od2_at_51_6 (state-holding): pup_reff=-1; pdn_reff=0.666667
* Od2_af_51_6 (state-holding): pup_reff=0.8; pdn_reff=0.666667
* Od2_at_52_6 (state-holding): pup_reff=-1; pdn_reff=0.666667
* Od2_af_52_6 (state-holding): pup_reff=0.8; pdn_reff=0.666667
* Od2_at_53_6 (state-holding): pup_reff=-1; pdn_reff=0.666667
* Od2_af_53_6 (state-holding): pup_reff=0.8; pdn_reff=0.666667
* Od3_at_50_6 (state-holding): pup_reff=-1; pdn_reff=0.666667
* Od3_af_50_6 (state-holding): pup_reff=0.8; pdn_reff=0.666667
* Od3_at_51_6 (state-holding): pup_reff=-1; pdn_reff=0.666667
* Od3_af_51_6 (state-holding): pup_reff=0.8; pdn_reff=0.666667
* Od3_at_52_6 (state-holding): pup_reff=-1; pdn_reff=0.666667
* Od3_af_52_6 (state-holding): pup_reff=0.8; pdn_reff=0.666667
* Od3_at_53_6 (state-holding): pup_reff=-1; pdn_reff=0.666667
* Od3_af_53_6 (state-holding): pup_reff=0.8; pdn_reff=0.666667
* __aa (combinational)
* W0_at_51_6 (state-holding): pup_reff=-1; pdn_reff=0.666667
* W0_af_51_6 (state-holding): pup_reff=1.6; pdn_reff=0.666667
* W0_at_52_6 (state-holding): pup_reff=-1; pdn_reff=0.666667
* W0_af_52_6 (state-holding): pup_reff=1.6; pdn_reff=0.666667
* W0_at_53_6 (state-holding): pup_reff=-1; pdn_reff=0.666667
* W0_af_53_6 (state-holding): pup_reff=1.6; pdn_reff=0.666667
* W0_at_54_6 (state-holding): pup_reff=-1; pdn_reff=0.666667
* W0_af_54_6 (state-holding): pup_reff=1.6; pdn_reff=0.666667
* W0_at_55_6 (state-holding): pup_reff=-1; pdn_reff=0.666667
* W0_af_55_6 (state-holding): pup_reff=1.6; pdn_reff=0.666667
* W0_at_56_6 (state-holding): pup_reff=-1; pdn_reff=0.666667
* W0_af_56_6 (state-holding): pup_reff=1.6; pdn_reff=0.666667
* W0_at_57_6 (state-holding): pup_reff=-1; pdn_reff=0.666667
* W0_af_57_6 (state-holding): pup_reff=1.6; pdn_reff=0.666667
* W0_at_50_6 (state-holding): pup_reff=2; pdn_reff=0.666667
* W0_af_50_6 (state-holding): pup_reff=2; pdn_reff=0.666667
* W1_at_51_6 (state-holding): pup_reff=-1; pdn_reff=0.666667
* W1_af_51_6 (state-holding): pup_reff=1.6; pdn_reff=0.666667
* W1_at_52_6 (state-holding): pup_reff=-1; pdn_reff=0.666667
* W1_af_52_6 (state-holding): pup_reff=1.6; pdn_reff=0.666667
* W1_at_53_6 (state-holding): pup_reff=-1; pdn_reff=0.666667
* W1_af_53_6 (state-holding): pup_reff=1.6; pdn_reff=0.666667
* W1_at_54_6 (state-holding): pup_reff=-1; pdn_reff=0.666667
* W1_af_54_6 (state-holding): pup_reff=1.6; pdn_reff=0.666667
* W1_at_55_6 (state-holding): pup_reff=-1; pdn_reff=0.666667
* W1_af_55_6 (state-holding): pup_reff=1.6; pdn_reff=0.666667
* W1_at_56_6 (state-holding): pup_reff=-1; pdn_reff=0.666667
* W1_af_56_6 (state-holding): pup_reff=1.6; pdn_reff=0.666667
* W1_at_57_6 (state-holding): pup_reff=-1; pdn_reff=0.666667
* W1_af_57_6 (state-holding): pup_reff=1.6; pdn_reff=0.666667
* W1_at_50_6 (state-holding): pup_reff=2; pdn_reff=0.666667
* W1_af_50_6 (state-holding): pup_reff=2; pdn_reff=0.666667
* W2_at_51_6 (state-holding): pup_reff=-1; pdn_reff=0.666667
* W2_af_51_6 (state-holding): pup_reff=1.6; pdn_reff=0.666667
* W2_at_52_6 (state-holding): pup_reff=-1; pdn_reff=0.666667
* W2_af_52_6 (state-holding): pup_reff=1.6; pdn_reff=0.666667
* W2_at_53_6 (state-holding): pup_reff=-1; pdn_reff=0.666667
* W2_af_53_6 (state-holding): pup_reff=1.6; pdn_reff=0.666667
* W2_at_54_6 (state-holding): pup_reff=-1; pdn_reff=0.666667
* W2_af_54_6 (state-holding): pup_reff=1.6; pdn_reff=0.666667
* W2_at_55_6 (state-holding): pup_reff=-1; pdn_reff=0.666667
* W2_af_55_6 (state-holding): pup_reff=1.6; pdn_reff=0.666667
* W2_at_56_6 (state-holding): pup_reff=-1; pdn_reff=0.666667
* W2_af_56_6 (state-holding): pup_reff=1.6; pdn_reff=0.666667
* W2_at_57_6 (state-holding): pup_reff=-1; pdn_reff=0.666667
* W2_af_57_6 (state-holding): pup_reff=1.6; pdn_reff=0.666667
* W2_at_50_6 (state-holding): pup_reff=2; pdn_reff=0.666667
* W2_af_50_6 (state-holding): pup_reff=2; pdn_reff=0.666667
* W3_at_51_6 (state-holding): pup_reff=-1; pdn_reff=0.666667
* W3_af_51_6 (state-holding): pup_reff=1.6; pdn_reff=0.666667
* W3_at_52_6 (state-holding): pup_reff=-1; pdn_reff=0.666667
* W3_af_52_6 (state-holding): pup_reff=1.6; pdn_reff=0.666667
* W3_at_53_6 (state-holding): pup_reff=-1; pdn_reff=0.666667
* W3_af_53_6 (state-holding): pup_reff=1.6; pdn_reff=0.666667
* W3_at_54_6 (state-holding): pup_reff=-1; pdn_reff=0.666667
* W3_af_54_6 (state-holding): pup_reff=1.6; pdn_reff=0.666667
* W3_at_55_6 (state-holding): pup_reff=-1; pdn_reff=0.666667
* W3_af_55_6 (state-holding): pup_reff=1.6; pdn_reff=0.666667
* W3_at_56_6 (state-holding): pup_reff=-1; pdn_reff=0.666667
* W3_af_56_6 (state-holding): pup_reff=1.6; pdn_reff=0.666667
* W3_at_57_6 (state-holding): pup_reff=-1; pdn_reff=0.666667
* W3_af_57_6 (state-holding): pup_reff=1.6; pdn_reff=0.666667
* W3_at_50_6 (state-holding): pup_reff=2; pdn_reff=0.666667
* W3_af_50_6 (state-holding): pup_reff=2; pdn_reff=0.666667
* Ch_at_50_6 (state-holding): pup_reff=2; pdn_reff=0.666667
* Ch_af_50_6 (state-holding): pup_reff=2; pdn_reff=0.666667
* Ch_at_51_6 (state-holding): pup_reff=2; pdn_reff=0.666667
* Ch_af_51_6 (state-holding): pup_reff=2; pdn_reff=0.666667
* Ch_at_52_6 (state-holding): pup_reff=2; pdn_reff=0.666667
* Ch_af_52_6 (state-holding): pup_reff=2; pdn_reff=0.666667
* Ch_at_53_6 (state-holding): pup_reff=2; pdn_reff=0.666667
* Ch_af_53_6 (state-holding): pup_reff=2; pdn_reff=0.666667
*
* --- end node flags ---
*
M0_ Vdd __ia #15 Vdd pmos W=0.1625U L=0.065U
M1_ Vdd __r __p0 Vdd pmos W=0.1625U L=0.065U
M2_ Vdd __ar #27 Vdd pmos W=0.1625U L=0.065U
M3_ Vdd __p1 #45 Vdd pmos W=0.1625U L=0.065U
M4_ Vdd p0 #85 Vdd pmos W=0.1625U L=0.065U
M5_ Vdd __r __ia Vdd pmos W=0.1625U L=0.065U
M6_ Vdd __p0 #93 Vdd pmos W=0.1625U L=0.065U
M7_ Vdd __r s Vdd pmos W=0.1625U L=0.065U
M8_ Vdd __ar #103 Vdd pmos W=0.1625U L=0.065U
M9_ Vdd I_aa #108 Vdd pmos W=0.1625U L=0.065U
M10_ Vdd I_aa #112 Vdd pmos W=0.1625U L=0.065U
M11_ Vdd I_aa #115 Vdd pmos W=0.1625U L=0.065U
M12_ Vdd I_aa #118 Vdd pmos W=0.1625U L=0.065U
M13_ Vdd I_aa #121 Vdd pmos W=0.1625U L=0.065U
M14_ Vdd I_aa #124 Vdd pmos W=0.1625U L=0.065U
M15_ Vdd I_aa #127 Vdd pmos W=0.1625U L=0.065U
M16_ Vdd I_aa #130 Vdd pmos W=0.1625U L=0.065U
M17_ Vdd I_aa #133 Vdd pmos W=0.1625U L=0.065U
M18_ Vdd I_aa #136 Vdd pmos W=0.1625U L=0.065U
M19_ Vdd I_aa #139 Vdd pmos W=0.1625U L=0.065U
M20_ Vdd I_aa #142 Vdd pmos W=0.1625U L=0.065U
M21_ Vdd I_aa #145 Vdd pmos W=0.1625U L=0.065U
M22_ Vdd I_aa #148 Vdd pmos W=0.1625U L=0.065U
M23_ Vdd I_aa #151 Vdd pmos W=0.1625U L=0.065U
M24_ Vdd I_aa #154 Vdd pmos W=0.1625U L=0.065U
M25_ Vdd __aa #156 Vdd pmos W=0.1625U L=0.065U
M26_ Vdd __aa #161 Vdd pmos W=0.1625U L=0.065U
M27_ Vdd __aa #165 Vdd pmos W=0.1625U L=0.065U
M28_ Vdd __aa #169 Vdd pmos W=0.1625U L=0.065U
M29_ Vdd __s #176 Vdd pmos W=0.1625U L=0.065U
M30_ Vdd __s #181 Vdd pmos W=0.1625U L=0.065U
M31_ Vdd __s #186 Vdd pmos W=0.1625U L=0.065U
M32_ Vdd __s #191 Vdd pmos W=0.1625U L=0.065U
M33_ Vdd __s #196 Vdd pmos W=0.1625U L=0.065U
M34_ Vdd __s #201 Vdd pmos W=0.1625U L=0.065U
M35_ Vdd __s #206 Vdd pmos W=0.1625U L=0.065U
M36_ Vdd __s #211 Vdd pmos W=0.1625U L=0.065U
M37_ Vdd __s #216 Vdd pmos W=0.1625U L=0.065U
M38_ Vdd __s #221 Vdd pmos W=0.1625U L=0.065U
M39_ Vdd __s #226 Vdd pmos W=0.1625U L=0.065U
M40_ Vdd __s #231 Vdd pmos W=0.1625U L=0.065U
M41_ Vdd __s #236 Vdd pmos W=0.1625U L=0.065U
M42_ Vdd __s #241 Vdd pmos W=0.1625U L=0.065U
M43_ Vdd __s #246 Vdd pmos W=0.1625U L=0.065U
M44_ Vdd __s #251 Vdd pmos W=0.1625U L=0.065U
M45_ Vdd __s #256 Vdd pmos W=0.1625U L=0.065U
M46_ Vdd __s #261 Vdd pmos W=0.1625U L=0.065U
M47_ Vdd __s #266 Vdd pmos W=0.1625U L=0.065U
M48_ Vdd __s #271 Vdd pmos W=0.1625U L=0.065U
M49_ Vdd __s #276 Vdd pmos W=0.1625U L=0.065U
M50_ Vdd __s #281 Vdd pmos W=0.1625U L=0.065U
M51_ Vdd __s #286 Vdd pmos W=0.1625U L=0.065U
M52_ Vdd __s #291 Vdd pmos W=0.1625U L=0.065U
M53_ Vdd __s #296 Vdd pmos W=0.1625U L=0.065U
M54_ Vdd __s #301 Vdd pmos W=0.1625U L=0.065U
M55_ Vdd __s #306 Vdd pmos W=0.1625U L=0.065U
M56_ Vdd __s #311 Vdd pmos W=0.1625U L=0.065U
M57_ Vdd __s #316 Vdd pmos W=0.1625U L=0.065U
M58_ Vdd __s #321 Vdd pmos W=0.1625U L=0.065U
M59_ Vdd __s #326 Vdd pmos W=0.1625U L=0.065U
M60_ Vdd __s #331 Vdd pmos W=0.1625U L=0.065U
M61_ Vdd __s #336 Vdd pmos W=0.1625U L=0.065U
M62_ Vdd __s #341 Vdd pmos W=0.1625U L=0.065U
M63_ Vdd __s #346 Vdd pmos W=0.1625U L=0.065U
M64_ Vdd __s #351 Vdd pmos W=0.1625U L=0.065U
M65_ Vdd __s #356 Vdd pmos W=0.1625U L=0.065U
M66_ Vdd __s #361 Vdd pmos W=0.1625U L=0.065U
M67_ Vdd __s #366 Vdd pmos W=0.1625U L=0.065U
M68_ Vdd __s #371 Vdd pmos W=0.1625U L=0.065U
M69_ Vdd __s #376 Vdd pmos W=0.1625U L=0.065U
M70_ Vdd __s #381 Vdd pmos W=0.1625U L=0.065U
M71_ Vdd __s #386 Vdd pmos W=0.1625U L=0.065U
M72_ Vdd __s #391 Vdd pmos W=0.1625U L=0.065U
M73_ Vdd s __s Vdd pmos W=0.1625U L=0.065U
M74_ Vdd reset __r Vdd pmos W=0.1625U L=0.065U
M75_ Vdd A_areq __ar Vdd pmos W=0.1625U L=0.065U
M76_ Vdd p1 __p1 Vdd pmos W=0.1625U L=0.065U
M77_ Vdd A_aa __aa Vdd pmos W=0.1625U L=0.065U
M78_ Vdd b_50_6 __b_50_6 Vdd pmos W=0.1625U L=0.065U
M79_ Vdd I_at_50_6 __it_50_6 Vdd pmos W=0.1625U L=0.065U
M80_ Vdd I_af_50_6 __if_50_6 Vdd pmos W=0.1625U L=0.065U
M81_ Vdd b_51_6 __b_51_6 Vdd pmos W=0.1625U L=0.065U
M82_ Vdd I_at_51_6 __it_51_6 Vdd pmos W=0.1625U L=0.065U
M83_ Vdd I_af_51_6 __if_51_6 Vdd pmos W=0.1625U L=0.065U
M84_ Vdd b_52_6 __b_52_6 Vdd pmos W=0.1625U L=0.065U
M85_ Vdd I_at_52_6 __it_52_6 Vdd pmos W=0.1625U L=0.065U
M86_ Vdd I_af_52_6 __if_52_6 Vdd pmos W=0.1625U L=0.065U
M87_ Vdd b_53_6 __b_53_6 Vdd pmos W=0.1625U L=0.065U
M88_ Vdd I_at_53_6 __it_53_6 Vdd pmos W=0.1625U L=0.065U
M89_ Vdd I_af_53_6 __if_53_6 Vdd pmos W=0.1625U L=0.065U
M90_ Vdd W0_aa __wa_50_6 Vdd pmos W=0.1625U L=0.065U
M91_ Vdd W1_aa __wa_51_6 Vdd pmos W=0.1625U L=0.065U
M92_ Vdd W2_aa __wa_52_6 Vdd pmos W=0.1625U L=0.065U
M93_ Vdd W3_aa __wa_53_6 Vdd pmos W=0.1625U L=0.065U
M94_ Vdd Ch_aa __cha Vdd pmos W=0.1625U L=0.065U
M95_ Vdd __p0 p0 Vdd pmos W=0.1625U L=0.065U
M96_ Vdd __ia I_aa Vdd pmos W=0.1625U L=0.065U
M97_ Vdd __p0 #fb396# Vdd pmos W=0.1625U L=0.13U
M98_ Vdd __ia #fb399# Vdd pmos W=0.1625U L=0.13U
M99_keeper Vdd GND #397 Vdd pmos W=0.0975U L=1.885U
M100_ Vdd p1 #fb402# Vdd pmos W=0.1625U L=0.13U
M101_keeper Vdd GND #400 Vdd pmos W=0.0975U L=1.235U
M102_ Vdd k #fb405# Vdd pmos W=0.1625U L=0.13U
M103_keeper Vdd GND #403 Vdd pmos W=0.0975U L=1.885U
M104_ Vdd b_53_6 #fb408# Vdd pmos W=0.1625U L=0.13U
M105_keeper Vdd GND #406 Vdd pmos W=0.0975U L=2.535U
M106_ Vdd b_52_6 #fb411# Vdd pmos W=0.1625U L=0.13U
M107_keeper Vdd GND #409 Vdd pmos W=0.0975U L=0.91U
M108_ Vdd b_51_6 #fb414# Vdd pmos W=0.1625U L=0.13U
M109_keeper Vdd GND #412 Vdd pmos W=0.0975U L=0.91U
M110_ Vdd b_50_6 #fb417# Vdd pmos W=0.1625U L=0.13U
M111_keeper Vdd GND #415 Vdd pmos W=0.0975U L=0.91U
M112_ Vdd A_aa #fb420# Vdd pmos W=0.1625U L=0.13U
M113_keeper Vdd GND #418 Vdd pmos W=0.0975U L=0.91U
M114_ Vdd s #fb423# Vdd pmos W=0.1625U L=0.13U
M115_keeper Vdd GND #421 Vdd pmos W=0.0975U L=0.585U
M116_ Vdd Od0_at_50_6 #fb426# Vdd pmos W=0.1625U L=0.13U
M117_keeper Vdd GND #424 Vdd pmos W=0.0975U L=1.56U
M118_ Vdd Od0_af_50_6 #fb428# Vdd pmos W=0.1625U L=0.13U
M119_keeper Vdd GND #427 Vdd pmos W=0.0975U L=0.26U
M120_ Vdd Od0_at_51_6 #fb431# Vdd pmos W=0.1625U L=0.13U
M121_keeper Vdd GND #429 Vdd pmos W=0.0975U L=0.26U
M122_ Vdd Od0_af_51_6 #fb433# Vdd pmos W=0.1625U L=0.13U
M123_keeper Vdd GND #432 Vdd pmos W=0.0975U L=0.26U
M124_ Vdd Od0_at_52_6 #fb436# Vdd pmos W=0.1625U L=0.13U
M125_keeper Vdd GND #434 Vdd pmos W=0.0975U L=0.26U
M126_ Vdd Od0_af_52_6 #fb438# Vdd pmos W=0.1625U L=0.13U
M127_keeper Vdd GND #437 Vdd pmos W=0.0975U L=0.26U
M128_ Vdd Od0_at_53_6 #fb441# Vdd pmos W=0.1625U L=0.13U
M129_keeper Vdd GND #439 Vdd pmos W=0.0975U L=0.26U
M130_ Vdd Od0_af_53_6 #fb443# Vdd pmos W=0.1625U L=0.13U
M131_keeper Vdd GND #442 Vdd pmos W=0.0975U L=0.26U
M132_ Vdd Od1_at_50_6 #fb446# Vdd pmos W=0.1625U L=0.13U
M133_keeper Vdd GND #444 Vdd pmos W=0.0975U L=0.26U
M134_ Vdd Od1_af_50_6 #fb448# Vdd pmos W=0.1625U L=0.13U
M135_keeper Vdd GND #447 Vdd pmos W=0.0975U L=0.26U
M136_ Vdd Od1_at_51_6 #fb451# Vdd pmos W=0.1625U L=0.13U
M137_keeper Vdd GND #449 Vdd pmos W=0.0975U L=0.26U
M138_ Vdd Od1_af_51_6 #fb453# Vdd pmos W=0.1625U L=0.13U
M139_keeper Vdd GND #452 Vdd pmos W=0.0975U L=0.26U
M140_ Vdd Od1_at_52_6 #fb456# Vdd pmos W=0.1625U L=0.13U
M141_keeper Vdd GND #454 Vdd pmos W=0.0975U L=0.26U
M142_ Vdd Od1_af_52_6 #fb458# Vdd pmos W=0.1625U L=0.13U
M143_keeper Vdd GND #457 Vdd pmos W=0.0975U L=0.26U
M144_ Vdd Od1_at_53_6 #fb461# Vdd pmos W=0.1625U L=0.13U
M145_keeper Vdd GND #459 Vdd pmos W=0.0975U L=0.26U
M146_ Vdd Od1_af_53_6 #fb463# Vdd pmos W=0.1625U L=0.13U
M147_keeper Vdd GND #462 Vdd pmos W=0.0975U L=0.26U
M148_ Vdd Od2_at_50_6 #fb466# Vdd pmos W=0.1625U L=0.13U
M149_keeper Vdd GND #464 Vdd pmos W=0.0975U L=0.26U
M150_ Vdd Od2_af_50_6 #fb468# Vdd pmos W=0.1625U L=0.13U
M151_keeper Vdd GND #467 Vdd pmos W=0.0975U L=0.26U
M152_ Vdd Od2_at_51_6 #fb471# Vdd pmos W=0.1625U L=0.13U
M153_keeper Vdd GND #469 Vdd pmos W=0.0975U L=0.26U
M154_ Vdd Od2_af_51_6 #fb473# Vdd pmos W=0.1625U L=0.13U
M155_keeper Vdd GND #472 Vdd pmos W=0.0975U L=0.26U
M156_ Vdd Od2_at_52_6 #fb476# Vdd pmos W=0.1625U L=0.13U
M157_keeper Vdd GND #474 Vdd pmos W=0.0975U L=0.26U
M158_ Vdd Od2_af_52_6 #fb478# Vdd pmos W=0.1625U L=0.13U
M159_keeper Vdd GND #477 Vdd pmos W=0.0975U L=0.26U
M160_ Vdd Od2_at_53_6 #fb481# Vdd pmos W=0.1625U L=0.13U
M161_keeper Vdd GND #479 Vdd pmos W=0.0975U L=0.26U
M162_ Vdd Od2_af_53_6 #fb483# Vdd pmos W=0.1625U L=0.13U
M163_keeper Vdd GND #482 Vdd pmos W=0.0975U L=0.26U
M164_ Vdd Od3_at_50_6 #fb486# Vdd pmos W=0.1625U L=0.13U
M165_keeper Vdd GND #484 Vdd pmos W=0.0975U L=0.26U
M166_ Vdd Od3_af_50_6 #fb488# Vdd pmos W=0.1625U L=0.13U
M167_keeper Vdd GND #487 Vdd pmos W=0.0975U L=0.26U
M168_ Vdd Od3_at_51_6 #fb491# Vdd pmos W=0.1625U L=0.13U
M169_keeper Vdd GND #489 Vdd pmos W=0.0975U L=0.26U
M170_ Vdd Od3_af_51_6 #fb493# Vdd pmos W=0.1625U L=0.13U
M171_keeper Vdd GND #492 Vdd pmos W=0.0975U L=0.26U
M172_ Vdd Od3_at_52_6 #fb496# Vdd pmos W=0.1625U L=0.13U
M173_keeper Vdd GND #494 Vdd pmos W=0.0975U L=0.26U
M174_ Vdd Od3_af_52_6 #fb498# Vdd pmos W=0.1625U L=0.13U
M175_keeper Vdd GND #497 Vdd pmos W=0.0975U L=0.26U
M176_ Vdd Od3_at_53_6 #fb501# Vdd pmos W=0.1625U L=0.13U
M177_keeper Vdd GND #499 Vdd pmos W=0.0975U L=0.26U
M178_ Vdd Od3_af_53_6 #fb503# Vdd pmos W=0.1625U L=0.13U
M179_keeper Vdd GND #502 Vdd pmos W=0.0975U L=0.26U
M180_ Vdd W0_at_51_6 #fb506# Vdd pmos W=0.1625U L=0.13U
M181_keeper Vdd GND #504 Vdd pmos W=0.0975U L=0.26U
M182_ Vdd W0_af_51_6 #fb508# Vdd pmos W=0.1625U L=0.13U
M183_keeper Vdd GND #507 Vdd pmos W=0.0975U L=0.26U
M184_ Vdd W0_at_52_6 #fb511# Vdd pmos W=0.1625U L=0.13U
M185_keeper Vdd GND #509 Vdd pmos W=0.0975U L=0.26U
M186_ Vdd W0_af_52_6 #fb513# Vdd pmos W=0.1625U L=0.13U
M187_keeper Vdd GND #512 Vdd pmos W=0.0975U L=0.26U
M188_ Vdd W0_at_53_6 #fb516# Vdd pmos W=0.1625U L=0.13U
M189_keeper Vdd GND #514 Vdd pmos W=0.0975U L=0.26U
M190_ Vdd W0_af_53_6 #fb518# Vdd pmos W=0.1625U L=0.13U
M191_keeper Vdd GND #517 Vdd pmos W=0.0975U L=0.26U
M192_ Vdd W0_at_54_6 #fb521# Vdd pmos W=0.1625U L=0.13U
M193_keeper Vdd GND #519 Vdd pmos W=0.0975U L=0.26U
M194_ Vdd W0_af_54_6 #fb523# Vdd pmos W=0.1625U L=0.13U
M195_keeper Vdd GND #522 Vdd pmos W=0.0975U L=0.26U
M196_ Vdd W0_at_55_6 #fb526# Vdd pmos W=0.1625U L=0.13U
M197_keeper Vdd GND #524 Vdd pmos W=0.0975U L=0.26U
M198_ Vdd W0_af_55_6 #fb528# Vdd pmos W=0.1625U L=0.13U
M199_keeper Vdd GND #527 Vdd pmos W=0.0975U L=0.26U
M200_ Vdd W0_at_56_6 #fb531# Vdd pmos W=0.1625U L=0.13U
M201_keeper Vdd GND #529 Vdd pmos W=0.0975U L=0.26U
M202_ Vdd W0_af_56_6 #fb533# Vdd pmos W=0.1625U L=0.13U
M203_keeper Vdd GND #532 Vdd pmos W=0.0975U L=0.26U
M204_ Vdd W0_at_57_6 #fb536# Vdd pmos W=0.1625U L=0.13U
M205_keeper Vdd GND #534 Vdd pmos W=0.0975U L=0.26U
M206_ Vdd W0_af_57_6 #fb538# Vdd pmos W=0.1625U L=0.13U
M207_keeper Vdd GND #537 Vdd pmos W=0.0975U L=0.26U
M208_ Vdd W0_at_50_6 #fb541# Vdd pmos W=0.1625U L=0.13U
M209_keeper Vdd GND #539 Vdd pmos W=0.0975U L=0.26U
M210_ Vdd W0_af_50_6 #fb544# Vdd pmos W=0.1625U L=0.13U
M211_keeper Vdd GND #542 Vdd pmos W=0.0975U L=0.26U
M212_ Vdd W1_at_51_6 #fb547# Vdd pmos W=0.1625U L=0.13U
M213_keeper Vdd GND #545 Vdd pmos W=0.0975U L=0.26U
M214_ Vdd W1_af_51_6 #fb549# Vdd pmos W=0.1625U L=0.13U
M215_keeper Vdd GND #548 Vdd pmos W=0.0975U L=0.26U
M216_ Vdd W1_at_52_6 #fb552# Vdd pmos W=0.1625U L=0.13U
M217_keeper Vdd GND #550 Vdd pmos W=0.0975U L=0.26U
M218_ Vdd W1_af_52_6 #fb554# Vdd pmos W=0.1625U L=0.13U
M219_keeper Vdd GND #553 Vdd pmos W=0.0975U L=0.26U
M220_ Vdd W1_at_53_6 #fb557# Vdd pmos W=0.1625U L=0.13U
M221_keeper Vdd GND #555 Vdd pmos W=0.0975U L=0.26U
M222_ Vdd W1_af_53_6 #fb559# Vdd pmos W=0.1625U L=0.13U
M223_keeper Vdd GND #558 Vdd pmos W=0.0975U L=0.26U
M224_ Vdd W1_at_54_6 #fb562# Vdd pmos W=0.1625U L=0.13U
M225_keeper Vdd GND #560 Vdd pmos W=0.0975U L=0.26U
M226_ Vdd W1_af_54_6 #fb564# Vdd pmos W=0.1625U L=0.13U
M227_keeper Vdd GND #563 Vdd pmos W=0.0975U L=0.26U
M228_ Vdd W1_at_55_6 #fb567# Vdd pmos W=0.1625U L=0.13U
M229_keeper Vdd GND #565 Vdd pmos W=0.0975U L=0.26U
M230_ Vdd W1_af_55_6 #fb569# Vdd pmos W=0.1625U L=0.13U
M231_keeper Vdd GND #568 Vdd pmos W=0.0975U L=0.26U
M232_ Vdd W1_at_56_6 #fb572# Vdd pmos W=0.1625U L=0.13U
M233_keeper Vdd GND #570 Vdd pmos W=0.0975U L=0.26U
M234_ Vdd W1_af_56_6 #fb574# Vdd pmos W=0.1625U L=0.13U
M235_keeper Vdd GND #573 Vdd pmos W=0.0975U L=0.26U
M236_ Vdd W1_at_57_6 #fb577# Vdd pmos W=0.1625U L=0.13U
M237_keeper Vdd GND #575 Vdd pmos W=0.0975U L=0.26U
M238_ Vdd W1_af_57_6 #fb579# Vdd pmos W=0.1625U L=0.13U
M239_keeper Vdd GND #578 Vdd pmos W=0.0975U L=0.26U
M240_ Vdd W1_at_50_6 #fb582# Vdd pmos W=0.1625U L=0.13U
M241_keeper Vdd GND #580 Vdd pmos W=0.0975U L=0.26U
M242_ Vdd W1_af_50_6 #fb585# Vdd pmos W=0.1625U L=0.13U
M243_keeper Vdd GND #583 Vdd pmos W=0.0975U L=0.26U
M244_ Vdd W2_at_51_6 #fb588# Vdd pmos W=0.1625U L=0.13U
M245_keeper Vdd GND #586 Vdd pmos W=0.0975U L=0.26U
M246_ Vdd W2_af_51_6 #fb590# Vdd pmos W=0.1625U L=0.13U
M247_keeper Vdd GND #589 Vdd pmos W=0.0975U L=0.26U
M248_ Vdd W2_at_52_6 #fb593# Vdd pmos W=0.1625U L=0.13U
M249_keeper Vdd GND #591 Vdd pmos W=0.0975U L=0.26U
M250_ Vdd W2_af_52_6 #fb595# Vdd pmos W=0.1625U L=0.13U
M251_keeper Vdd GND #594 Vdd pmos W=0.0975U L=0.26U
M252_ Vdd W2_at_53_6 #fb598# Vdd pmos W=0.1625U L=0.13U
M253_keeper Vdd GND #596 Vdd pmos W=0.0975U L=0.26U
M254_ Vdd W2_af_53_6 #fb600# Vdd pmos W=0.1625U L=0.13U
M255_keeper Vdd GND #599 Vdd pmos W=0.0975U L=0.26U
M256_ Vdd W2_at_54_6 #fb603# Vdd pmos W=0.1625U L=0.13U
M257_keeper Vdd GND #601 Vdd pmos W=0.0975U L=0.26U
M258_ Vdd W2_af_54_6 #fb605# Vdd pmos W=0.1625U L=0.13U
M259_keeper Vdd GND #604 Vdd pmos W=0.0975U L=0.26U
M260_ Vdd W2_at_55_6 #fb608# Vdd pmos W=0.1625U L=0.13U
M261_keeper Vdd GND #606 Vdd pmos W=0.0975U L=0.26U
M262_ Vdd W2_af_55_6 #fb610# Vdd pmos W=0.1625U L=0.13U
M263_keeper Vdd GND #609 Vdd pmos W=0.0975U L=0.26U
M264_ Vdd W2_at_56_6 #fb613# Vdd pmos W=0.1625U L=0.13U
M265_keeper Vdd GND #611 Vdd pmos W=0.0975U L=0.26U
M266_ Vdd W2_af_56_6 #fb615# Vdd pmos W=0.1625U L=0.13U
M267_keeper Vdd GND #614 Vdd pmos W=0.0975U L=0.26U
M268_ Vdd W2_at_57_6 #fb618# Vdd pmos W=0.1625U L=0.13U
M269_keeper Vdd GND #616 Vdd pmos W=0.0975U L=0.26U
M270_ Vdd W2_af_57_6 #fb620# Vdd pmos W=0.1625U L=0.13U
M271_keeper Vdd GND #619 Vdd pmos W=0.0975U L=0.26U
M272_ Vdd W2_at_50_6 #fb623# Vdd pmos W=0.1625U L=0.13U
M273_keeper Vdd GND #621 Vdd pmos W=0.0975U L=0.26U
M274_ Vdd W2_af_50_6 #fb626# Vdd pmos W=0.1625U L=0.13U
M275_keeper Vdd GND #624 Vdd pmos W=0.0975U L=0.26U
M276_ Vdd W3_at_51_6 #fb629# Vdd pmos W=0.1625U L=0.13U
M277_keeper Vdd GND #627 Vdd pmos W=0.0975U L=0.26U
M278_ Vdd W3_af_51_6 #fb631# Vdd pmos W=0.1625U L=0.13U
M279_keeper Vdd GND #630 Vdd pmos W=0.0975U L=0.26U
M280_ Vdd W3_at_52_6 #fb634# Vdd pmos W=0.1625U L=0.13U
M281_keeper Vdd GND #632 Vdd pmos W=0.0975U L=0.26U
M282_ Vdd W3_af_52_6 #fb636# Vdd pmos W=0.1625U L=0.13U
M283_keeper Vdd GND #635 Vdd pmos W=0.0975U L=0.26U
M284_ Vdd W3_at_53_6 #fb639# Vdd pmos W=0.1625U L=0.13U
M285_keeper Vdd GND #637 Vdd pmos W=0.0975U L=0.26U
M286_ Vdd W3_af_53_6 #fb641# Vdd pmos W=0.1625U L=0.13U
M287_keeper Vdd GND #640 Vdd pmos W=0.0975U L=0.26U
M288_ Vdd W3_at_54_6 #fb644# Vdd pmos W=0.1625U L=0.13U
M289_keeper Vdd GND #642 Vdd pmos W=0.0975U L=0.26U
M290_ Vdd W3_af_54_6 #fb646# Vdd pmos W=0.1625U L=0.13U
M291_keeper Vdd GND #645 Vdd pmos W=0.0975U L=0.26U
M292_ Vdd W3_at_55_6 #fb649# Vdd pmos W=0.1625U L=0.13U
M293_keeper Vdd GND #647 Vdd pmos W=0.0975U L=0.26U
M294_ Vdd W3_af_55_6 #fb651# Vdd pmos W=0.1625U L=0.13U
M295_keeper Vdd GND #650 Vdd pmos W=0.0975U L=0.26U
M296_ Vdd W3_at_56_6 #fb654# Vdd pmos W=0.1625U L=0.13U
M297_keeper Vdd GND #652 Vdd pmos W=0.0975U L=0.26U
M298_ Vdd W3_af_56_6 #fb656# Vdd pmos W=0.1625U L=0.13U
M299_keeper Vdd GND #655 Vdd pmos W=0.0975U L=0.26U
M300_ Vdd W3_at_57_6 #fb659# Vdd pmos W=0.1625U L=0.13U
M301_keeper Vdd GND #657 Vdd pmos W=0.0975U L=0.26U
M302_ Vdd W3_af_57_6 #fb661# Vdd pmos W=0.1625U L=0.13U
M303_keeper Vdd GND #660 Vdd pmos W=0.0975U L=0.26U
M304_ Vdd W3_at_50_6 #fb664# Vdd pmos W=0.1625U L=0.13U
M305_keeper Vdd GND #662 Vdd pmos W=0.0975U L=0.26U
M306_ Vdd W3_af_50_6 #fb667# Vdd pmos W=0.1625U L=0.13U
M307_keeper Vdd GND #665 Vdd pmos W=0.0975U L=0.26U
M308_ Vdd Ch_at_50_6 #fb670# Vdd pmos W=0.1625U L=0.13U
M309_keeper Vdd GND #668 Vdd pmos W=0.0975U L=0.26U
M310_ Vdd Ch_af_50_6 #fb673# Vdd pmos W=0.1625U L=0.13U
M311_keeper Vdd GND #671 Vdd pmos W=0.0975U L=0.26U
M312_ Vdd Ch_at_51_6 #fb676# Vdd pmos W=0.1625U L=0.13U
M313_keeper Vdd GND #674 Vdd pmos W=0.0975U L=0.26U
M314_ Vdd Ch_af_51_6 #fb679# Vdd pmos W=0.1625U L=0.13U
M315_keeper Vdd GND #677 Vdd pmos W=0.0975U L=0.26U
M316_ Vdd Ch_at_52_6 #fb682# Vdd pmos W=0.1625U L=0.13U
M317_keeper Vdd GND #680 Vdd pmos W=0.0975U L=0.26U
M318_ Vdd Ch_af_52_6 #fb685# Vdd pmos W=0.1625U L=0.13U
M319_keeper Vdd GND #683 Vdd pmos W=0.0975U L=0.26U
M320_ Vdd Ch_at_53_6 #fb688# Vdd pmos W=0.1625U L=0.13U
M321_keeper Vdd GND #686 Vdd pmos W=0.0975U L=0.26U
M322_ Vdd Ch_af_53_6 #fb691# Vdd pmos W=0.1625U L=0.13U
M323_keeper Vdd GND #689 Vdd pmos W=0.0975U L=0.26U
M324_keeper Vdd GND #692 Vdd pmos W=0.0975U L=0.26U
M325_ GND A_areq #7 GND nmos W=0.0975U L=0.065U
M326_ GND __s #37 GND nmos W=0.0975U L=0.065U
M327_ GND reset p1 GND nmos W=0.0975U L=0.065U
M328_ GND __it_53_6 #73 GND nmos W=0.0975U L=0.065U
M329_ GND k __ia GND nmos W=0.0975U L=0.065U
M330_ GND Od0_aa #79 GND nmos W=0.0975U L=0.065U
M331_ GND W0_aa #97 GND nmos W=0.0975U L=0.065U
M332_ GND __p1 #105 GND nmos W=0.0975U L=0.065U
M333_ GND reset A_aa GND nmos W=0.0975U L=0.065U
M334_ GND reset Od0_at_50_6 GND nmos W=0.0975U L=0.065U
M335_ GND I_aa Od0_af_50_6 GND nmos W=0.0975U L=0.065U
M336_ GND reset Od0_af_50_6 GND nmos W=0.0975U L=0.065U
M337_ GND reset Od0_at_51_6 GND nmos W=0.0975U L=0.065U
M338_ GND I_aa Od0_af_51_6 GND nmos W=0.0975U L=0.065U
M339_ GND reset Od0_af_51_6 GND nmos W=0.0975U L=0.065U
M340_ GND reset Od0_at_52_6 GND nmos W=0.0975U L=0.065U
M341_ GND I_aa Od0_af_52_6 GND nmos W=0.0975U L=0.065U
M342_ GND reset Od0_af_52_6 GND nmos W=0.0975U L=0.065U
M343_ GND reset Od0_at_53_6 GND nmos W=0.0975U L=0.065U
M344_ GND I_aa Od0_af_53_6 GND nmos W=0.0975U L=0.065U
M345_ GND reset Od0_af_53_6 GND nmos W=0.0975U L=0.065U
M346_ GND reset Od1_at_50_6 GND nmos W=0.0975U L=0.065U
M347_ GND I_aa Od1_af_50_6 GND nmos W=0.0975U L=0.065U
M348_ GND reset Od1_af_50_6 GND nmos W=0.0975U L=0.065U
M349_ GND reset Od1_at_51_6 GND nmos W=0.0975U L=0.065U
M350_ GND I_aa Od1_af_51_6 GND nmos W=0.0975U L=0.065U
M351_ GND reset Od1_af_51_6 GND nmos W=0.0975U L=0.065U
M352_ GND reset Od1_at_52_6 GND nmos W=0.0975U L=0.065U
M353_ GND I_aa Od1_af_52_6 GND nmos W=0.0975U L=0.065U
M354_ GND reset Od1_af_52_6 GND nmos W=0.0975U L=0.065U
M355_ GND reset Od1_at_53_6 GND nmos W=0.0975U L=0.065U
M356_ GND I_aa Od1_af_53_6 GND nmos W=0.0975U L=0.065U
M357_ GND reset Od1_af_53_6 GND nmos W=0.0975U L=0.065U
M358_ GND reset Od2_at_50_6 GND nmos W=0.0975U L=0.065U
M359_ GND I_aa Od2_af_50_6 GND nmos W=0.0975U L=0.065U
M360_ GND reset Od2_af_50_6 GND nmos W=0.0975U L=0.065U
M361_ GND reset Od2_at_51_6 GND nmos W=0.0975U L=0.065U
M362_ GND I_aa Od2_af_51_6 GND nmos W=0.0975U L=0.065U
M363_ GND reset Od2_af_51_6 GND nmos W=0.0975U L=0.065U
M364_ GND reset Od2_at_52_6 GND nmos W=0.0975U L=0.065U
M365_ GND I_aa Od2_af_52_6 GND nmos W=0.0975U L=0.065U
M366_ GND reset Od2_af_52_6 GND nmos W=0.0975U L=0.065U
M367_ GND reset Od2_at_53_6 GND nmos W=0.0975U L=0.065U
M368_ GND I_aa Od2_af_53_6 GND nmos W=0.0975U L=0.065U
M369_ GND reset Od2_af_53_6 GND nmos W=0.0975U L=0.065U
M370_ GND reset Od3_at_50_6 GND nmos W=0.0975U L=0.065U
M371_ GND I_aa Od3_af_50_6 GND nmos W=0.0975U L=0.065U
M372_ GND reset Od3_af_50_6 GND nmos W=0.0975U L=0.065U
M373_ GND reset Od3_at_51_6 GND nmos W=0.0975U L=0.065U
M374_ GND I_aa Od3_af_51_6 GND nmos W=0.0975U L=0.065U
M375_ GND reset Od3_af_51_6 GND nmos W=0.0975U L=0.065U
M376_ GND reset Od3_at_52_6 GND nmos W=0.0975U L=0.065U
M377_ GND I_aa Od3_af_52_6 GND nmos W=0.0975U L=0.065U
M378_ GND reset Od3_af_52_6 GND nmos W=0.0975U L=0.065U
M379_ GND reset Od3_at_53_6 GND nmos W=0.0975U L=0.065U
M380_ GND I_aa Od3_af_53_6 GND nmos W=0.0975U L=0.065U
M381_ GND reset Od3_af_53_6 GND nmos W=0.0975U L=0.065U
M382_ GND A_aa #159 GND nmos W=0.0975U L=0.065U
M383_ GND reset b_50_6 GND nmos W=0.0975U L=0.065U
M384_ GND A_aa #163 GND nmos W=0.0975U L=0.065U
M385_ GND reset b_51_6 GND nmos W=0.0975U L=0.065U
M386_ GND A_aa #167 GND nmos W=0.0975U L=0.065U
M387_ GND reset b_52_6 GND nmos W=0.0975U L=0.065U
M388_ GND A_aa #171 GND nmos W=0.0975U L=0.065U
M389_ GND reset b_53_6 GND nmos W=0.0975U L=0.065U
M390_ GND reset W0_at_51_6 GND nmos W=0.0975U L=0.065U
M391_ GND __s W0_af_51_6 GND nmos W=0.0975U L=0.065U
M392_ GND reset W0_af_51_6 GND nmos W=0.0975U L=0.065U
M393_ GND reset W0_at_52_6 GND nmos W=0.0975U L=0.065U
M394_ GND __s W0_af_52_6 GND nmos W=0.0975U L=0.065U
M395_ GND reset W0_af_52_6 GND nmos W=0.0975U L=0.065U
M396_ GND reset W0_at_53_6 GND nmos W=0.0975U L=0.065U
M397_ GND __s W0_af_53_6 GND nmos W=0.0975U L=0.065U
M398_ GND reset W0_af_53_6 GND nmos W=0.0975U L=0.065U
M399_ GND reset W0_at_54_6 GND nmos W=0.0975U L=0.065U
M400_ GND __s W0_af_54_6 GND nmos W=0.0975U L=0.065U
M401_ GND reset W0_af_54_6 GND nmos W=0.0975U L=0.065U
M402_ GND reset W0_at_55_6 GND nmos W=0.0975U L=0.065U
M403_ GND __s W0_af_55_6 GND nmos W=0.0975U L=0.065U
M404_ GND reset W0_af_55_6 GND nmos W=0.0975U L=0.065U
M405_ GND reset W0_at_56_6 GND nmos W=0.0975U L=0.065U
M406_ GND __s W0_af_56_6 GND nmos W=0.0975U L=0.065U
M407_ GND reset W0_af_56_6 GND nmos W=0.0975U L=0.065U
M408_ GND reset W0_at_57_6 GND nmos W=0.0975U L=0.065U
M409_ GND __s W0_af_57_6 GND nmos W=0.0975U L=0.065U
M410_ GND reset W0_af_57_6 GND nmos W=0.0975U L=0.065U
M411_ GND __s W0_at_50_6 GND nmos W=0.0975U L=0.065U
M412_ GND reset W0_at_50_6 GND nmos W=0.0975U L=0.065U
M413_ GND __s W0_af_50_6 GND nmos W=0.0975U L=0.065U
M414_ GND reset W0_af_50_6 GND nmos W=0.0975U L=0.065U
M415_ GND reset W1_at_51_6 GND nmos W=0.0975U L=0.065U
M416_ GND __s W1_af_51_6 GND nmos W=0.0975U L=0.065U
M417_ GND reset W1_af_51_6 GND nmos W=0.0975U L=0.065U
M418_ GND reset W1_at_52_6 GND nmos W=0.0975U L=0.065U
M419_ GND __s W1_af_52_6 GND nmos W=0.0975U L=0.065U
M420_ GND reset W1_af_52_6 GND nmos W=0.0975U L=0.065U
M421_ GND reset W1_at_53_6 GND nmos W=0.0975U L=0.065U
M422_ GND __s W1_af_53_6 GND nmos W=0.0975U L=0.065U
M423_ GND reset W1_af_53_6 GND nmos W=0.0975U L=0.065U
M424_ GND reset W1_at_54_6 GND nmos W=0.0975U L=0.065U
M425_ GND __s W1_af_54_6 GND nmos W=0.0975U L=0.065U
M426_ GND reset W1_af_54_6 GND nmos W=0.0975U L=0.065U
M427_ GND reset W1_at_55_6 GND nmos W=0.0975U L=0.065U
M428_ GND __s W1_af_55_6 GND nmos W=0.0975U L=0.065U
M429_ GND reset W1_af_55_6 GND nmos W=0.0975U L=0.065U
M430_ GND reset W1_at_56_6 GND nmos W=0.0975U L=0.065U
M431_ GND __s W1_af_56_6 GND nmos W=0.0975U L=0.065U
M432_ GND reset W1_af_56_6 GND nmos W=0.0975U L=0.065U
M433_ GND reset W1_at_57_6 GND nmos W=0.0975U L=0.065U
M434_ GND __s W1_af_57_6 GND nmos W=0.0975U L=0.065U
M435_ GND reset W1_af_57_6 GND nmos W=0.0975U L=0.065U
M436_ GND __s W1_at_50_6 GND nmos W=0.0975U L=0.065U
M437_ GND reset W1_at_50_6 GND nmos W=0.0975U L=0.065U
M438_ GND __s W1_af_50_6 GND nmos W=0.0975U L=0.065U
M439_ GND reset W1_af_50_6 GND nmos W=0.0975U L=0.065U
M440_ GND reset W2_at_51_6 GND nmos W=0.0975U L=0.065U
M441_ GND __s W2_af_51_6 GND nmos W=0.0975U L=0.065U
M442_ GND reset W2_af_51_6 GND nmos W=0.0975U L=0.065U
M443_ GND reset W2_at_52_6 GND nmos W=0.0975U L=0.065U
M444_ GND __s W2_af_52_6 GND nmos W=0.0975U L=0.065U
M445_ GND reset W2_af_52_6 GND nmos W=0.0975U L=0.065U
M446_ GND reset W2_at_53_6 GND nmos W=0.0975U L=0.065U
M447_ GND __s W2_af_53_6 GND nmos W=0.0975U L=0.065U
M448_ GND reset W2_af_53_6 GND nmos W=0.0975U L=0.065U
M449_ GND reset W2_at_54_6 GND nmos W=0.0975U L=0.065U
M450_ GND __s W2_af_54_6 GND nmos W=0.0975U L=0.065U
M451_ GND reset W2_af_54_6 GND nmos W=0.0975U L=0.065U
M452_ GND reset W2_at_55_6 GND nmos W=0.0975U L=0.065U
M453_ GND __s W2_af_55_6 GND nmos W=0.0975U L=0.065U
M454_ GND reset W2_af_55_6 GND nmos W=0.0975U L=0.065U
M455_ GND reset W2_at_56_6 GND nmos W=0.0975U L=0.065U
M456_ GND __s W2_af_56_6 GND nmos W=0.0975U L=0.065U
M457_ GND reset W2_af_56_6 GND nmos W=0.0975U L=0.065U
M458_ GND reset W2_at_57_6 GND nmos W=0.0975U L=0.065U
M459_ GND __s W2_af_57_6 GND nmos W=0.0975U L=0.065U
M460_ GND reset W2_af_57_6 GND nmos W=0.0975U L=0.065U
M461_ GND __s W2_at_50_6 GND nmos W=0.0975U L=0.065U
M462_ GND reset W2_at_50_6 GND nmos W=0.0975U L=0.065U
M463_ GND __s W2_af_50_6 GND nmos W=0.0975U L=0.065U
M464_ GND reset W2_af_50_6 GND nmos W=0.0975U L=0.065U
M465_ GND reset W3_at_51_6 GND nmos W=0.0975U L=0.065U
M466_ GND __s W3_af_51_6 GND nmos W=0.0975U L=0.065U
M467_ GND reset W3_af_51_6 GND nmos W=0.0975U L=0.065U
M468_ GND reset W3_at_52_6 GND nmos W=0.0975U L=0.065U
M469_ GND __s W3_af_52_6 GND nmos W=0.0975U L=0.065U
M470_ GND reset W3_af_52_6 GND nmos W=0.0975U L=0.065U
M471_ GND reset W3_at_53_6 GND nmos W=0.0975U L=0.065U
M472_ GND __s W3_af_53_6 GND nmos W=0.0975U L=0.065U
M473_ GND reset W3_af_53_6 GND nmos W=0.0975U L=0.065U
M474_ GND reset W3_at_54_6 GND nmos W=0.0975U L=0.065U
M475_ GND __s W3_af_54_6 GND nmos W=0.0975U L=0.065U
M476_ GND reset W3_af_54_6 GND nmos W=0.0975U L=0.065U
M477_ GND reset W3_at_55_6 GND nmos W=0.0975U L=0.065U
M478_ GND __s W3_af_55_6 GND nmos W=0.0975U L=0.065U
M479_ GND reset W3_af_55_6 GND nmos W=0.0975U L=0.065U
M480_ GND reset W3_at_56_6 GND nmos W=0.0975U L=0.065U
M481_ GND __s W3_af_56_6 GND nmos W=0.0975U L=0.065U
M482_ GND reset W3_af_56_6 GND nmos W=0.0975U L=0.065U
M483_ GND reset W3_at_57_6 GND nmos W=0.0975U L=0.065U
M484_ GND __s W3_af_57_6 GND nmos W=0.0975U L=0.065U
M485_ GND reset W3_af_57_6 GND nmos W=0.0975U L=0.065U
M486_ GND __s W3_at_50_6 GND nmos W=0.0975U L=0.065U
M487_ GND reset W3_at_50_6 GND nmos W=0.0975U L=0.065U
M488_ GND __s W3_af_50_6 GND nmos W=0.0975U L=0.065U
M489_ GND reset W3_af_50_6 GND nmos W=0.0975U L=0.065U
M490_ GND __s Ch_at_50_6 GND nmos W=0.0975U L=0.065U
M491_ GND reset Ch_at_50_6 GND nmos W=0.0975U L=0.065U
M492_ GND __s Ch_af_50_6 GND nmos W=0.0975U L=0.065U
M493_ GND reset Ch_af_50_6 GND nmos W=0.0975U L=0.065U
M494_ GND __s Ch_at_51_6 GND nmos W=0.0975U L=0.065U
M495_ GND reset Ch_at_51_6 GND nmos W=0.0975U L=0.065U
M496_ GND __s Ch_af_51_6 GND nmos W=0.0975U L=0.065U
M497_ GND reset Ch_af_51_6 GND nmos W=0.0975U L=0.065U
M498_ GND __s Ch_at_52_6 GND nmos W=0.0975U L=0.065U
M499_ GND reset Ch_at_52_6 GND nmos W=0.0975U L=0.065U
M500_ GND __s Ch_af_52_6 GND nmos W=0.0975U L=0.065U
M501_ GND reset Ch_af_52_6 GND nmos W=0.0975U L=0.065U
M502_ GND __s Ch_at_53_6 GND nmos W=0.0975U L=0.065U
M503_ GND reset Ch_at_53_6 GND nmos W=0.0975U L=0.065U
M504_ GND __s Ch_af_53_6 GND nmos W=0.0975U L=0.065U
M505_ GND reset Ch_af_53_6 GND nmos W=0.0975U L=0.065U
M506_ GND s __s GND nmos W=0.0975U L=0.065U
M507_ GND reset __r GND nmos W=0.0975U L=0.065U
M508_ GND A_areq __ar GND nmos W=0.0975U L=0.065U
M509_ GND p1 __p1 GND nmos W=0.0975U L=0.065U
M510_ GND A_aa __aa GND nmos W=0.0975U L=0.065U
M511_ GND b_50_6 __b_50_6 GND nmos W=0.0975U L=0.065U
M512_ GND I_at_50_6 __it_50_6 GND nmos W=0.0975U L=0.065U
M513_ GND I_af_50_6 __if_50_6 GND nmos W=0.0975U L=0.065U
M514_ GND b_51_6 __b_51_6 GND nmos W=0.0975U L=0.065U
M515_ GND I_at_51_6 __it_51_6 GND nmos W=0.0975U L=0.065U
M516_ GND I_af_51_6 __if_51_6 GND nmos W=0.0975U L=0.065U
M517_ GND b_52_6 __b_52_6 GND nmos W=0.0975U L=0.065U
M518_ GND I_at_52_6 __it_52_6 GND nmos W=0.0975U L=0.065U
M519_ GND I_af_52_6 __if_52_6 GND nmos W=0.0975U L=0.065U
M520_ GND b_53_6 __b_53_6 GND nmos W=0.0975U L=0.065U
M521_ GND I_at_53_6 __it_53_6 GND nmos W=0.0975U L=0.065U
M522_ GND I_af_53_6 __if_53_6 GND nmos W=0.0975U L=0.065U
M523_ GND W0_aa __wa_50_6 GND nmos W=0.0975U L=0.065U
M524_ GND W1_aa __wa_51_6 GND nmos W=0.0975U L=0.065U
M525_ GND W2_aa __wa_52_6 GND nmos W=0.0975U L=0.065U
M526_ GND W3_aa __wa_53_6 GND nmos W=0.0975U L=0.065U
M527_ GND Ch_aa __cha GND nmos W=0.0975U L=0.065U
M528_ GND __p0 p0 GND nmos W=0.0975U L=0.065U
M529_ GND __ia I_aa GND nmos W=0.0975U L=0.065U
M530_ GND __p0 #fb396# GND nmos W=0.0975U L=0.13U
M531_ GND __ia #fb399# GND nmos W=0.0975U L=0.13U
M532_keeper GND Vdd #398 GND nmos W=0.0975U L=4.615U
M533_ GND p1 #fb402# GND nmos W=0.0975U L=0.13U
M534_keeper GND Vdd #401 GND nmos W=0.0975U L=5.395U
M535_ GND k #fb405# GND nmos W=0.0975U L=0.13U
M536_keeper GND Vdd #404 GND nmos W=0.0975U L=2.275U
M537_ GND b_53_6 #fb408# GND nmos W=0.0975U L=0.13U
M538_keeper GND Vdd #407 GND nmos W=0.0975U L=6.955U
M539_ GND b_52_6 #fb411# GND nmos W=0.0975U L=0.13U
M540_keeper GND Vdd #410 GND nmos W=0.0975U L=2.275U
M541_ GND b_51_6 #fb414# GND nmos W=0.0975U L=0.13U
M542_keeper GND Vdd #413 GND nmos W=0.0975U L=2.275U
M543_ GND b_50_6 #fb417# GND nmos W=0.0975U L=0.13U
M544_keeper GND Vdd #416 GND nmos W=0.0975U L=2.275U
M545_ GND A_aa #fb420# GND nmos W=0.0975U L=0.13U
M546_keeper GND Vdd #419 GND nmos W=0.0975U L=2.275U
M547_ GND s #fb423# GND nmos W=0.0975U L=0.13U
M548_keeper GND Vdd #422 GND nmos W=0.0975U L=2.275U
M549_ GND Od0_at_50_6 #fb426# GND nmos W=0.0975U L=0.13U
M550_keeper GND #fb426# Od0_at_50_6 GND nmos W=0.0975U L=0.065U
M551_ GND Od0_af_50_6 #fb428# GND nmos W=0.0975U L=0.13U
M552_keeper GND Vdd #425 GND nmos W=0.0975U L=4.615U
M553_ GND Od0_at_51_6 #fb431# GND nmos W=0.0975U L=0.13U
M554_keeper GND #fb431# Od0_at_51_6 GND nmos W=0.0975U L=0.065U
M555_ GND Od0_af_51_6 #fb433# GND nmos W=0.0975U L=0.13U
M556_keeper GND Vdd #430 GND nmos W=0.0975U L=1.495U
M557_ GND Od0_at_52_6 #fb436# GND nmos W=0.0975U L=0.13U
M558_keeper GND #fb436# Od0_at_52_6 GND nmos W=0.0975U L=0.065U
M559_ GND Od0_af_52_6 #fb438# GND nmos W=0.0975U L=0.13U
M560_keeper GND Vdd #435 GND nmos W=0.0975U L=1.495U
M561_ GND Od0_at_53_6 #fb441# GND nmos W=0.0975U L=0.13U
M562_keeper GND #fb441# Od0_at_53_6 GND nmos W=0.0975U L=0.065U
M563_ GND Od0_af_53_6 #fb443# GND nmos W=0.0975U L=0.13U
M564_keeper GND Vdd #440 GND nmos W=0.0975U L=1.495U
M565_ GND Od1_at_50_6 #fb446# GND nmos W=0.0975U L=0.13U
M566_keeper GND #fb446# Od1_at_50_6 GND nmos W=0.0975U L=0.065U
M567_ GND Od1_af_50_6 #fb448# GND nmos W=0.0975U L=0.13U
M568_keeper GND Vdd #445 GND nmos W=0.0975U L=1.495U
M569_ GND Od1_at_51_6 #fb451# GND nmos W=0.0975U L=0.13U
M570_keeper GND #fb451# Od1_at_51_6 GND nmos W=0.0975U L=0.065U
M571_ GND Od1_af_51_6 #fb453# GND nmos W=0.0975U L=0.13U
M572_keeper GND Vdd #450 GND nmos W=0.0975U L=1.495U
M573_ GND Od1_at_52_6 #fb456# GND nmos W=0.0975U L=0.13U
M574_keeper GND #fb456# Od1_at_52_6 GND nmos W=0.0975U L=0.065U
M575_ GND Od1_af_52_6 #fb458# GND nmos W=0.0975U L=0.13U
M576_keeper GND Vdd #455 GND nmos W=0.0975U L=1.495U
M577_ GND Od1_at_53_6 #fb461# GND nmos W=0.0975U L=0.13U
M578_keeper GND #fb461# Od1_at_53_6 GND nmos W=0.0975U L=0.065U
M579_ GND Od1_af_53_6 #fb463# GND nmos W=0.0975U L=0.13U
M580_keeper GND Vdd #460 GND nmos W=0.0975U L=1.495U
M581_ GND Od2_at_50_6 #fb466# GND nmos W=0.0975U L=0.13U
M582_keeper GND #fb466# Od2_at_50_6 GND nmos W=0.0975U L=0.065U
M583_ GND Od2_af_50_6 #fb468# GND nmos W=0.0975U L=0.13U
M584_keeper GND Vdd #465 GND nmos W=0.0975U L=1.495U
M585_ GND Od2_at_51_6 #fb471# GND nmos W=0.0975U L=0.13U
M586_keeper GND #fb471# Od2_at_51_6 GND nmos W=0.0975U L=0.065U
M587_ GND Od2_af_51_6 #fb473# GND nmos W=0.0975U L=0.13U
M588_keeper GND Vdd #470 GND nmos W=0.0975U L=1.495U
M589_ GND Od2_at_52_6 #fb476# GND nmos W=0.0975U L=0.13U
M590_keeper GND #fb476# Od2_at_52_6 GND nmos W=0.0975U L=0.065U
M591_ GND Od2_af_52_6 #fb478# GND nmos W=0.0975U L=0.13U
M592_keeper GND Vdd #475 GND nmos W=0.0975U L=1.495U
M593_ GND Od2_at_53_6 #fb481# GND nmos W=0.0975U L=0.13U
M594_keeper GND #fb481# Od2_at_53_6 GND nmos W=0.0975U L=0.065U
M595_ GND Od2_af_53_6 #fb483# GND nmos W=0.0975U L=0.13U
M596_keeper GND Vdd #480 GND nmos W=0.0975U L=1.495U
M597_ GND Od3_at_50_6 #fb486# GND nmos W=0.0975U L=0.13U
M598_keeper GND #fb486# Od3_at_50_6 GND nmos W=0.0975U L=0.065U
M599_ GND Od3_af_50_6 #fb488# GND nmos W=0.0975U L=0.13U
M600_keeper GND Vdd #485 GND nmos W=0.0975U L=1.495U
M601_ GND Od3_at_51_6 #fb491# GND nmos W=0.0975U L=0.13U
M602_keeper GND #fb491# Od3_at_51_6 GND nmos W=0.0975U L=0.065U
M603_ GND Od3_af_51_6 #fb493# GND nmos W=0.0975U L=0.13U
M604_keeper GND Vdd #490 GND nmos W=0.0975U L=1.495U
M605_ GND Od3_at_52_6 #fb496# GND nmos W=0.0975U L=0.13U
M606_keeper GND #fb496# Od3_at_52_6 GND nmos W=0.0975U L=0.065U
M607_ GND Od3_af_52_6 #fb498# GND nmos W=0.0975U L=0.13U
M608_keeper GND Vdd #495 GND nmos W=0.0975U L=1.495U
M609_ GND Od3_at_53_6 #fb501# GND nmos W=0.0975U L=0.13U
M610_keeper GND #fb501# Od3_at_53_6 GND nmos W=0.0975U L=0.065U
M611_ GND Od3_af_53_6 #fb503# GND nmos W=0.0975U L=0.13U
M612_keeper GND Vdd #500 GND nmos W=0.0975U L=1.495U
M613_ GND W0_at_51_6 #fb506# GND nmos W=0.0975U L=0.13U
M614_keeper GND #fb506# W0_at_51_6 GND nmos W=0.0975U L=0.065U
M615_ GND W0_af_51_6 #fb508# GND nmos W=0.0975U L=0.13U
M616_keeper GND Vdd #505 GND nmos W=0.0975U L=1.495U
M617_ GND W0_at_52_6 #fb511# GND nmos W=0.0975U L=0.13U
M618_keeper GND #fb511# W0_at_52_6 GND nmos W=0.0975U L=0.065U
M619_ GND W0_af_52_6 #fb513# GND nmos W=0.0975U L=0.13U
M620_keeper GND Vdd #510 GND nmos W=0.0975U L=3.055U
M621_ GND W0_at_53_6 #fb516# GND nmos W=0.0975U L=0.13U
M622_keeper GND #fb516# W0_at_53_6 GND nmos W=0.0975U L=0.065U
M623_ GND W0_af_53_6 #fb518# GND nmos W=0.0975U L=0.13U
M624_keeper GND Vdd #515 GND nmos W=0.0975U L=3.055U
M625_ GND W0_at_54_6 #fb521# GND nmos W=0.0975U L=0.13U
M626_keeper GND #fb521# W0_at_54_6 GND nmos W=0.0975U L=0.065U
M627_ GND W0_af_54_6 #fb523# GND nmos W=0.0975U L=0.13U
M628_keeper GND Vdd #520 GND nmos W=0.0975U L=3.055U
M629_ GND W0_at_55_6 #fb526# GND nmos W=0.0975U L=0.13U
M630_keeper GND #fb526# W0_at_55_6 GND nmos W=0.0975U L=0.065U
M631_ GND W0_af_55_6 #fb528# GND nmos W=0.0975U L=0.13U
M632_keeper GND Vdd #525 GND nmos W=0.0975U L=3.055U
M633_ GND W0_at_56_6 #fb531# GND nmos W=0.0975U L=0.13U
M634_keeper GND #fb531# W0_at_56_6 GND nmos W=0.0975U L=0.065U
M635_ GND W0_af_56_6 #fb533# GND nmos W=0.0975U L=0.13U
M636_keeper GND Vdd #530 GND nmos W=0.0975U L=3.055U
M637_ GND W0_at_57_6 #fb536# GND nmos W=0.0975U L=0.13U
M638_keeper GND #fb536# W0_at_57_6 GND nmos W=0.0975U L=0.065U
M639_ GND W0_af_57_6 #fb538# GND nmos W=0.0975U L=0.13U
M640_keeper GND Vdd #535 GND nmos W=0.0975U L=3.055U
M641_ GND W0_at_50_6 #fb541# GND nmos W=0.0975U L=0.13U
M642_keeper GND Vdd #540 GND nmos W=0.0975U L=3.055U
M643_ GND W0_af_50_6 #fb544# GND nmos W=0.0975U L=0.13U
M644_keeper GND Vdd #543 GND nmos W=0.0975U L=3.835U
M645_ GND W1_at_51_6 #fb547# GND nmos W=0.0975U L=0.13U
M646_keeper GND #fb547# W1_at_51_6 GND nmos W=0.0975U L=0.065U
M647_ GND W1_af_51_6 #fb549# GND nmos W=0.0975U L=0.13U
M648_keeper GND Vdd #546 GND nmos W=0.0975U L=3.835U
M649_ GND W1_at_52_6 #fb552# GND nmos W=0.0975U L=0.13U
M650_keeper GND #fb552# W1_at_52_6 GND nmos W=0.0975U L=0.065U
M651_ GND W1_af_52_6 #fb554# GND nmos W=0.0975U L=0.13U
M652_keeper GND Vdd #551 GND nmos W=0.0975U L=3.055U
M653_ GND W1_at_53_6 #fb557# GND nmos W=0.0975U L=0.13U
M654_keeper GND #fb557# W1_at_53_6 GND nmos W=0.0975U L=0.065U
M655_ GND W1_af_53_6 #fb559# GND nmos W=0.0975U L=0.13U
M656_keeper GND Vdd #556 GND nmos W=0.0975U L=3.055U
M657_ GND W1_at_54_6 #fb562# GND nmos W=0.0975U L=0.13U
M658_keeper GND #fb562# W1_at_54_6 GND nmos W=0.0975U L=0.065U
M659_ GND W1_af_54_6 #fb564# GND nmos W=0.0975U L=0.13U
M660_keeper GND Vdd #561 GND nmos W=0.0975U L=3.055U
M661_ GND W1_at_55_6 #fb567# GND nmos W=0.0975U L=0.13U
M662_keeper GND #fb567# W1_at_55_6 GND nmos W=0.0975U L=0.065U
M663_ GND W1_af_55_6 #fb569# GND nmos W=0.0975U L=0.13U
M664_keeper GND Vdd #566 GND nmos W=0.0975U L=3.055U
M665_ GND W1_at_56_6 #fb572# GND nmos W=0.0975U L=0.13U
M666_keeper GND #fb572# W1_at_56_6 GND nmos W=0.0975U L=0.065U
M667_ GND W1_af_56_6 #fb574# GND nmos W=0.0975U L=0.13U
M668_keeper GND Vdd #571 GND nmos W=0.0975U L=3.055U
M669_ GND W1_at_57_6 #fb577# GND nmos W=0.0975U L=0.13U
M670_keeper GND #fb577# W1_at_57_6 GND nmos W=0.0975U L=0.065U
M671_ GND W1_af_57_6 #fb579# GND nmos W=0.0975U L=0.13U
M672_keeper GND Vdd #576 GND nmos W=0.0975U L=3.055U
M673_ GND W1_at_50_6 #fb582# GND nmos W=0.0975U L=0.13U
M674_keeper GND Vdd #581 GND nmos W=0.0975U L=3.055U
M675_ GND W1_af_50_6 #fb585# GND nmos W=0.0975U L=0.13U
M676_keeper GND Vdd #584 GND nmos W=0.0975U L=3.835U
M677_ GND W2_at_51_6 #fb588# GND nmos W=0.0975U L=0.13U
M678_keeper GND #fb588# W2_at_51_6 GND nmos W=0.0975U L=0.065U
M679_ GND W2_af_51_6 #fb590# GND nmos W=0.0975U L=0.13U
M680_keeper GND Vdd #587 GND nmos W=0.0975U L=3.835U
M681_ GND W2_at_52_6 #fb593# GND nmos W=0.0975U L=0.13U
M682_keeper GND #fb593# W2_at_52_6 GND nmos W=0.0975U L=0.065U
M683_ GND W2_af_52_6 #fb595# GND nmos W=0.0975U L=0.13U
M684_keeper GND Vdd #592 GND nmos W=0.0975U L=3.055U
M685_ GND W2_at_53_6 #fb598# GND nmos W=0.0975U L=0.13U
M686_keeper GND #fb598# W2_at_53_6 GND nmos W=0.0975U L=0.065U
M687_ GND W2_af_53_6 #fb600# GND nmos W=0.0975U L=0.13U
M688_keeper GND Vdd #597 GND nmos W=0.0975U L=3.055U
M689_ GND W2_at_54_6 #fb603# GND nmos W=0.0975U L=0.13U
M690_keeper GND #fb603# W2_at_54_6 GND nmos W=0.0975U L=0.065U
M691_ GND W2_af_54_6 #fb605# GND nmos W=0.0975U L=0.13U
M692_keeper GND Vdd #602 GND nmos W=0.0975U L=3.055U
M693_ GND W2_at_55_6 #fb608# GND nmos W=0.0975U L=0.13U
M694_keeper GND #fb608# W2_at_55_6 GND nmos W=0.0975U L=0.065U
M695_ GND W2_af_55_6 #fb610# GND nmos W=0.0975U L=0.13U
M696_keeper GND Vdd #607 GND nmos W=0.0975U L=3.055U
M697_ GND W2_at_56_6 #fb613# GND nmos W=0.0975U L=0.13U
M698_keeper GND #fb613# W2_at_56_6 GND nmos W=0.0975U L=0.065U
M699_ GND W2_af_56_6 #fb615# GND nmos W=0.0975U L=0.13U
M700_keeper GND Vdd #612 GND nmos W=0.0975U L=3.055U
M701_ GND W2_at_57_6 #fb618# GND nmos W=0.0975U L=0.13U
M702_keeper GND #fb618# W2_at_57_6 GND nmos W=0.0975U L=0.065U
M703_ GND W2_af_57_6 #fb620# GND nmos W=0.0975U L=0.13U
M704_keeper GND Vdd #617 GND nmos W=0.0975U L=3.055U
M705_ GND W2_at_50_6 #fb623# GND nmos W=0.0975U L=0.13U
M706_keeper GND Vdd #622 GND nmos W=0.0975U L=3.055U
M707_ GND W2_af_50_6 #fb626# GND nmos W=0.0975U L=0.13U
M708_keeper GND Vdd #625 GND nmos W=0.0975U L=3.835U
M709_ GND W3_at_51_6 #fb629# GND nmos W=0.0975U L=0.13U
M710_keeper GND #fb629# W3_at_51_6 GND nmos W=0.0975U L=0.065U
M711_ GND W3_af_51_6 #fb631# GND nmos W=0.0975U L=0.13U
M712_keeper GND Vdd #628 GND nmos W=0.0975U L=3.835U
M713_ GND W3_at_52_6 #fb634# GND nmos W=0.0975U L=0.13U
M714_keeper GND #fb634# W3_at_52_6 GND nmos W=0.0975U L=0.065U
M715_ GND W3_af_52_6 #fb636# GND nmos W=0.0975U L=0.13U
M716_keeper GND Vdd #633 GND nmos W=0.0975U L=3.055U
M717_ GND W3_at_53_6 #fb639# GND nmos W=0.0975U L=0.13U
M718_keeper GND #fb639# W3_at_53_6 GND nmos W=0.0975U L=0.065U
M719_ GND W3_af_53_6 #fb641# GND nmos W=0.0975U L=0.13U
M720_keeper GND Vdd #638 GND nmos W=0.0975U L=3.055U
M721_ GND W3_at_54_6 #fb644# GND nmos W=0.0975U L=0.13U
M722_keeper GND #fb644# W3_at_54_6 GND nmos W=0.0975U L=0.065U
M723_ GND W3_af_54_6 #fb646# GND nmos W=0.0975U L=0.13U
M724_keeper GND Vdd #643 GND nmos W=0.0975U L=3.055U
M725_ GND W3_at_55_6 #fb649# GND nmos W=0.0975U L=0.13U
M726_keeper GND #fb649# W3_at_55_6 GND nmos W=0.0975U L=0.065U
M727_ GND W3_af_55_6 #fb651# GND nmos W=0.0975U L=0.13U
M728_keeper GND Vdd #648 GND nmos W=0.0975U L=3.055U
M729_ GND W3_at_56_6 #fb654# GND nmos W=0.0975U L=0.13U
M730_keeper GND #fb654# W3_at_56_6 GND nmos W=0.0975U L=0.065U
M731_ GND W3_af_56_6 #fb656# GND nmos W=0.0975U L=0.13U
M732_keeper GND Vdd #653 GND nmos W=0.0975U L=3.055U
M733_ GND W3_at_57_6 #fb659# GND nmos W=0.0975U L=0.13U
M734_keeper GND #fb659# W3_at_57_6 GND nmos W=0.0975U L=0.065U
M735_ GND W3_af_57_6 #fb661# GND nmos W=0.0975U L=0.13U
M736_keeper GND Vdd #658 GND nmos W=0.0975U L=3.055U
M737_ GND W3_at_50_6 #fb664# GND nmos W=0.0975U L=0.13U
M738_keeper GND Vdd #663 GND nmos W=0.0975U L=3.055U
M739_ GND W3_af_50_6 #fb667# GND nmos W=0.0975U L=0.13U
M740_keeper GND Vdd #666 GND nmos W=0.0975U L=3.835U
M741_ GND Ch_at_50_6 #fb670# GND nmos W=0.0975U L=0.13U
M742_keeper GND Vdd #669 GND nmos W=0.0975U L=3.835U
M743_ GND Ch_af_50_6 #fb673# GND nmos W=0.0975U L=0.13U
M744_keeper GND Vdd #672 GND nmos W=0.0975U L=3.835U
M745_ GND Ch_at_51_6 #fb676# GND nmos W=0.0975U L=0.13U
M746_keeper GND Vdd #675 GND nmos W=0.0975U L=3.835U
M747_ GND Ch_af_51_6 #fb679# GND nmos W=0.0975U L=0.13U
M748_keeper GND Vdd #678 GND nmos W=0.0975U L=3.835U
M749_ GND Ch_at_52_6 #fb682# GND nmos W=0.0975U L=0.13U
M750_keeper GND Vdd #681 GND nmos W=0.0975U L=3.835U
M751_ GND Ch_af_52_6 #fb685# GND nmos W=0.0975U L=0.13U
M752_keeper GND Vdd #684 GND nmos W=0.0975U L=3.835U
M753_ GND Ch_at_53_6 #fb688# GND nmos W=0.0975U L=0.13U
M754_keeper GND Vdd #687 GND nmos W=0.0975U L=3.835U
M755_ GND Ch_af_53_6 #fb691# GND nmos W=0.0975U L=0.13U
M756_keeper GND Vdd #690 GND nmos W=0.0975U L=3.835U
M757_keeper GND Vdd #693 GND nmos W=0.0975U L=3.835U
M758_ #3 __ia __p0 GND nmos W=0.0975U L=0.065U
M759_ #17 Od3_aa __p0 Vdd pmos W=0.1625U L=0.065U
M760_keeper #397 #fb396# __p0 Vdd pmos W=0.0975U L=0.065U
M761_keeper #398 #fb396# __p0 GND nmos W=0.0975U L=0.065U
M762_ #4 I_af_50_6 #3 GND nmos W=0.0975U L=0.065U
M763_ #5 I_af_51_6 #4 GND nmos W=0.0975U L=0.065U
M764_ #6 I_af_52_6 #5 GND nmos W=0.0975U L=0.065U
M765_ #7 I_af_53_6 #6 GND nmos W=0.0975U L=0.065U
M766_ #77 Od3_aa __ia GND nmos W=0.0975U L=0.065U
M767_ #80 I_af_50_6 __ia Vdd pmos W=0.1625U L=0.065U
M768_keeper #400 #fb399# __ia Vdd pmos W=0.0975U L=0.065U
M769_keeper #401 #fb399# __ia GND nmos W=0.0975U L=0.065U
M770_ #15 __s #14 Vdd pmos W=0.1625U L=0.065U
M771_ #14 Od0_aa #19 Vdd pmos W=0.1625U L=0.065U
M772_ #18 Od2_aa #17 Vdd pmos W=0.1625U L=0.065U
M773_ #19 Od1_aa #18 Vdd pmos W=0.1625U L=0.065U
M774_ #26 __it_53_6 p1 Vdd pmos W=0.1625U L=0.065U
M775_ #26 __it_52_6 p1 Vdd pmos W=0.1625U L=0.065U
M776_ #26 __it_51_6 p1 Vdd pmos W=0.1625U L=0.065U
M777_ #26 __it_50_6 p1 Vdd pmos W=0.1625U L=0.065U
M778_ #33 __cha p1 GND nmos W=0.0975U L=0.065U
M779_keeper #403 #fb402# p1 Vdd pmos W=0.0975U L=0.065U
M780_keeper #404 #fb402# p1 GND nmos W=0.0975U L=0.065U
M781_ #27 __s #26 Vdd pmos W=0.1625U L=0.065U
M782_ #34 __wa_53_6 #33 GND nmos W=0.0975U L=0.065U
M783_ #35 __wa_52_6 #34 GND nmos W=0.0975U L=0.065U
M784_ #36 __wa_51_6 #35 GND nmos W=0.0975U L=0.065U
M785_ #37 __wa_50_6 #36 GND nmos W=0.0975U L=0.065U
M786_ #65 __b_50_6 k Vdd pmos W=0.1625U L=0.065U
M787_ #67 b_50_6 k Vdd pmos W=0.1625U L=0.065U
M788_ #76 __if_50_6 k GND nmos W=0.0975U L=0.065U
M789_keeper #406 #fb405# k Vdd pmos W=0.0975U L=0.065U
M790_keeper #407 #fb405# k GND nmos W=0.0975U L=0.065U
M791_ #45 __it_53_6 #50 Vdd pmos W=0.1625U L=0.065U
M792_ #45 __if_53_6 #52 Vdd pmos W=0.1625U L=0.065U
M793_ #60 __b_51_6 #47 Vdd pmos W=0.1625U L=0.065U
M794_ #62 b_51_6 #47 Vdd pmos W=0.1625U L=0.065U
M795_ #47 __it_50_6 #65 Vdd pmos W=0.1625U L=0.065U
M796_ #47 __if_50_6 #67 Vdd pmos W=0.1625U L=0.065U
M797_ #55 __b_52_6 #48 Vdd pmos W=0.1625U L=0.065U
M798_ #57 b_52_6 #48 Vdd pmos W=0.1625U L=0.065U
M799_ #48 __it_51_6 #60 Vdd pmos W=0.1625U L=0.065U
M800_ #48 __if_51_6 #62 Vdd pmos W=0.1625U L=0.065U
M801_ #50 __b_53_6 #49 Vdd pmos W=0.1625U L=0.065U
M802_ #52 b_53_6 #49 Vdd pmos W=0.1625U L=0.065U
M803_ #49 __it_52_6 #55 Vdd pmos W=0.1625U L=0.065U
M804_ #49 __if_52_6 #57 Vdd pmos W=0.1625U L=0.065U
M805_ #168 __it_53_6 b_53_6 Vdd pmos W=0.1625U L=0.065U
M806_ #170 I_af_53_6 b_53_6 GND nmos W=0.0975U L=0.065U
M807_keeper #409 #fb408# b_53_6 Vdd pmos W=0.0975U L=0.065U
M808_keeper #410 #fb408# b_53_6 GND nmos W=0.0975U L=0.065U
M809_ #164 __it_52_6 b_52_6 Vdd pmos W=0.1625U L=0.065U
M810_ #166 I_af_52_6 b_52_6 GND nmos W=0.0975U L=0.065U
M811_keeper #412 #fb411# b_52_6 Vdd pmos W=0.0975U L=0.065U
M812_keeper #413 #fb411# b_52_6 GND nmos W=0.0975U L=0.065U
M813_ #160 __it_51_6 b_51_6 Vdd pmos W=0.1625U L=0.065U
M814_ #162 I_af_51_6 b_51_6 GND nmos W=0.0975U L=0.065U
M815_keeper #415 #fb414# b_51_6 Vdd pmos W=0.0975U L=0.065U
M816_keeper #416 #fb414# b_51_6 GND nmos W=0.0975U L=0.065U
M817_ #155 __it_50_6 b_50_6 Vdd pmos W=0.1625U L=0.065U
M818_ #158 I_af_50_6 b_50_6 GND nmos W=0.0975U L=0.065U
M819_keeper #418 #fb417# b_50_6 Vdd pmos W=0.0975U L=0.065U
M820_keeper #419 #fb417# b_50_6 GND nmos W=0.0975U L=0.065U
M821_ #75 __if_51_6 #70 GND nmos W=0.0975U L=0.065U
M822_ #70 __it_50_6 #76 GND nmos W=0.0975U L=0.065U
M823_ #74 __if_52_6 #71 GND nmos W=0.0975U L=0.065U
M824_ #71 __it_51_6 #75 GND nmos W=0.0975U L=0.065U
M825_ #73 __if_53_6 #72 GND nmos W=0.0975U L=0.065U
M826_ #72 __it_52_6 #74 GND nmos W=0.0975U L=0.065U
M827_ #78 Od2_aa #77 GND nmos W=0.0975U L=0.065U
M828_ #79 Od1_aa #78 GND nmos W=0.0975U L=0.065U
M829_ #81 I_af_51_6 #80 Vdd pmos W=0.1625U L=0.065U
M830_ #82 I_af_52_6 #81 Vdd pmos W=0.1625U L=0.065U
M831_ #83 I_af_53_6 #82 Vdd pmos W=0.1625U L=0.065U
M832_ #84 A_aa #83 Vdd pmos W=0.1625U L=0.065U
M833_ #85 p1 #84 Vdd pmos W=0.1625U L=0.065U
M834_ #103 __p1 A_aa Vdd pmos W=0.1625U L=0.065U
M835_ #104 __it_53_6 A_aa Vdd pmos W=0.1625U L=0.065U
M836_ #104 __it_52_6 A_aa Vdd pmos W=0.1625U L=0.065U
M837_ #104 __it_51_6 A_aa Vdd pmos W=0.1625U L=0.065U
M838_ #104 __it_50_6 A_aa Vdd pmos W=0.1625U L=0.065U
M839_ #105 __ar A_aa GND nmos W=0.0975U L=0.065U
M840_keeper #421 #fb420# A_aa Vdd pmos W=0.0975U L=0.065U
M841_keeper #422 #fb420# A_aa GND nmos W=0.0975U L=0.065U
M842_ #89 Od3_aa s Vdd pmos W=0.1625U L=0.065U
M843_ #94 Ch_aa s GND nmos W=0.0975U L=0.065U
M844_keeper #424 #fb423# s Vdd pmos W=0.0975U L=0.065U
M845_keeper #425 #fb423# s GND nmos W=0.0975U L=0.065U
M846_ #90 Od2_aa #89 Vdd pmos W=0.1625U L=0.065U
M847_ #91 Od1_aa #90 Vdd pmos W=0.1625U L=0.065U
M848_ #92 Od0_aa #91 Vdd pmos W=0.1625U L=0.065U
M849_ #93 __ia #92 Vdd pmos W=0.1625U L=0.065U
M850_ #95 W3_aa #94 GND nmos W=0.0975U L=0.065U
M851_ #96 W2_aa #95 GND nmos W=0.0975U L=0.065U
M852_ #97 W1_aa #96 GND nmos W=0.0975U L=0.065U
M853_ #103 s #104 Vdd pmos W=0.1625U L=0.065U
M854_keeper #427 #fb426# Od0_at_50_6 Vdd pmos W=0.0975U L=0.065U
M855_ #108 __p0 Od0_af_50_6 Vdd pmos W=0.1625U L=0.065U
M856_keeper #429 #fb428# Od0_af_50_6 Vdd pmos W=0.0975U L=0.065U
M857_keeper #430 #fb428# Od0_af_50_6 GND nmos W=0.0975U L=0.065U
M858_keeper #432 #fb431# Od0_at_51_6 Vdd pmos W=0.0975U L=0.065U
M859_ #112 __p0 Od0_af_51_6 Vdd pmos W=0.1625U L=0.065U
M860_keeper #434 #fb433# Od0_af_51_6 Vdd pmos W=0.0975U L=0.065U
M861_keeper #435 #fb433# Od0_af_51_6 GND nmos W=0.0975U L=0.065U
M862_keeper #437 #fb436# Od0_at_52_6 Vdd pmos W=0.0975U L=0.065U
M863_ #115 __p0 Od0_af_52_6 Vdd pmos W=0.1625U L=0.065U
M864_keeper #439 #fb438# Od0_af_52_6 Vdd pmos W=0.0975U L=0.065U
M865_keeper #440 #fb438# Od0_af_52_6 GND nmos W=0.0975U L=0.065U
M866_keeper #442 #fb441# Od0_at_53_6 Vdd pmos W=0.0975U L=0.065U
M867_ #118 __p0 Od0_af_53_6 Vdd pmos W=0.1625U L=0.065U
M868_keeper #444 #fb443# Od0_af_53_6 Vdd pmos W=0.0975U L=0.065U
M869_keeper #445 #fb443# Od0_af_53_6 GND nmos W=0.0975U L=0.065U
M870_keeper #447 #fb446# Od1_at_50_6 Vdd pmos W=0.0975U L=0.065U
M871_ #121 __p0 Od1_af_50_6 Vdd pmos W=0.1625U L=0.065U
M872_keeper #449 #fb448# Od1_af_50_6 Vdd pmos W=0.0975U L=0.065U
M873_keeper #450 #fb448# Od1_af_50_6 GND nmos W=0.0975U L=0.065U
M874_keeper #452 #fb451# Od1_at_51_6 Vdd pmos W=0.0975U L=0.065U
M875_ #124 __p0 Od1_af_51_6 Vdd pmos W=0.1625U L=0.065U
M876_keeper #454 #fb453# Od1_af_51_6 Vdd pmos W=0.0975U L=0.065U
M877_keeper #455 #fb453# Od1_af_51_6 GND nmos W=0.0975U L=0.065U
M878_keeper #457 #fb456# Od1_at_52_6 Vdd pmos W=0.0975U L=0.065U
M879_ #127 __p0 Od1_af_52_6 Vdd pmos W=0.1625U L=0.065U
M880_keeper #459 #fb458# Od1_af_52_6 Vdd pmos W=0.0975U L=0.065U
M881_keeper #460 #fb458# Od1_af_52_6 GND nmos W=0.0975U L=0.065U
M882_keeper #462 #fb461# Od1_at_53_6 Vdd pmos W=0.0975U L=0.065U
M883_ #130 __p0 Od1_af_53_6 Vdd pmos W=0.1625U L=0.065U
M884_keeper #464 #fb463# Od1_af_53_6 Vdd pmos W=0.0975U L=0.065U
M885_keeper #465 #fb463# Od1_af_53_6 GND nmos W=0.0975U L=0.065U
M886_keeper #467 #fb466# Od2_at_50_6 Vdd pmos W=0.0975U L=0.065U
M887_ #133 __p0 Od2_af_50_6 Vdd pmos W=0.1625U L=0.065U
M888_keeper #469 #fb468# Od2_af_50_6 Vdd pmos W=0.0975U L=0.065U
M889_keeper #470 #fb468# Od2_af_50_6 GND nmos W=0.0975U L=0.065U
M890_keeper #472 #fb471# Od2_at_51_6 Vdd pmos W=0.0975U L=0.065U
M891_ #136 __p0 Od2_af_51_6 Vdd pmos W=0.1625U L=0.065U
M892_keeper #474 #fb473# Od2_af_51_6 Vdd pmos W=0.0975U L=0.065U
M893_keeper #475 #fb473# Od2_af_51_6 GND nmos W=0.0975U L=0.065U
M894_keeper #477 #fb476# Od2_at_52_6 Vdd pmos W=0.0975U L=0.065U
M895_ #139 __p0 Od2_af_52_6 Vdd pmos W=0.1625U L=0.065U
M896_keeper #479 #fb478# Od2_af_52_6 Vdd pmos W=0.0975U L=0.065U
M897_keeper #480 #fb478# Od2_af_52_6 GND nmos W=0.0975U L=0.065U
M898_keeper #482 #fb481# Od2_at_53_6 Vdd pmos W=0.0975U L=0.065U
M899_ #142 __p0 Od2_af_53_6 Vdd pmos W=0.1625U L=0.065U
M900_keeper #484 #fb483# Od2_af_53_6 Vdd pmos W=0.0975U L=0.065U
M901_keeper #485 #fb483# Od2_af_53_6 GND nmos W=0.0975U L=0.065U
M902_keeper #487 #fb486# Od3_at_50_6 Vdd pmos W=0.0975U L=0.065U
M903_ #145 __p0 Od3_af_50_6 Vdd pmos W=0.1625U L=0.065U
M904_keeper #489 #fb488# Od3_af_50_6 Vdd pmos W=0.0975U L=0.065U
M905_keeper #490 #fb488# Od3_af_50_6 GND nmos W=0.0975U L=0.065U
M906_keeper #492 #fb491# Od3_at_51_6 Vdd pmos W=0.0975U L=0.065U
M907_ #148 __p0 Od3_af_51_6 Vdd pmos W=0.1625U L=0.065U
M908_keeper #494 #fb493# Od3_af_51_6 Vdd pmos W=0.0975U L=0.065U
M909_keeper #495 #fb493# Od3_af_51_6 GND nmos W=0.0975U L=0.065U
M910_keeper #497 #fb496# Od3_at_52_6 Vdd pmos W=0.0975U L=0.065U
M911_ #151 __p0 Od3_af_52_6 Vdd pmos W=0.1625U L=0.065U
M912_keeper #499 #fb498# Od3_af_52_6 Vdd pmos W=0.0975U L=0.065U
M913_keeper #500 #fb498# Od3_af_52_6 GND nmos W=0.0975U L=0.065U
M914_keeper #502 #fb501# Od3_at_53_6 Vdd pmos W=0.0975U L=0.065U
M915_ #154 __p0 Od3_af_53_6 Vdd pmos W=0.1625U L=0.065U
M916_keeper #504 #fb503# Od3_af_53_6 Vdd pmos W=0.0975U L=0.065U
M917_keeper #505 #fb503# Od3_af_53_6 GND nmos W=0.0975U L=0.065U
M918_ #156 __s #155 Vdd pmos W=0.1625U L=0.065U
M919_ #159 s #158 GND nmos W=0.0975U L=0.065U
M920_ #161 __s #160 Vdd pmos W=0.1625U L=0.065U
M921_ #163 s #162 GND nmos W=0.0975U L=0.065U
M922_ #165 __s #164 Vdd pmos W=0.1625U L=0.065U
M923_ #167 s #166 GND nmos W=0.0975U L=0.065U
M924_ #169 __s #168 Vdd pmos W=0.1625U L=0.065U
M925_ #171 s #170 GND nmos W=0.0975U L=0.065U
M926_keeper #507 #fb506# W0_at_51_6 Vdd pmos W=0.0975U L=0.065U
M927_ #174 __p1 W0_af_51_6 Vdd pmos W=0.1625U L=0.065U
M928_keeper #509 #fb508# W0_af_51_6 Vdd pmos W=0.0975U L=0.065U
M929_keeper #510 #fb508# W0_af_51_6 GND nmos W=0.0975U L=0.065U
M930_ #175 __ia #174 Vdd pmos W=0.1625U L=0.065U
M931_ #176 k #175 Vdd pmos W=0.1625U L=0.065U
M932_keeper #512 #fb511# W0_at_52_6 Vdd pmos W=0.0975U L=0.065U
M933_ #179 __p1 W0_af_52_6 Vdd pmos W=0.1625U L=0.065U
M934_keeper #514 #fb513# W0_af_52_6 Vdd pmos W=0.0975U L=0.065U
M935_keeper #515 #fb513# W0_af_52_6 GND nmos W=0.0975U L=0.065U
M936_ #180 __ia #179 Vdd pmos W=0.1625U L=0.065U
M937_ #181 k #180 Vdd pmos W=0.1625U L=0.065U
M938_keeper #517 #fb516# W0_at_53_6 Vdd pmos W=0.0975U L=0.065U
M939_ #184 __p1 W0_af_53_6 Vdd pmos W=0.1625U L=0.065U
M940_keeper #519 #fb518# W0_af_53_6 Vdd pmos W=0.0975U L=0.065U
M941_keeper #520 #fb518# W0_af_53_6 GND nmos W=0.0975U L=0.065U
M942_ #185 __ia #184 Vdd pmos W=0.1625U L=0.065U
M943_ #186 k #185 Vdd pmos W=0.1625U L=0.065U
M944_keeper #522 #fb521# W0_at_54_6 Vdd pmos W=0.0975U L=0.065U
M945_ #189 __p1 W0_af_54_6 Vdd pmos W=0.1625U L=0.065U
M946_keeper #524 #fb523# W0_af_54_6 Vdd pmos W=0.0975U L=0.065U
M947_keeper #525 #fb523# W0_af_54_6 GND nmos W=0.0975U L=0.065U
M948_ #190 __ia #189 Vdd pmos W=0.1625U L=0.065U
M949_ #191 k #190 Vdd pmos W=0.1625U L=0.065U
M950_keeper #527 #fb526# W0_at_55_6 Vdd pmos W=0.0975U L=0.065U
M951_ #194 __p1 W0_af_55_6 Vdd pmos W=0.1625U L=0.065U
M952_keeper #529 #fb528# W0_af_55_6 Vdd pmos W=0.0975U L=0.065U
M953_keeper #530 #fb528# W0_af_55_6 GND nmos W=0.0975U L=0.065U
M954_ #195 __ia #194 Vdd pmos W=0.1625U L=0.065U
M955_ #196 k #195 Vdd pmos W=0.1625U L=0.065U
M956_keeper #532 #fb531# W0_at_56_6 Vdd pmos W=0.0975U L=0.065U
M957_ #199 __p1 W0_af_56_6 Vdd pmos W=0.1625U L=0.065U
M958_keeper #534 #fb533# W0_af_56_6 Vdd pmos W=0.0975U L=0.065U
M959_keeper #535 #fb533# W0_af_56_6 GND nmos W=0.0975U L=0.065U
M960_ #200 __ia #199 Vdd pmos W=0.1625U L=0.065U
M961_ #201 k #200 Vdd pmos W=0.1625U L=0.065U
M962_keeper #537 #fb536# W0_at_57_6 Vdd pmos W=0.0975U L=0.065U
M963_ #204 __p1 W0_af_57_6 Vdd pmos W=0.1625U L=0.065U
M964_keeper #539 #fb538# W0_af_57_6 Vdd pmos W=0.0975U L=0.065U
M965_keeper #540 #fb538# W0_af_57_6 GND nmos W=0.0975U L=0.065U
M966_ #205 __ia #204 Vdd pmos W=0.1625U L=0.065U
M967_ #206 k #205 Vdd pmos W=0.1625U L=0.065U
M968_ #208 __b_53_6 W0_at_50_6 Vdd pmos W=0.1625U L=0.065U
M969_keeper #542 #fb541# W0_at_50_6 Vdd pmos W=0.0975U L=0.065U
M970_keeper #543 #fb541# W0_at_50_6 GND nmos W=0.0975U L=0.065U
M971_ #209 __p1 #208 Vdd pmos W=0.1625U L=0.065U
M972_ #210 __ia #209 Vdd pmos W=0.1625U L=0.065U
M973_ #211 k #210 Vdd pmos W=0.1625U L=0.065U
M974_ #213 b_53_6 W0_af_50_6 Vdd pmos W=0.1625U L=0.065U
M975_keeper #545 #fb544# W0_af_50_6 Vdd pmos W=0.0975U L=0.065U
M976_keeper #546 #fb544# W0_af_50_6 GND nmos W=0.0975U L=0.065U
M977_ #214 __p1 #213 Vdd pmos W=0.1625U L=0.065U
M978_ #215 __ia #214 Vdd pmos W=0.1625U L=0.065U
M979_ #216 k #215 Vdd pmos W=0.1625U L=0.065U
M980_keeper #548 #fb547# W1_at_51_6 Vdd pmos W=0.0975U L=0.065U
M981_ #219 __p1 W1_af_51_6 Vdd pmos W=0.1625U L=0.065U
M982_keeper #550 #fb549# W1_af_51_6 Vdd pmos W=0.0975U L=0.065U
M983_keeper #551 #fb549# W1_af_51_6 GND nmos W=0.0975U L=0.065U
M984_ #220 __ia #219 Vdd pmos W=0.1625U L=0.065U
M985_ #221 k #220 Vdd pmos W=0.1625U L=0.065U
M986_keeper #553 #fb552# W1_at_52_6 Vdd pmos W=0.0975U L=0.065U
M987_ #224 __p1 W1_af_52_6 Vdd pmos W=0.1625U L=0.065U
M988_keeper #555 #fb554# W1_af_52_6 Vdd pmos W=0.0975U L=0.065U
M989_keeper #556 #fb554# W1_af_52_6 GND nmos W=0.0975U L=0.065U
M990_ #225 __ia #224 Vdd pmos W=0.1625U L=0.065U
M991_ #226 k #225 Vdd pmos W=0.1625U L=0.065U
M992_keeper #558 #fb557# W1_at_53_6 Vdd pmos W=0.0975U L=0.065U
M993_ #229 __p1 W1_af_53_6 Vdd pmos W=0.1625U L=0.065U
M994_keeper #560 #fb559# W1_af_53_6 Vdd pmos W=0.0975U L=0.065U
M995_keeper #561 #fb559# W1_af_53_6 GND nmos W=0.0975U L=0.065U
M996_ #230 __ia #229 Vdd pmos W=0.1625U L=0.065U
M997_ #231 k #230 Vdd pmos W=0.1625U L=0.065U
M998_keeper #563 #fb562# W1_at_54_6 Vdd pmos W=0.0975U L=0.065U
M999_ #234 __p1 W1_af_54_6 Vdd pmos W=0.1625U L=0.065U
M1000_keeper #565 #fb564# W1_af_54_6 Vdd pmos W=0.0975U L=0.065U
M1001_keeper #566 #fb564# W1_af_54_6 GND nmos W=0.0975U L=0.065U
M1002_ #235 __ia #234 Vdd pmos W=0.1625U L=0.065U
M1003_ #236 k #235 Vdd pmos W=0.1625U L=0.065U
M1004_keeper #568 #fb567# W1_at_55_6 Vdd pmos W=0.0975U L=0.065U
M1005_ #239 __p1 W1_af_55_6 Vdd pmos W=0.1625U L=0.065U
M1006_keeper #570 #fb569# W1_af_55_6 Vdd pmos W=0.0975U L=0.065U
M1007_keeper #571 #fb569# W1_af_55_6 GND nmos W=0.0975U L=0.065U
M1008_ #240 __ia #239 Vdd pmos W=0.1625U L=0.065U
M1009_ #241 k #240 Vdd pmos W=0.1625U L=0.065U
M1010_keeper #573 #fb572# W1_at_56_6 Vdd pmos W=0.0975U L=0.065U
M1011_ #244 __p1 W1_af_56_6 Vdd pmos W=0.1625U L=0.065U
M1012_keeper #575 #fb574# W1_af_56_6 Vdd pmos W=0.0975U L=0.065U
M1013_keeper #576 #fb574# W1_af_56_6 GND nmos W=0.0975U L=0.065U
M1014_ #245 __ia #244 Vdd pmos W=0.1625U L=0.065U
M1015_ #246 k #245 Vdd pmos W=0.1625U L=0.065U
M1016_keeper #578 #fb577# W1_at_57_6 Vdd pmos W=0.0975U L=0.065U
M1017_ #249 __p1 W1_af_57_6 Vdd pmos W=0.1625U L=0.065U
M1018_keeper #580 #fb579# W1_af_57_6 Vdd pmos W=0.0975U L=0.065U
M1019_keeper #581 #fb579# W1_af_57_6 GND nmos W=0.0975U L=0.065U
M1020_ #250 __ia #249 Vdd pmos W=0.1625U L=0.065U
M1021_ #251 k #250 Vdd pmos W=0.1625U L=0.065U
M1022_ #253 __b_52_6 W1_at_50_6 Vdd pmos W=0.1625U L=0.065U
M1023_keeper #583 #fb582# W1_at_50_6 Vdd pmos W=0.0975U L=0.065U
M1024_keeper #584 #fb582# W1_at_50_6 GND nmos W=0.0975U L=0.065U
M1025_ #254 __p1 #253 Vdd pmos W=0.1625U L=0.065U
M1026_ #255 __ia #254 Vdd pmos W=0.1625U L=0.065U
M1027_ #256 k #255 Vdd pmos W=0.1625U L=0.065U
M1028_ #258 b_52_6 W1_af_50_6 Vdd pmos W=0.1625U L=0.065U
M1029_keeper #586 #fb585# W1_af_50_6 Vdd pmos W=0.0975U L=0.065U
M1030_keeper #587 #fb585# W1_af_50_6 GND nmos W=0.0975U L=0.065U
M1031_ #259 __p1 #258 Vdd pmos W=0.1625U L=0.065U
M1032_ #260 __ia #259 Vdd pmos W=0.1625U L=0.065U
M1033_ #261 k #260 Vdd pmos W=0.1625U L=0.065U
M1034_keeper #589 #fb588# W2_at_51_6 Vdd pmos W=0.0975U L=0.065U
M1035_ #264 __p1 W2_af_51_6 Vdd pmos W=0.1625U L=0.065U
M1036_keeper #591 #fb590# W2_af_51_6 Vdd pmos W=0.0975U L=0.065U
M1037_keeper #592 #fb590# W2_af_51_6 GND nmos W=0.0975U L=0.065U
M1038_ #265 __ia #264 Vdd pmos W=0.1625U L=0.065U
M1039_ #266 k #265 Vdd pmos W=0.1625U L=0.065U
M1040_keeper #594 #fb593# W2_at_52_6 Vdd pmos W=0.0975U L=0.065U
M1041_ #269 __p1 W2_af_52_6 Vdd pmos W=0.1625U L=0.065U
M1042_keeper #596 #fb595# W2_af_52_6 Vdd pmos W=0.0975U L=0.065U
M1043_keeper #597 #fb595# W2_af_52_6 GND nmos W=0.0975U L=0.065U
M1044_ #270 __ia #269 Vdd pmos W=0.1625U L=0.065U
M1045_ #271 k #270 Vdd pmos W=0.1625U L=0.065U
M1046_keeper #599 #fb598# W2_at_53_6 Vdd pmos W=0.0975U L=0.065U
M1047_ #274 __p1 W2_af_53_6 Vdd pmos W=0.1625U L=0.065U
M1048_keeper #601 #fb600# W2_af_53_6 Vdd pmos W=0.0975U L=0.065U
M1049_keeper #602 #fb600# W2_af_53_6 GND nmos W=0.0975U L=0.065U
M1050_ #275 __ia #274 Vdd pmos W=0.1625U L=0.065U
M1051_ #276 k #275 Vdd pmos W=0.1625U L=0.065U
M1052_keeper #604 #fb603# W2_at_54_6 Vdd pmos W=0.0975U L=0.065U
M1053_ #279 __p1 W2_af_54_6 Vdd pmos W=0.1625U L=0.065U
M1054_keeper #606 #fb605# W2_af_54_6 Vdd pmos W=0.0975U L=0.065U
M1055_keeper #607 #fb605# W2_af_54_6 GND nmos W=0.0975U L=0.065U
M1056_ #280 __ia #279 Vdd pmos W=0.1625U L=0.065U
M1057_ #281 k #280 Vdd pmos W=0.1625U L=0.065U
M1058_keeper #609 #fb608# W2_at_55_6 Vdd pmos W=0.0975U L=0.065U
M1059_ #284 __p1 W2_af_55_6 Vdd pmos W=0.1625U L=0.065U
M1060_keeper #611 #fb610# W2_af_55_6 Vdd pmos W=0.0975U L=0.065U
M1061_keeper #612 #fb610# W2_af_55_6 GND nmos W=0.0975U L=0.065U
M1062_ #285 __ia #284 Vdd pmos W=0.1625U L=0.065U
M1063_ #286 k #285 Vdd pmos W=0.1625U L=0.065U
M1064_keeper #614 #fb613# W2_at_56_6 Vdd pmos W=0.0975U L=0.065U
M1065_ #289 __p1 W2_af_56_6 Vdd pmos W=0.1625U L=0.065U
M1066_keeper #616 #fb615# W2_af_56_6 Vdd pmos W=0.0975U L=0.065U
M1067_keeper #617 #fb615# W2_af_56_6 GND nmos W=0.0975U L=0.065U
M1068_ #290 __ia #289 Vdd pmos W=0.1625U L=0.065U
M1069_ #291 k #290 Vdd pmos W=0.1625U L=0.065U
M1070_keeper #619 #fb618# W2_at_57_6 Vdd pmos W=0.0975U L=0.065U
M1071_ #294 __p1 W2_af_57_6 Vdd pmos W=0.1625U L=0.065U
M1072_keeper #621 #fb620# W2_af_57_6 Vdd pmos W=0.0975U L=0.065U
M1073_keeper #622 #fb620# W2_af_57_6 GND nmos W=0.0975U L=0.065U
M1074_ #295 __ia #294 Vdd pmos W=0.1625U L=0.065U
M1075_ #296 k #295 Vdd pmos W=0.1625U L=0.065U
M1076_ #298 __b_51_6 W2_at_50_6 Vdd pmos W=0.1625U L=0.065U
M1077_keeper #624 #fb623# W2_at_50_6 Vdd pmos W=0.0975U L=0.065U
M1078_keeper #625 #fb623# W2_at_50_6 GND nmos W=0.0975U L=0.065U
M1079_ #299 __p1 #298 Vdd pmos W=0.1625U L=0.065U
M1080_ #300 __ia #299 Vdd pmos W=0.1625U L=0.065U
M1081_ #301 k #300 Vdd pmos W=0.1625U L=0.065U
M1082_ #303 b_51_6 W2_af_50_6 Vdd pmos W=0.1625U L=0.065U
M1083_keeper #627 #fb626# W2_af_50_6 Vdd pmos W=0.0975U L=0.065U
M1084_keeper #628 #fb626# W2_af_50_6 GND nmos W=0.0975U L=0.065U
M1085_ #304 __p1 #303 Vdd pmos W=0.1625U L=0.065U
M1086_ #305 __ia #304 Vdd pmos W=0.1625U L=0.065U
M1087_ #306 k #305 Vdd pmos W=0.1625U L=0.065U
M1088_keeper #630 #fb629# W3_at_51_6 Vdd pmos W=0.0975U L=0.065U
M1089_ #309 __p1 W3_af_51_6 Vdd pmos W=0.1625U L=0.065U
M1090_keeper #632 #fb631# W3_af_51_6 Vdd pmos W=0.0975U L=0.065U
M1091_keeper #633 #fb631# W3_af_51_6 GND nmos W=0.0975U L=0.065U
M1092_ #310 __ia #309 Vdd pmos W=0.1625U L=0.065U
M1093_ #311 k #310 Vdd pmos W=0.1625U L=0.065U
M1094_keeper #635 #fb634# W3_at_52_6 Vdd pmos W=0.0975U L=0.065U
M1095_ #314 __p1 W3_af_52_6 Vdd pmos W=0.1625U L=0.065U
M1096_keeper #637 #fb636# W3_af_52_6 Vdd pmos W=0.0975U L=0.065U
M1097_keeper #638 #fb636# W3_af_52_6 GND nmos W=0.0975U L=0.065U
M1098_ #315 __ia #314 Vdd pmos W=0.1625U L=0.065U
M1099_ #316 k #315 Vdd pmos W=0.1625U L=0.065U
M1100_keeper #640 #fb639# W3_at_53_6 Vdd pmos W=0.0975U L=0.065U
M1101_ #319 __p1 W3_af_53_6 Vdd pmos W=0.1625U L=0.065U
M1102_keeper #642 #fb641# W3_af_53_6 Vdd pmos W=0.0975U L=0.065U
M1103_keeper #643 #fb641# W3_af_53_6 GND nmos W=0.0975U L=0.065U
M1104_ #320 __ia #319 Vdd pmos W=0.1625U L=0.065U
M1105_ #321 k #320 Vdd pmos W=0.1625U L=0.065U
M1106_keeper #645 #fb644# W3_at_54_6 Vdd pmos W=0.0975U L=0.065U
M1107_ #324 __p1 W3_af_54_6 Vdd pmos W=0.1625U L=0.065U
M1108_keeper #647 #fb646# W3_af_54_6 Vdd pmos W=0.0975U L=0.065U
M1109_keeper #648 #fb646# W3_af_54_6 GND nmos W=0.0975U L=0.065U
M1110_ #325 __ia #324 Vdd pmos W=0.1625U L=0.065U
M1111_ #326 k #325 Vdd pmos W=0.1625U L=0.065U
M1112_keeper #650 #fb649# W3_at_55_6 Vdd pmos W=0.0975U L=0.065U
M1113_ #329 __p1 W3_af_55_6 Vdd pmos W=0.1625U L=0.065U
M1114_keeper #652 #fb651# W3_af_55_6 Vdd pmos W=0.0975U L=0.065U
M1115_keeper #653 #fb651# W3_af_55_6 GND nmos W=0.0975U L=0.065U
M1116_ #330 __ia #329 Vdd pmos W=0.1625U L=0.065U
M1117_ #331 k #330 Vdd pmos W=0.1625U L=0.065U
M1118_keeper #655 #fb654# W3_at_56_6 Vdd pmos W=0.0975U L=0.065U
M1119_ #334 __p1 W3_af_56_6 Vdd pmos W=0.1625U L=0.065U
M1120_keeper #657 #fb656# W3_af_56_6 Vdd pmos W=0.0975U L=0.065U
M1121_keeper #658 #fb656# W3_af_56_6 GND nmos W=0.0975U L=0.065U
M1122_ #335 __ia #334 Vdd pmos W=0.1625U L=0.065U
M1123_ #336 k #335 Vdd pmos W=0.1625U L=0.065U
M1124_keeper #660 #fb659# W3_at_57_6 Vdd pmos W=0.0975U L=0.065U
M1125_ #339 __p1 W3_af_57_6 Vdd pmos W=0.1625U L=0.065U
M1126_keeper #662 #fb661# W3_af_57_6 Vdd pmos W=0.0975U L=0.065U
M1127_keeper #663 #fb661# W3_af_57_6 GND nmos W=0.0975U L=0.065U
M1128_ #340 __ia #339 Vdd pmos W=0.1625U L=0.065U
M1129_ #341 k #340 Vdd pmos W=0.1625U L=0.065U
M1130_ #343 __b_50_6 W3_at_50_6 Vdd pmos W=0.1625U L=0.065U
M1131_keeper #665 #fb664# W3_at_50_6 Vdd pmos W=0.0975U L=0.065U
M1132_keeper #666 #fb664# W3_at_50_6 GND nmos W=0.0975U L=0.065U
M1133_ #344 __p1 #343 Vdd pmos W=0.1625U L=0.065U
M1134_ #345 __ia #344 Vdd pmos W=0.1625U L=0.065U
M1135_ #346 k #345 Vdd pmos W=0.1625U L=0.065U
M1136_ #348 b_50_6 W3_af_50_6 Vdd pmos W=0.1625U L=0.065U
M1137_keeper #668 #fb667# W3_af_50_6 Vdd pmos W=0.0975U L=0.065U
M1138_keeper #669 #fb667# W3_af_50_6 GND nmos W=0.0975U L=0.065U
M1139_ #349 __p1 #348 Vdd pmos W=0.1625U L=0.065U
M1140_ #350 __ia #349 Vdd pmos W=0.1625U L=0.065U
M1141_ #351 k #350 Vdd pmos W=0.1625U L=0.065U
M1142_ #353 __b_50_6 Ch_at_50_6 Vdd pmos W=0.1625U L=0.065U
M1143_keeper #671 #fb670# Ch_at_50_6 Vdd pmos W=0.0975U L=0.065U
M1144_keeper #672 #fb670# Ch_at_50_6 GND nmos W=0.0975U L=0.065U
M1145_ #354 __p1 #353 Vdd pmos W=0.1625U L=0.065U
M1146_ #355 __ia #354 Vdd pmos W=0.1625U L=0.065U
M1147_ #356 k #355 Vdd pmos W=0.1625U L=0.065U
M1148_ #358 b_50_6 Ch_af_50_6 Vdd pmos W=0.1625U L=0.065U
M1149_keeper #674 #fb673# Ch_af_50_6 Vdd pmos W=0.0975U L=0.065U
M1150_keeper #675 #fb673# Ch_af_50_6 GND nmos W=0.0975U L=0.065U
M1151_ #359 __p1 #358 Vdd pmos W=0.1625U L=0.065U
M1152_ #360 __ia #359 Vdd pmos W=0.1625U L=0.065U
M1153_ #361 k #360 Vdd pmos W=0.1625U L=0.065U
M1154_ #363 __b_51_6 Ch_at_51_6 Vdd pmos W=0.1625U L=0.065U
M1155_keeper #677 #fb676# Ch_at_51_6 Vdd pmos W=0.0975U L=0.065U
M1156_keeper #678 #fb676# Ch_at_51_6 GND nmos W=0.0975U L=0.065U
M1157_ #364 __p1 #363 Vdd pmos W=0.1625U L=0.065U
M1158_ #365 __ia #364 Vdd pmos W=0.1625U L=0.065U
M1159_ #366 k #365 Vdd pmos W=0.1625U L=0.065U
M1160_ #368 b_51_6 Ch_af_51_6 Vdd pmos W=0.1625U L=0.065U
M1161_keeper #680 #fb679# Ch_af_51_6 Vdd pmos W=0.0975U L=0.065U
M1162_keeper #681 #fb679# Ch_af_51_6 GND nmos W=0.0975U L=0.065U
M1163_ #369 __p1 #368 Vdd pmos W=0.1625U L=0.065U
M1164_ #370 __ia #369 Vdd pmos W=0.1625U L=0.065U
M1165_ #371 k #370 Vdd pmos W=0.1625U L=0.065U
M1166_ #373 __b_52_6 Ch_at_52_6 Vdd pmos W=0.1625U L=0.065U
M1167_keeper #683 #fb682# Ch_at_52_6 Vdd pmos W=0.0975U L=0.065U
M1168_keeper #684 #fb682# Ch_at_52_6 GND nmos W=0.0975U L=0.065U
M1169_ #374 __p1 #373 Vdd pmos W=0.1625U L=0.065U
M1170_ #375 __ia #374 Vdd pmos W=0.1625U L=0.065U
M1171_ #376 k #375 Vdd pmos W=0.1625U L=0.065U
M1172_ #378 b_52_6 Ch_af_52_6 Vdd pmos W=0.1625U L=0.065U
M1173_keeper #686 #fb685# Ch_af_52_6 Vdd pmos W=0.0975U L=0.065U
M1174_keeper #687 #fb685# Ch_af_52_6 GND nmos W=0.0975U L=0.065U
M1175_ #379 __p1 #378 Vdd pmos W=0.1625U L=0.065U
M1176_ #380 __ia #379 Vdd pmos W=0.1625U L=0.065U
M1177_ #381 k #380 Vdd pmos W=0.1625U L=0.065U
M1178_ #383 __b_53_6 Ch_at_53_6 Vdd pmos W=0.1625U L=0.065U
M1179_keeper #689 #fb688# Ch_at_53_6 Vdd pmos W=0.0975U L=0.065U
M1180_keeper #690 #fb688# Ch_at_53_6 GND nmos W=0.0975U L=0.065U
M1181_ #384 __p1 #383 Vdd pmos W=0.1625U L=0.065U
M1182_ #385 __ia #384 Vdd pmos W=0.1625U L=0.065U
M1183_ #386 k #385 Vdd pmos W=0.1625U L=0.065U
M1184_ #388 b_53_6 Ch_af_53_6 Vdd pmos W=0.1625U L=0.065U
M1185_keeper #692 #fb691# Ch_af_53_6 Vdd pmos W=0.0975U L=0.065U
M1186_keeper #693 #fb691# Ch_af_53_6 GND nmos W=0.0975U L=0.065U
M1187_ #389 __p1 #388 Vdd pmos W=0.1625U L=0.065U
M1188_ #390 __ia #389 Vdd pmos W=0.1625U L=0.065U
M1189_ #391 k #390 Vdd pmos W=0.1625U L=0.065U
.ends
*---- end of process: SUpdate<> -----
*
*---- act defproc: QuadRouter<> -----
* raw ports:  reset I.t[0] I.t[1] I.t[2] I.t[3] I.f[0] I.f[1] I.f[2] I.f[3] I.a Cnt0.req Cnt0.t[0] Cnt0.t[1] Cnt0.t[2] Cnt0.t[3] Cnt0.t[4] Cnt0.t[5] Cnt0.t[6] Cnt0.t[7] Cnt0.f[0] Cnt0.f[1] Cnt0.f[2] Cnt0.f[3] Cnt0.f[4] Cnt0.f[5] Cnt0.f[6] Cnt0.f[7] Cnt1.req Cnt1.t[0] Cnt1.t[1] Cnt1.t[2] Cnt1.t[3] Cnt1.t[4] Cnt1.t[5] Cnt1.t[6] Cnt1.t[7] Cnt1.f[0] Cnt1.f[1] Cnt1.f[2] Cnt1.f[3] Cnt1.f[4] Cnt1.f[5] Cnt1.f[6] Cnt1.f[7] Cnt2.req Cnt2.t[0] Cnt2.t[1] Cnt2.t[2] Cnt2.t[3] Cnt2.t[4] Cnt2.t[5] Cnt2.t[6] Cnt2.t[7] Cnt2.f[0] Cnt2.f[1] Cnt2.f[2] Cnt2.f[3] Cnt2.f[4] Cnt2.f[5] Cnt2.f[6] Cnt2.f[7] Cnt3.req Cnt3.t[0] Cnt3.t[1] Cnt3.t[2] Cnt3.t[3] Cnt3.t[4] Cnt3.t[5] Cnt3.t[6] Cnt3.t[7] Cnt3.f[0] Cnt3.f[1] Cnt3.f[2] Cnt3.f[3] Cnt3.f[4] Cnt3.f[5] Cnt3.f[6] Cnt3.f[7] OC0.t[0] OC0.t[1] OC0.t[2] OC0.t[3] OC0.f[0] OC0.f[1] OC0.f[2] OC0.f[3] OC0.a OC1.t[0] OC1.t[1] OC1.t[2] OC1.t[3] OC1.f[0] OC1.f[1] OC1.f[2] OC1.f[3] OC1.a OC2.t[0] OC2.t[1] OC2.t[2] OC2.t[3] OC2.f[0] OC2.f[1] OC2.f[2] OC2.f[3] OC2.a OC3.t[0] OC3.t[1] OC3.t[2] OC3.t[3] OC3.f[0] OC3.f[1] OC3.f[2] OC3.f[3] OC3.a OD0.t[0] OD0.t[1] OD0.t[2] OD0.t[3] OD0.f[0] OD0.f[1] OD0.f[2] OD0.f[3] OD0.a OD1.t[0] OD1.t[1] OD1.t[2] OD1.t[3] OD1.f[0] OD1.f[1] OD1.f[2] OD1.f[3] OD1.a OD2.t[0] OD2.t[1] OD2.t[2] OD2.t[3] OD2.f[0] OD2.f[1] OD2.f[2] OD2.f[3] OD2.a OD3.t[0] OD3.t[1] OD3.t[2] OD3.t[3] OD3.f[0] OD3.f[1] OD3.f[2] OD3.f[3] OD3.a Ch.t[0] Ch.t[1] Ch.t[2] Ch.t[3] Ch.f[0] Ch.f[1] Ch.f[2] Ch.f[3] Ch.a
*
.subckt QuadRouter reset I_at_50_6 I_at_51_6 I_at_52_6 I_at_53_6 I_af_50_6 I_af_51_6 I_af_52_6 I_af_53_6 I_aa Cnt0_areq Cnt0_at_50_6 Cnt0_at_51_6 Cnt0_at_52_6 Cnt0_at_53_6 Cnt0_at_54_6 Cnt0_at_55_6 Cnt0_at_56_6 Cnt0_at_57_6 Cnt0_af_50_6 Cnt0_af_51_6 Cnt0_af_52_6 Cnt0_af_53_6 Cnt0_af_54_6 Cnt0_af_55_6 Cnt0_af_56_6 Cnt0_af_57_6 Cnt1_areq Cnt1_at_50_6 Cnt1_at_51_6 Cnt1_at_52_6 Cnt1_at_53_6 Cnt1_at_54_6 Cnt1_at_55_6 Cnt1_at_56_6 Cnt1_at_57_6 Cnt1_af_50_6 Cnt1_af_51_6 Cnt1_af_52_6 Cnt1_af_53_6 Cnt1_af_54_6 Cnt1_af_55_6 Cnt1_af_56_6 Cnt1_af_57_6 Cnt2_areq Cnt2_at_50_6 Cnt2_at_51_6 Cnt2_at_52_6 Cnt2_at_53_6 Cnt2_at_54_6 Cnt2_at_55_6 Cnt2_at_56_6 Cnt2_at_57_6 Cnt2_af_50_6 Cnt2_af_51_6 Cnt2_af_52_6 Cnt2_af_53_6 Cnt2_af_54_6 Cnt2_af_55_6 Cnt2_af_56_6 Cnt2_af_57_6 Cnt3_areq Cnt3_at_50_6 Cnt3_at_51_6 Cnt3_at_52_6 Cnt3_at_53_6 Cnt3_at_54_6 Cnt3_at_55_6 Cnt3_at_56_6 Cnt3_at_57_6 Cnt3_af_50_6 Cnt3_af_51_6 Cnt3_af_52_6 Cnt3_af_53_6 Cnt3_af_54_6 Cnt3_af_55_6 Cnt3_af_56_6 Cnt3_af_57_6 OC0_at_50_6 OC0_at_51_6 OC0_at_52_6 OC0_at_53_6 OC0_af_50_6 OC0_af_51_6 OC0_af_52_6 OC0_af_53_6 OC0_aa OC1_at_50_6 OC1_at_51_6 OC1_at_52_6 OC1_at_53_6 OC1_af_50_6 OC1_af_51_6 OC1_af_52_6 OC1_af_53_6 OC1_aa OC2_at_50_6 OC2_at_51_6 OC2_at_52_6 OC2_at_53_6 OC2_af_50_6 OC2_af_51_6 OC2_af_52_6 OC2_af_53_6 OC2_aa OC3_at_50_6 OC3_at_51_6 OC3_at_52_6 OC3_at_53_6 OC3_af_50_6 OC3_af_51_6 OC3_af_52_6 OC3_af_53_6 OC3_aa OD0_at_50_6 OD0_at_51_6 OD0_at_52_6 OD0_at_53_6 OD0_af_50_6 OD0_af_51_6 OD0_af_52_6 OD0_af_53_6 OD0_aa OD1_at_50_6 OD1_at_51_6 OD1_at_52_6 OD1_at_53_6 OD1_af_50_6 OD1_af_51_6 OD1_af_52_6 OD1_af_53_6 OD1_aa OD2_at_50_6 OD2_at_51_6 OD2_at_52_6 OD2_at_53_6 OD2_af_50_6 OD2_af_51_6 OD2_af_52_6 OD2_af_53_6 OD2_aa OD3_at_50_6 OD3_at_51_6 OD3_at_52_6 OD3_at_53_6 OD3_af_50_6 OD3_af_51_6 OD3_af_52_6 OD3_af_53_6 OD3_aa Ch_at_50_6 Ch_at_51_6 Ch_at_52_6 Ch_at_53_6 Ch_af_50_6 Ch_af_51_6 Ch_af_52_6 Ch_af_53_6 Ch_aa
*.PININFO reset:I I_at_50_6:I I_at_51_6:I I_at_52_6:I I_at_53_6:I I_af_50_6:I I_af_51_6:I I_af_52_6:I I_af_53_6:I I_aa:O Cnt0_areq:O Cnt0_at_50_6:I Cnt0_at_51_6:I Cnt0_at_52_6:I Cnt0_at_53_6:I Cnt0_at_54_6:I Cnt0_at_55_6:I Cnt0_at_56_6:I Cnt0_at_57_6:I Cnt0_af_50_6:I Cnt0_af_51_6:I Cnt0_af_52_6:I Cnt0_af_53_6:I Cnt0_af_54_6:I Cnt0_af_55_6:I Cnt0_af_56_6:I Cnt0_af_57_6:I Cnt1_areq:O Cnt1_at_50_6:I Cnt1_at_51_6:I Cnt1_at_52_6:I Cnt1_at_53_6:I Cnt1_at_54_6:I Cnt1_at_55_6:I Cnt1_at_56_6:I Cnt1_at_57_6:I Cnt1_af_50_6:I Cnt1_af_51_6:I Cnt1_af_52_6:I Cnt1_af_53_6:I Cnt1_af_54_6:I Cnt1_af_55_6:I Cnt1_af_56_6:I Cnt1_af_57_6:I Cnt2_areq:O Cnt2_at_50_6:I Cnt2_at_51_6:I Cnt2_at_52_6:I Cnt2_at_53_6:I Cnt2_at_54_6:I Cnt2_at_55_6:I Cnt2_at_56_6:I Cnt2_at_57_6:I Cnt2_af_50_6:I Cnt2_af_51_6:I Cnt2_af_52_6:I Cnt2_af_53_6:I Cnt2_af_54_6:I Cnt2_af_55_6:I Cnt2_af_56_6:I Cnt2_af_57_6:I Cnt3_areq:O Cnt3_at_50_6:I Cnt3_at_51_6:I Cnt3_at_52_6:I Cnt3_at_53_6:I Cnt3_at_54_6:I Cnt3_at_55_6:I Cnt3_at_56_6:I Cnt3_at_57_6:I Cnt3_af_50_6:I Cnt3_af_51_6:I Cnt3_af_52_6:I Cnt3_af_53_6:I Cnt3_af_54_6:I Cnt3_af_55_6:I Cnt3_af_56_6:I Cnt3_af_57_6:I OC0_at_50_6:O OC0_at_51_6:O OC0_at_52_6:O OC0_at_53_6:O OC0_af_50_6:O OC0_af_51_6:O OC0_af_52_6:O OC0_af_53_6:O OC0_aa:I OC1_at_50_6:O OC1_at_51_6:O OC1_at_52_6:O OC1_at_53_6:O OC1_af_50_6:O OC1_af_51_6:O OC1_af_52_6:O OC1_af_53_6:O OC1_aa:I OC2_at_50_6:O OC2_at_51_6:O OC2_at_52_6:O OC2_at_53_6:O OC2_af_50_6:O OC2_af_51_6:O OC2_af_52_6:O OC2_af_53_6:O OC2_aa:I OC3_at_50_6:O OC3_at_51_6:O OC3_at_52_6:O OC3_at_53_6:O OC3_af_50_6:O OC3_af_51_6:O OC3_af_52_6:O OC3_af_53_6:O OC3_aa:I OD0_at_50_6:O OD0_at_51_6:O OD0_at_52_6:O OD0_at_53_6:O OD0_af_50_6:O OD0_af_51_6:O OD0_af_52_6:O OD0_af_53_6:O OD0_aa:I OD1_at_50_6:O OD1_at_51_6:O OD1_at_52_6:O OD1_at_53_6:O OD1_af_50_6:O OD1_af_51_6:O OD1_af_52_6:O OD1_af_53_6:O OD1_aa:I OD2_at_50_6:O OD2_at_51_6:O OD2_at_52_6:O OD2_at_53_6:O OD2_af_50_6:O OD2_af_51_6:O OD2_af_52_6:O OD2_af_53_6:O OD2_aa:I OD3_at_50_6:O OD3_at_51_6:O OD3_at_52_6:O OD3_at_53_6:O OD3_af_50_6:O OD3_af_51_6:O OD3_af_52_6:O OD3_af_53_6:O OD3_aa:I Ch_at_50_6:O Ch_at_51_6:O Ch_at_52_6:O Ch_at_53_6:O Ch_af_50_6:O Ch_af_51_6:O Ch_af_52_6:O Ch_af_53_6:O Ch_aa:I
*.POWER VDD Vdd
*.POWER GND GND
*.POWER NSUB GND
*.POWER PSUB Vdd
*
* --- node flags ---
*
* __ia (combinational)
* update_aI_aa (combinational)
* child0_aI_aa (combinational)
* child1_aI_aa (combinational)
* child2_aI_aa (combinational)
* child3_aI_aa (combinational)
* I_aa (combinational)
*
* --- end node flags ---
*
M0_ Vdd update_aI_aa #6 Vdd pmos W=0.1625U L=0.065U
M1_ Vdd __ia I_aa Vdd pmos W=0.1625U L=0.065U
M2_ GND update_aI_aa __ia GND nmos W=0.0975U L=0.065U
M3_ GND child0_aI_aa __ia GND nmos W=0.0975U L=0.065U
M4_ GND child1_aI_aa __ia GND nmos W=0.0975U L=0.065U
M5_ GND child2_aI_aa __ia GND nmos W=0.0975U L=0.065U
M6_ GND child3_aI_aa __ia GND nmos W=0.0975U L=0.065U
M7_ GND __ia I_aa GND nmos W=0.0975U L=0.065U
M8_ #3 child3_aI_aa __ia Vdd pmos W=0.1625U L=0.065U
M9_ #4 child2_aI_aa #3 Vdd pmos W=0.1625U L=0.065U
M10_ #5 child1_aI_aa #4 Vdd pmos W=0.1625U L=0.065U
M11_ #6 child0_aI_aa #5 Vdd pmos W=0.1625U L=0.065U
xod3 od3_aI0_at_50_6 od3_aI0_at_51_6 od3_aI0_at_52_6 od3_aI0_at_53_6 od3_aI0_af_50_6 od3_aI0_af_51_6 od3_aI0_af_52_6 od3_aI0_af_53_6 od3_aI0_aa od3_aI1_at_50_6 od3_aI1_at_51_6 od3_aI1_at_52_6 od3_aI1_at_53_6 od3_aI1_af_50_6 od3_aI1_af_51_6 od3_aI1_af_52_6 od3_aI1_af_53_6 od3_aI1_aa OD3_at_50_6 OD3_at_51_6 OD3_at_52_6 OD3_at_53_6 OD3_af_50_6 OD3_af_51_6 OD3_af_52_6 OD3_af_53_6 OD3_aa Merge_34_7f_4
xchild2 reset I_at_50_6 I_at_51_6 I_at_52_6 I_at_53_6 I_af_50_6 I_af_51_6 I_af_52_6 I_af_53_6 child2_aI_aa Cnt2_areq Cnt2_at_50_6 Cnt2_at_51_6 Cnt2_at_52_6 Cnt2_at_53_6 Cnt2_at_54_6 Cnt2_at_55_6 Cnt2_at_56_6 Cnt2_at_57_6 Cnt2_af_50_6 Cnt2_af_51_6 Cnt2_af_52_6 Cnt2_af_53_6 Cnt2_af_54_6 Cnt2_af_55_6 Cnt2_af_56_6 Cnt2_af_57_6 q2_aR_areq q2_aR_at_50_6 q2_aR_at_51_6 q2_aR_at_52_6 q2_aR_at_53_6 q2_aR_at_54_6 q2_aR_at_55_6 q2_aR_at_56_6 q2_aR_at_57_6 q2_aR_af_50_6 q2_aR_af_51_6 q2_aR_af_52_6 q2_aR_af_53_6 q2_aR_af_54_6 q2_aR_af_55_6 q2_aR_af_56_6 q2_aR_af_57_6 od2_aI1_at_50_6 od2_aI1_at_51_6 od2_aI1_at_52_6 od2_aI1_at_53_6 od2_aI1_af_50_6 od2_aI1_af_51_6 od2_aI1_af_52_6 od2_aI1_af_53_6 od2_aI1_aa OC2_at_50_6 OC2_at_51_6 OC2_at_52_6 OC2_at_53_6 OC2_af_50_6 OC2_af_51_6 OC2_af_52_6 OC2_af_53_6 OC2_aa q2_aW1_at_50_6 q2_aW1_at_51_6 q2_aW1_at_52_6 q2_aW1_at_53_6 q2_aW1_at_54_6 q2_aW1_at_55_6 q2_aW1_at_56_6 q2_aW1_at_57_6 q2_aW1_af_50_6 q2_aW1_af_51_6 q2_aW1_af_52_6 q2_aW1_af_53_6 q2_aW1_af_54_6 q2_aW1_af_55_6 q2_aW1_af_56_6 q2_aW1_af_57_6 q2_aW1_aa seq_aA3_areq seq_aA3_aa ChildServer
xchild1 reset I_at_50_6 I_at_51_6 I_at_52_6 I_at_53_6 I_af_50_6 I_af_51_6 I_af_52_6 I_af_53_6 child1_aI_aa Cnt1_areq Cnt1_at_50_6 Cnt1_at_51_6 Cnt1_at_52_6 Cnt1_at_53_6 Cnt1_at_54_6 Cnt1_at_55_6 Cnt1_at_56_6 Cnt1_at_57_6 Cnt1_af_50_6 Cnt1_af_51_6 Cnt1_af_52_6 Cnt1_af_53_6 Cnt1_af_54_6 Cnt1_af_55_6 Cnt1_af_56_6 Cnt1_af_57_6 q1_aR_areq q1_aR_at_50_6 q1_aR_at_51_6 q1_aR_at_52_6 q1_aR_at_53_6 q1_aR_at_54_6 q1_aR_at_55_6 q1_aR_at_56_6 q1_aR_at_57_6 q1_aR_af_50_6 q1_aR_af_51_6 q1_aR_af_52_6 q1_aR_af_53_6 q1_aR_af_54_6 q1_aR_af_55_6 q1_aR_af_56_6 q1_aR_af_57_6 od1_aI1_at_50_6 od1_aI1_at_51_6 od1_aI1_at_52_6 od1_aI1_at_53_6 od1_aI1_af_50_6 od1_aI1_af_51_6 od1_aI1_af_52_6 od1_aI1_af_53_6 od1_aI1_aa OC1_at_50_6 OC1_at_51_6 OC1_at_52_6 OC1_at_53_6 OC1_af_50_6 OC1_af_51_6 OC1_af_52_6 OC1_af_53_6 OC1_aa q1_aW1_at_50_6 q1_aW1_at_51_6 q1_aW1_at_52_6 q1_aW1_at_53_6 q1_aW1_at_54_6 q1_aW1_at_55_6 q1_aW1_at_56_6 q1_aW1_at_57_6 q1_aW1_af_50_6 q1_aW1_af_51_6 q1_aW1_af_52_6 q1_aW1_af_53_6 q1_aW1_af_54_6 q1_aW1_af_55_6 q1_aW1_af_56_6 q1_aW1_af_57_6 q1_aW1_aa seq_aA2_areq seq_aA2_aa ChildServer
xseq reset seq_aA0_areq seq_aA0_aa seq_aA1_areq seq_aA1_aa seq_aA2_areq seq_aA2_aa seq_aA3_areq seq_aA3_aa seq_aA4_areq seq_aA4_aa seq_aA5_aa seq_aA5_aa seq_aA6_aa seq_aA6_aa Seq7
xq0 reset q0_aW0_at_50_6 q0_aW0_at_51_6 q0_aW0_at_52_6 q0_aW0_at_53_6 q0_aW0_at_54_6 q0_aW0_at_55_6 q0_aW0_at_56_6 q0_aW0_at_57_6 q0_aW0_af_50_6 q0_aW0_af_51_6 q0_aW0_af_52_6 q0_aW0_af_53_6 q0_aW0_af_54_6 q0_aW0_af_55_6 q0_aW0_af_56_6 q0_aW0_af_57_6 q0_aW0_aa q0_aW1_at_50_6 q0_aW1_at_51_6 q0_aW1_at_52_6 q0_aW1_at_53_6 q0_aW1_at_54_6 q0_aW1_at_55_6 q0_aW1_at_56_6 q0_aW1_at_57_6 q0_aW1_af_50_6 q0_aW1_af_51_6 q0_aW1_af_52_6 q0_aW1_af_53_6 q0_aW1_af_54_6 q0_aW1_af_55_6 q0_aW1_af_56_6 q0_aW1_af_57_6 q0_aW1_aa q0_aR_areq q0_aR_at_50_6 q0_aR_at_51_6 q0_aR_at_52_6 q0_aR_at_53_6 q0_aR_at_54_6 q0_aR_at_55_6 q0_aR_at_56_6 q0_aR_at_57_6 q0_aR_af_50_6 q0_aR_af_51_6 q0_aR_af_52_6 q0_aR_af_53_6 q0_aR_af_54_6 q0_aR_af_55_6 q0_aR_af_56_6 q0_aR_af_57_6 QVar
xod0 od0_aI0_at_50_6 od0_aI0_at_51_6 od0_aI0_at_52_6 od0_aI0_at_53_6 od0_aI0_af_50_6 od0_aI0_af_51_6 od0_aI0_af_52_6 od0_aI0_af_53_6 od0_aI0_aa od0_aI1_at_50_6 od0_aI1_at_51_6 od0_aI1_at_52_6 od0_aI1_at_53_6 od0_aI1_af_50_6 od0_aI1_af_51_6 od0_aI1_af_52_6 od0_aI1_af_53_6 od0_aI1_aa OD0_at_50_6 OD0_at_51_6 OD0_at_52_6 OD0_at_53_6 OD0_af_50_6 OD0_af_51_6 OD0_af_52_6 OD0_af_53_6 OD0_aa Merge_34_7f_4
xod2 od2_aI0_at_50_6 od2_aI0_at_51_6 od2_aI0_at_52_6 od2_aI0_at_53_6 od2_aI0_af_50_6 od2_aI0_af_51_6 od2_aI0_af_52_6 od2_aI0_af_53_6 od2_aI0_aa od2_aI1_at_50_6 od2_aI1_at_51_6 od2_aI1_at_52_6 od2_aI1_at_53_6 od2_aI1_af_50_6 od2_aI1_af_51_6 od2_aI1_af_52_6 od2_aI1_af_53_6 od2_aI1_aa OD2_at_50_6 OD2_at_51_6 OD2_at_52_6 OD2_at_53_6 OD2_af_50_6 OD2_af_51_6 OD2_af_52_6 OD2_af_53_6 OD2_aa Merge_34_7f_4
xod1 od1_aI0_at_50_6 od1_aI0_at_51_6 od1_aI0_at_52_6 od1_aI0_at_53_6 od1_aI0_af_50_6 od1_aI0_af_51_6 od1_aI0_af_52_6 od1_aI0_af_53_6 od1_aI0_aa od1_aI1_at_50_6 od1_aI1_at_51_6 od1_aI1_at_52_6 od1_aI1_at_53_6 od1_aI1_af_50_6 od1_aI1_af_51_6 od1_aI1_af_52_6 od1_aI1_af_53_6 od1_aI1_aa OD1_at_50_6 OD1_at_51_6 OD1_at_52_6 OD1_at_53_6 OD1_af_50_6 OD1_af_51_6 OD1_af_52_6 OD1_af_53_6 OD1_aa Merge_34_7f_4
xq1 reset q1_aW0_at_50_6 q1_aW0_at_51_6 q1_aW0_at_52_6 q1_aW0_at_53_6 q1_aW0_at_54_6 q1_aW0_at_55_6 q1_aW0_at_56_6 q1_aW0_at_57_6 q1_aW0_af_50_6 q1_aW0_af_51_6 q1_aW0_af_52_6 q1_aW0_af_53_6 q1_aW0_af_54_6 q1_aW0_af_55_6 q1_aW0_af_56_6 q1_aW0_af_57_6 q1_aW0_aa q1_aW1_at_50_6 q1_aW1_at_51_6 q1_aW1_at_52_6 q1_aW1_at_53_6 q1_aW1_at_54_6 q1_aW1_at_55_6 q1_aW1_at_56_6 q1_aW1_at_57_6 q1_aW1_af_50_6 q1_aW1_af_51_6 q1_aW1_af_52_6 q1_aW1_af_53_6 q1_aW1_af_54_6 q1_aW1_af_55_6 q1_aW1_af_56_6 q1_aW1_af_57_6 q1_aW1_aa q1_aR_areq q1_aR_at_50_6 q1_aR_at_51_6 q1_aR_at_52_6 q1_aR_at_53_6 q1_aR_at_54_6 q1_aR_at_55_6 q1_aR_at_56_6 q1_aR_at_57_6 q1_aR_af_50_6 q1_aR_af_51_6 q1_aR_af_52_6 q1_aR_af_53_6 q1_aR_af_54_6 q1_aR_af_55_6 q1_aR_af_56_6 q1_aR_af_57_6 QVar
xupdate reset I_at_50_6 I_at_51_6 I_at_52_6 I_at_53_6 I_af_50_6 I_af_51_6 I_af_52_6 I_af_53_6 update_aI_aa od0_aI0_at_50_6 od0_aI0_at_51_6 od0_aI0_at_52_6 od0_aI0_at_53_6 od0_aI0_af_50_6 od0_aI0_af_51_6 od0_aI0_af_52_6 od0_aI0_af_53_6 od0_aI0_aa od1_aI0_at_50_6 od1_aI0_at_51_6 od1_aI0_at_52_6 od1_aI0_at_53_6 od1_aI0_af_50_6 od1_aI0_af_51_6 od1_aI0_af_52_6 od1_aI0_af_53_6 od1_aI0_aa od2_aI0_at_50_6 od2_aI0_at_51_6 od2_aI0_at_52_6 od2_aI0_at_53_6 od2_aI0_af_50_6 od2_aI0_af_51_6 od2_aI0_af_52_6 od2_aI0_af_53_6 od2_aI0_aa od3_aI0_at_50_6 od3_aI0_at_51_6 od3_aI0_at_52_6 od3_aI0_at_53_6 od3_aI0_af_50_6 od3_aI0_af_51_6 od3_aI0_af_52_6 od3_aI0_af_53_6 od3_aI0_aa q0_aW0_at_50_6 q0_aW0_at_51_6 q0_aW0_at_52_6 q0_aW0_at_53_6 q0_aW0_at_54_6 q0_aW0_at_55_6 q0_aW0_at_56_6 q0_aW0_at_57_6 q0_aW0_af_50_6 q0_aW0_af_51_6 q0_aW0_af_52_6 q0_aW0_af_53_6 q0_aW0_af_54_6 q0_aW0_af_55_6 q0_aW0_af_56_6 q0_aW0_af_57_6 q0_aW0_aa q1_aW0_at_50_6 q1_aW0_at_51_6 q1_aW0_at_52_6 q1_aW0_at_53_6 q1_aW0_at_54_6 q1_aW0_at_55_6 q1_aW0_at_56_6 q1_aW0_at_57_6 q1_aW0_af_50_6 q1_aW0_af_51_6 q1_aW0_af_52_6 q1_aW0_af_53_6 q1_aW0_af_54_6 q1_aW0_af_55_6 q1_aW0_af_56_6 q1_aW0_af_57_6 q1_aW0_aa q2_aW0_at_50_6 q2_aW0_at_51_6 q2_aW0_at_52_6 q2_aW0_at_53_6 q2_aW0_at_54_6 q2_aW0_at_55_6 q2_aW0_at_56_6 q2_aW0_at_57_6 q2_aW0_af_50_6 q2_aW0_af_51_6 q2_aW0_af_52_6 q2_aW0_af_53_6 q2_aW0_af_54_6 q2_aW0_af_55_6 q2_aW0_af_56_6 q2_aW0_af_57_6 q2_aW0_aa q3_aW0_at_50_6 q3_aW0_at_51_6 q3_aW0_at_52_6 q3_aW0_at_53_6 q3_aW0_at_54_6 q3_aW0_at_55_6 q3_aW0_at_56_6 q3_aW0_at_57_6 q3_aW0_af_50_6 q3_aW0_af_51_6 q3_aW0_af_52_6 q3_aW0_af_53_6 q3_aW0_af_54_6 q3_aW0_af_55_6 q3_aW0_af_56_6 q3_aW0_af_57_6 q3_aW0_aa Ch_at_50_6 Ch_at_51_6 Ch_at_52_6 Ch_at_53_6 Ch_af_50_6 Ch_af_51_6 Ch_af_52_6 Ch_af_53_6 Ch_aa seq_aA0_areq seq_aA0_aa SUpdate
xq3 reset q3_aW0_at_50_6 q3_aW0_at_51_6 q3_aW0_at_52_6 q3_aW0_at_53_6 q3_aW0_at_54_6 q3_aW0_at_55_6 q3_aW0_at_56_6 q3_aW0_at_57_6 q3_aW0_af_50_6 q3_aW0_af_51_6 q3_aW0_af_52_6 q3_aW0_af_53_6 q3_aW0_af_54_6 q3_aW0_af_55_6 q3_aW0_af_56_6 q3_aW0_af_57_6 q3_aW0_aa q3_aW1_at_50_6 q3_aW1_at_51_6 q3_aW1_at_52_6 q3_aW1_at_53_6 q3_aW1_at_54_6 q3_aW1_at_55_6 q3_aW1_at_56_6 q3_aW1_at_57_6 q3_aW1_af_50_6 q3_aW1_af_51_6 q3_aW1_af_52_6 q3_aW1_af_53_6 q3_aW1_af_54_6 q3_aW1_af_55_6 q3_aW1_af_56_6 q3_aW1_af_57_6 q3_aW1_aa q3_aR_areq q3_aR_at_50_6 q3_aR_at_51_6 q3_aR_at_52_6 q3_aR_at_53_6 q3_aR_at_54_6 q3_aR_at_55_6 q3_aR_at_56_6 q3_aR_at_57_6 q3_aR_af_50_6 q3_aR_af_51_6 q3_aR_af_52_6 q3_aR_af_53_6 q3_aR_af_54_6 q3_aR_af_55_6 q3_aR_af_56_6 q3_aR_af_57_6 QVar
xq2 reset q2_aW0_at_50_6 q2_aW0_at_51_6 q2_aW0_at_52_6 q2_aW0_at_53_6 q2_aW0_at_54_6 q2_aW0_at_55_6 q2_aW0_at_56_6 q2_aW0_at_57_6 q2_aW0_af_50_6 q2_aW0_af_51_6 q2_aW0_af_52_6 q2_aW0_af_53_6 q2_aW0_af_54_6 q2_aW0_af_55_6 q2_aW0_af_56_6 q2_aW0_af_57_6 q2_aW0_aa q2_aW1_at_50_6 q2_aW1_at_51_6 q2_aW1_at_52_6 q2_aW1_at_53_6 q2_aW1_at_54_6 q2_aW1_at_55_6 q2_aW1_at_56_6 q2_aW1_at_57_6 q2_aW1_af_50_6 q2_aW1_af_51_6 q2_aW1_af_52_6 q2_aW1_af_53_6 q2_aW1_af_54_6 q2_aW1_af_55_6 q2_aW1_af_56_6 q2_aW1_af_57_6 q2_aW1_aa q2_aR_areq q2_aR_at_50_6 q2_aR_at_51_6 q2_aR_at_52_6 q2_aR_at_53_6 q2_aR_at_54_6 q2_aR_at_55_6 q2_aR_at_56_6 q2_aR_at_57_6 q2_aR_af_50_6 q2_aR_af_51_6 q2_aR_af_52_6 q2_aR_af_53_6 q2_aR_af_54_6 q2_aR_af_55_6 q2_aR_af_56_6 q2_aR_af_57_6 QVar
xchild0 reset I_at_50_6 I_at_51_6 I_at_52_6 I_at_53_6 I_af_50_6 I_af_51_6 I_af_52_6 I_af_53_6 child0_aI_aa Cnt0_areq Cnt0_at_50_6 Cnt0_at_51_6 Cnt0_at_52_6 Cnt0_at_53_6 Cnt0_at_54_6 Cnt0_at_55_6 Cnt0_at_56_6 Cnt0_at_57_6 Cnt0_af_50_6 Cnt0_af_51_6 Cnt0_af_52_6 Cnt0_af_53_6 Cnt0_af_54_6 Cnt0_af_55_6 Cnt0_af_56_6 Cnt0_af_57_6 q0_aR_areq q0_aR_at_50_6 q0_aR_at_51_6 q0_aR_at_52_6 q0_aR_at_53_6 q0_aR_at_54_6 q0_aR_at_55_6 q0_aR_at_56_6 q0_aR_at_57_6 q0_aR_af_50_6 q0_aR_af_51_6 q0_aR_af_52_6 q0_aR_af_53_6 q0_aR_af_54_6 q0_aR_af_55_6 q0_aR_af_56_6 q0_aR_af_57_6 od0_aI1_at_50_6 od0_aI1_at_51_6 od0_aI1_at_52_6 od0_aI1_at_53_6 od0_aI1_af_50_6 od0_aI1_af_51_6 od0_aI1_af_52_6 od0_aI1_af_53_6 od0_aI1_aa OC0_at_50_6 OC0_at_51_6 OC0_at_52_6 OC0_at_53_6 OC0_af_50_6 OC0_af_51_6 OC0_af_52_6 OC0_af_53_6 OC0_aa q0_aW1_at_50_6 q0_aW1_at_51_6 q0_aW1_at_52_6 q0_aW1_at_53_6 q0_aW1_at_54_6 q0_aW1_at_55_6 q0_aW1_at_56_6 q0_aW1_at_57_6 q0_aW1_af_50_6 q0_aW1_af_51_6 q0_aW1_af_52_6 q0_aW1_af_53_6 q0_aW1_af_54_6 q0_aW1_af_55_6 q0_aW1_af_56_6 q0_aW1_af_57_6 q0_aW1_aa seq_aA1_areq seq_aA1_aa ChildServer
xchild3 reset I_at_50_6 I_at_51_6 I_at_52_6 I_at_53_6 I_af_50_6 I_af_51_6 I_af_52_6 I_af_53_6 child3_aI_aa Cnt3_areq Cnt3_at_50_6 Cnt3_at_51_6 Cnt3_at_52_6 Cnt3_at_53_6 Cnt3_at_54_6 Cnt3_at_55_6 Cnt3_at_56_6 Cnt3_at_57_6 Cnt3_af_50_6 Cnt3_af_51_6 Cnt3_af_52_6 Cnt3_af_53_6 Cnt3_af_54_6 Cnt3_af_55_6 Cnt3_af_56_6 Cnt3_af_57_6 q3_aR_areq q3_aR_at_50_6 q3_aR_at_51_6 q3_aR_at_52_6 q3_aR_at_53_6 q3_aR_at_54_6 q3_aR_at_55_6 q3_aR_at_56_6 q3_aR_at_57_6 q3_aR_af_50_6 q3_aR_af_51_6 q3_aR_af_52_6 q3_aR_af_53_6 q3_aR_af_54_6 q3_aR_af_55_6 q3_aR_af_56_6 q3_aR_af_57_6 od3_aI1_at_50_6 od3_aI1_at_51_6 od3_aI1_at_52_6 od3_aI1_at_53_6 od3_aI1_af_50_6 od3_aI1_af_51_6 od3_aI1_af_52_6 od3_aI1_af_53_6 od3_aI1_aa OC3_at_50_6 OC3_at_51_6 OC3_at_52_6 OC3_at_53_6 OC3_af_50_6 OC3_af_51_6 OC3_af_52_6 OC3_af_53_6 OC3_aa q3_aW1_at_50_6 q3_aW1_at_51_6 q3_aW1_at_52_6 q3_aW1_at_53_6 q3_aW1_at_54_6 q3_aW1_at_55_6 q3_aW1_at_56_6 q3_aW1_at_57_6 q3_aW1_af_50_6 q3_aW1_af_51_6 q3_aW1_af_52_6 q3_aW1_af_53_6 q3_aW1_af_54_6 q3_aW1_af_55_6 q3_aW1_af_56_6 q3_aW1_af_57_6 q3_aW1_aa seq_aA4_areq seq_aA4_aa ChildServer
.ends
*---- end of process: QuadRouter<> -----
*
*---- act defproc: InputRouter<> -----
* raw ports:  reset I.t[0] I.t[1] I.t[2] I.t[3] I.t[4] I.t[5] I.t[6] I.t[7] I.t[8] I.t[9] I.t[10] I.t[11] I.t[12] I.t[13] I.t[14] I.t[15] I.t[16] I.t[17] I.t[18] I.t[19] I.t[20] I.t[21] I.t[22] I.t[23] I.t[24] I.t[25] I.t[26] I.t[27] I.t[28] I.t[29] I.t[30] I.t[31] I.f[0] I.f[1] I.f[2] I.f[3] I.f[4] I.f[5] I.f[6] I.f[7] I.f[8] I.f[9] I.f[10] I.f[11] I.f[12] I.f[13] I.f[14] I.f[15] I.f[16] I.f[17] I.f[18] I.f[19] I.f[20] I.f[21] I.f[22] I.f[23] I.f[24] I.f[25] I.f[26] I.f[27] I.f[28] I.f[29] I.f[30] I.f[31] I.a O0.t[0] O0.t[1] O0.t[2] O0.t[3] O0.t[4] O0.t[5] O0.t[6] O0.t[7] O0.t[8] O0.t[9] O0.t[10] O0.t[11] O0.t[12] O0.t[13] O0.t[14] O0.t[15] O0.t[16] O0.t[17] O0.t[18] O0.t[19] O0.t[20] O0.t[21] O0.t[22] O0.t[23] O0.t[24] O0.t[25] O0.t[26] O0.t[27] O0.t[28] O0.t[29] O0.t[30] O0.t[31] O0.f[0] O0.f[1] O0.f[2] O0.f[3] O0.f[4] O0.f[5] O0.f[6] O0.f[7] O0.f[8] O0.f[9] O0.f[10] O0.f[11] O0.f[12] O0.f[13] O0.f[14] O0.f[15] O0.f[16] O0.f[17] O0.f[18] O0.f[19] O0.f[20] O0.f[21] O0.f[22] O0.f[23] O0.f[24] O0.f[25] O0.f[26] O0.f[27] O0.f[28] O0.f[29] O0.f[30] O0.f[31] O0.a O1.t[0] O1.t[1] O1.t[2] O1.t[3] O1.t[4] O1.t[5] O1.t[6] O1.t[7] O1.t[8] O1.t[9] O1.t[10] O1.t[11] O1.t[12] O1.t[13] O1.t[14] O1.t[15] O1.t[16] O1.t[17] O1.t[18] O1.t[19] O1.t[20] O1.t[21] O1.t[22] O1.t[23] O1.t[24] O1.t[25] O1.t[26] O1.t[27] O1.t[28] O1.t[29] O1.t[30] O1.t[31] O1.f[0] O1.f[1] O1.f[2] O1.f[3] O1.f[4] O1.f[5] O1.f[6] O1.f[7] O1.f[8] O1.f[9] O1.f[10] O1.f[11] O1.f[12] O1.f[13] O1.f[14] O1.f[15] O1.f[16] O1.f[17] O1.f[18] O1.f[19] O1.f[20] O1.f[21] O1.f[22] O1.f[23] O1.f[24] O1.f[25] O1.f[26] O1.f[27] O1.f[28] O1.f[29] O1.f[30] O1.f[31] O1.a
*
.subckt InputRouter reset I_at_50_6 I_at_51_6 I_at_52_6 I_at_53_6 I_at_54_6 I_at_55_6 I_at_56_6 I_at_57_6 I_at_58_6 I_at_59_6 I_at_510_6 I_at_511_6 I_at_512_6 I_at_513_6 I_at_514_6 I_at_515_6 I_at_516_6 I_at_517_6 I_at_518_6 I_at_519_6 I_at_520_6 I_at_521_6 I_at_522_6 I_at_523_6 I_at_524_6 I_at_525_6 I_at_526_6 I_at_527_6 I_at_528_6 I_at_529_6 I_at_530_6 I_at_531_6 I_af_50_6 I_af_51_6 I_af_52_6 I_af_53_6 I_af_54_6 I_af_55_6 I_af_56_6 I_af_57_6 I_af_58_6 I_af_59_6 I_af_510_6 I_af_511_6 I_af_512_6 I_af_513_6 I_af_514_6 I_af_515_6 I_af_516_6 I_af_517_6 I_af_518_6 I_af_519_6 I_af_520_6 I_af_521_6 I_af_522_6 I_af_523_6 I_af_524_6 I_af_525_6 I_af_526_6 I_af_527_6 I_af_528_6 I_af_529_6 I_af_530_6 I_af_531_6 I_aa O0_at_50_6 O0_at_51_6 O0_at_52_6 O0_at_53_6 O0_at_54_6 O0_at_55_6 O0_at_56_6 O0_at_57_6 O0_at_58_6 O0_at_59_6 O0_at_510_6 O0_at_511_6 O0_at_512_6 O0_at_513_6 O0_at_514_6 O0_at_515_6 O0_at_516_6 O0_at_517_6 O0_at_518_6 O0_at_519_6 O0_at_520_6 O0_at_521_6 O0_at_522_6 O0_at_523_6 O0_at_524_6 O0_at_525_6 O0_at_526_6 O0_at_527_6 O0_at_528_6 O0_at_529_6 O0_at_530_6 O0_at_531_6 O0_af_50_6 O0_af_51_6 O0_af_52_6 O0_af_53_6 O0_af_54_6 O0_af_55_6 O0_af_56_6 O0_af_57_6 O0_af_58_6 O0_af_59_6 O0_af_510_6 O0_af_511_6 O0_af_512_6 O0_af_513_6 O0_af_514_6 O0_af_515_6 O0_af_516_6 O0_af_517_6 O0_af_518_6 O0_af_519_6 O0_af_520_6 O0_af_521_6 O0_af_522_6 O0_af_523_6 O0_af_524_6 O0_af_525_6 O0_af_526_6 O0_af_527_6 O0_af_528_6 O0_af_529_6 O0_af_530_6 O0_af_531_6 O0_aa O1_at_50_6 O1_at_51_6 O1_at_52_6 O1_at_53_6 O1_at_54_6 O1_at_55_6 O1_at_56_6 O1_at_57_6 O1_at_58_6 O1_at_59_6 O1_at_510_6 O1_at_511_6 O1_at_512_6 O1_at_513_6 O1_at_514_6 O1_at_515_6 O1_at_516_6 O1_at_517_6 O1_at_518_6 O1_at_519_6 O1_at_520_6 O1_at_521_6 O1_at_522_6 O1_at_523_6 O1_at_524_6 O1_at_525_6 O1_at_526_6 O1_at_527_6 O1_at_528_6 O1_at_529_6 O1_at_530_6 O1_at_531_6 O1_af_50_6 O1_af_51_6 O1_af_52_6 O1_af_53_6 O1_af_54_6 O1_af_55_6 O1_af_56_6 O1_af_57_6 O1_af_58_6 O1_af_59_6 O1_af_510_6 O1_af_511_6 O1_af_512_6 O1_af_513_6 O1_af_514_6 O1_af_515_6 O1_af_516_6 O1_af_517_6 O1_af_518_6 O1_af_519_6 O1_af_520_6 O1_af_521_6 O1_af_522_6 O1_af_523_6 O1_af_524_6 O1_af_525_6 O1_af_526_6 O1_af_527_6 O1_af_528_6 O1_af_529_6 O1_af_530_6 O1_af_531_6 O1_aa
*.PININFO reset:I I_at_50_6:I I_at_51_6:I I_at_52_6:I I_at_53_6:I I_at_54_6:I I_at_55_6:I I_at_56_6:I I_at_57_6:I I_at_58_6:I I_at_59_6:I I_at_510_6:I I_at_511_6:I I_at_512_6:I I_at_513_6:I I_at_514_6:I I_at_515_6:I I_at_516_6:I I_at_517_6:I I_at_518_6:I I_at_519_6:I I_at_520_6:I I_at_521_6:I I_at_522_6:I I_at_523_6:I I_at_524_6:I I_at_525_6:I I_at_526_6:I I_at_527_6:I I_at_528_6:I I_at_529_6:I I_at_530_6:I I_at_531_6:I I_af_50_6:I I_af_51_6:I I_af_52_6:I I_af_53_6:I I_af_54_6:I I_af_55_6:I I_af_56_6:I I_af_57_6:I I_af_58_6:I I_af_59_6:I I_af_510_6:I I_af_511_6:I I_af_512_6:I I_af_513_6:I I_af_514_6:I I_af_515_6:I I_af_516_6:I I_af_517_6:I I_af_518_6:I I_af_519_6:I I_af_520_6:I I_af_521_6:I I_af_522_6:I I_af_523_6:I I_af_524_6:I I_af_525_6:I I_af_526_6:I I_af_527_6:I I_af_528_6:I I_af_529_6:I I_af_530_6:I I_af_531_6:I I_aa:O O0_at_50_6:O O0_at_51_6:O O0_at_52_6:O O0_at_53_6:O O0_at_54_6:O O0_at_55_6:O O0_at_56_6:O O0_at_57_6:O O0_at_58_6:O O0_at_59_6:O O0_at_510_6:O O0_at_511_6:O O0_at_512_6:O O0_at_513_6:O O0_at_514_6:O O0_at_515_6:O O0_at_516_6:O O0_at_517_6:O O0_at_518_6:O O0_at_519_6:O O0_at_520_6:O O0_at_521_6:O O0_at_522_6:O O0_at_523_6:O O0_at_524_6:O O0_at_525_6:O O0_at_526_6:O O0_at_527_6:O O0_at_528_6:O O0_at_529_6:O O0_at_530_6:O O0_at_531_6:O O0_af_50_6:O O0_af_51_6:O O0_af_52_6:O O0_af_53_6:O O0_af_54_6:O O0_af_55_6:O O0_af_56_6:O O0_af_57_6:O O0_af_58_6:O O0_af_59_6:O O0_af_510_6:O O0_af_511_6:O O0_af_512_6:O O0_af_513_6:O O0_af_514_6:O O0_af_515_6:O O0_af_516_6:O O0_af_517_6:O O0_af_518_6:O O0_af_519_6:O O0_af_520_6:O O0_af_521_6:O O0_af_522_6:O O0_af_523_6:O O0_af_524_6:O O0_af_525_6:O O0_af_526_6:O O0_af_527_6:O O0_af_528_6:O O0_af_529_6:O O0_af_530_6:O O0_af_531_6:O O0_aa:I O1_at_50_6:O O1_at_51_6:O O1_at_52_6:O O1_at_53_6:O O1_at_54_6:O O1_at_55_6:O O1_at_56_6:O O1_at_57_6:O O1_at_58_6:O O1_at_59_6:O O1_at_510_6:O O1_at_511_6:O O1_at_512_6:O O1_at_513_6:O O1_at_514_6:O O1_at_515_6:O O1_at_516_6:O O1_at_517_6:O O1_at_518_6:O O1_at_519_6:O O1_at_520_6:O O1_at_521_6:O O1_at_522_6:O O1_at_523_6:O O1_at_524_6:O O1_at_525_6:O O1_at_526_6:O O1_at_527_6:O O1_at_528_6:O O1_at_529_6:O O1_at_530_6:O O1_at_531_6:O O1_af_50_6:O O1_af_51_6:O O1_af_52_6:O O1_af_53_6:O O1_af_54_6:O O1_af_55_6:O O1_af_56_6:O O1_af_57_6:O O1_af_58_6:O O1_af_59_6:O O1_af_510_6:O O1_af_511_6:O O1_af_512_6:O O1_af_513_6:O O1_af_514_6:O O1_af_515_6:O O1_af_516_6:O O1_af_517_6:O O1_af_518_6:O O1_af_519_6:O O1_af_520_6:O O1_af_521_6:O O1_af_522_6:O O1_af_523_6:O O1_af_524_6:O O1_af_525_6:O O1_af_526_6:O O1_af_527_6:O O1_af_528_6:O O1_af_529_6:O O1_af_530_6:O O1_af_531_6:O O1_aa:I
*.POWER VDD Vdd
*.POWER GND GND
*.POWER NSUB GND
*.POWER PSUB Vdd
*
* --- node flags ---
*
* __w0 (state-holding): pup_reff=0.8; pdn_reff=1.33333
* __p (combinational)
* p (state-holding): pup_reff=0.8; pdn_reff=1.33333
* __a (combinational)
* __r (combinational)
* __w1 (state-holding): pup_reff=0.8; pdn_reff=3.33333
* a (state-holding): pup_reff=1.6; pdn_reff=1.33333
* __i__a (combinational)
* w1 (combinational)
* I_aa (state-holding): pup_reff=0.8; pdn_reff=2
* __o0a (combinational)
* __o1a (combinational)
* __o0t_50_6 (state-holding): pup_reff=0.4; pdn_reff=1.33333
* __o0f_50_6 (state-holding): pup_reff=0.4; pdn_reff=1.33333
* O1_at_50_6 (state-holding): pup_reff=0.8; pdn_reff=0.666667
* __i__t_50_6 (combinational)
* O1_af_50_6 (state-holding): pup_reff=0.8; pdn_reff=0.666667
* __i__f_50_6 (combinational)
* __o0t_51_6 (state-holding): pup_reff=0.4; pdn_reff=1.33333
* __o0f_51_6 (state-holding): pup_reff=0.4; pdn_reff=1.33333
* O1_at_51_6 (state-holding): pup_reff=0.8; pdn_reff=0.666667
* __i__t_51_6 (combinational)
* O1_af_51_6 (state-holding): pup_reff=0.8; pdn_reff=0.666667
* __i__f_51_6 (combinational)
* __o0t_52_6 (state-holding): pup_reff=0.4; pdn_reff=1.33333
* __o0f_52_6 (state-holding): pup_reff=0.4; pdn_reff=1.33333
* O1_at_52_6 (state-holding): pup_reff=0.8; pdn_reff=0.666667
* __i__t_52_6 (combinational)
* O1_af_52_6 (state-holding): pup_reff=0.8; pdn_reff=0.666667
* __i__f_52_6 (combinational)
* __o0t_53_6 (state-holding): pup_reff=0.4; pdn_reff=1.33333
* __o0f_53_6 (state-holding): pup_reff=0.4; pdn_reff=1.33333
* O1_at_53_6 (state-holding): pup_reff=0.8; pdn_reff=0.666667
* __i__t_53_6 (combinational)
* O1_af_53_6 (state-holding): pup_reff=0.8; pdn_reff=0.666667
* __i__f_53_6 (combinational)
* __o0t_54_6 (state-holding): pup_reff=0.4; pdn_reff=1.33333
* __o0f_54_6 (state-holding): pup_reff=0.4; pdn_reff=1.33333
* O1_at_54_6 (state-holding): pup_reff=0.8; pdn_reff=0.666667
* __i__t_54_6 (combinational)
* O1_af_54_6 (state-holding): pup_reff=0.8; pdn_reff=0.666667
* __i__f_54_6 (combinational)
* __o0t_55_6 (state-holding): pup_reff=0.4; pdn_reff=1.33333
* __o0f_55_6 (state-holding): pup_reff=0.4; pdn_reff=1.33333
* O1_at_55_6 (state-holding): pup_reff=0.8; pdn_reff=0.666667
* __i__t_55_6 (combinational)
* O1_af_55_6 (state-holding): pup_reff=0.8; pdn_reff=0.666667
* __i__f_55_6 (combinational)
* __o0t_56_6 (state-holding): pup_reff=0.4; pdn_reff=1.33333
* __o0f_56_6 (state-holding): pup_reff=0.4; pdn_reff=1.33333
* O1_at_56_6 (state-holding): pup_reff=0.8; pdn_reff=0.666667
* __i__t_56_6 (combinational)
* O1_af_56_6 (state-holding): pup_reff=0.8; pdn_reff=0.666667
* __i__f_56_6 (combinational)
* __o0t_57_6 (state-holding): pup_reff=0.4; pdn_reff=1.33333
* __o0f_57_6 (state-holding): pup_reff=0.4; pdn_reff=1.33333
* O1_at_57_6 (state-holding): pup_reff=0.8; pdn_reff=0.666667
* __i__t_57_6 (combinational)
* O1_af_57_6 (state-holding): pup_reff=0.8; pdn_reff=0.666667
* __i__f_57_6 (combinational)
* __o0t_58_6 (state-holding): pup_reff=0.4; pdn_reff=1.33333
* __o0f_58_6 (state-holding): pup_reff=0.4; pdn_reff=1.33333
* O1_at_58_6 (state-holding): pup_reff=0.8; pdn_reff=0.666667
* __i__t_58_6 (combinational)
* O1_af_58_6 (state-holding): pup_reff=0.8; pdn_reff=0.666667
* __i__f_58_6 (combinational)
* __o0t_59_6 (state-holding): pup_reff=0.4; pdn_reff=1.33333
* __o0f_59_6 (state-holding): pup_reff=0.4; pdn_reff=1.33333
* O1_at_59_6 (state-holding): pup_reff=0.8; pdn_reff=0.666667
* __i__t_59_6 (combinational)
* O1_af_59_6 (state-holding): pup_reff=0.8; pdn_reff=0.666667
* __i__f_59_6 (combinational)
* __o0t_510_6 (state-holding): pup_reff=0.4; pdn_reff=1.33333
* __o0f_510_6 (state-holding): pup_reff=0.4; pdn_reff=1.33333
* O1_at_510_6 (state-holding): pup_reff=0.8; pdn_reff=0.666667
* __i__t_510_6 (combinational)
* O1_af_510_6 (state-holding): pup_reff=0.8; pdn_reff=0.666667
* __i__f_510_6 (combinational)
* __o0t_511_6 (state-holding): pup_reff=0.4; pdn_reff=1.33333
* __o0f_511_6 (state-holding): pup_reff=0.4; pdn_reff=1.33333
* O1_at_511_6 (state-holding): pup_reff=0.8; pdn_reff=0.666667
* __i__t_511_6 (combinational)
* O1_af_511_6 (state-holding): pup_reff=0.8; pdn_reff=0.666667
* __i__f_511_6 (combinational)
* __o0t_512_6 (state-holding): pup_reff=0.4; pdn_reff=1.33333
* __o0f_512_6 (state-holding): pup_reff=0.4; pdn_reff=1.33333
* O1_at_512_6 (state-holding): pup_reff=0.8; pdn_reff=0.666667
* __i__t_512_6 (combinational)
* O1_af_512_6 (state-holding): pup_reff=0.8; pdn_reff=0.666667
* __i__f_512_6 (combinational)
* __o0t_513_6 (state-holding): pup_reff=0.4; pdn_reff=1.33333
* __o0f_513_6 (state-holding): pup_reff=0.4; pdn_reff=1.33333
* O1_at_513_6 (state-holding): pup_reff=0.8; pdn_reff=0.666667
* __i__t_513_6 (combinational)
* O1_af_513_6 (state-holding): pup_reff=0.8; pdn_reff=0.666667
* __i__f_513_6 (combinational)
* __o0t_514_6 (state-holding): pup_reff=0.4; pdn_reff=1.33333
* __o0f_514_6 (state-holding): pup_reff=0.4; pdn_reff=1.33333
* O1_at_514_6 (state-holding): pup_reff=0.8; pdn_reff=0.666667
* __i__t_514_6 (combinational)
* O1_af_514_6 (state-holding): pup_reff=0.8; pdn_reff=0.666667
* __i__f_514_6 (combinational)
* __o0t_515_6 (state-holding): pup_reff=0.4; pdn_reff=1.33333
* __o0f_515_6 (state-holding): pup_reff=0.4; pdn_reff=1.33333
* O1_at_515_6 (state-holding): pup_reff=0.8; pdn_reff=0.666667
* __i__t_515_6 (combinational)
* O1_af_515_6 (state-holding): pup_reff=0.8; pdn_reff=0.666667
* __i__f_515_6 (combinational)
* __o0t_516_6 (state-holding): pup_reff=0.4; pdn_reff=1.33333
* __o0f_516_6 (state-holding): pup_reff=0.4; pdn_reff=1.33333
* O1_at_516_6 (state-holding): pup_reff=0.8; pdn_reff=0.666667
* __i__t_516_6 (combinational)
* O1_af_516_6 (state-holding): pup_reff=0.8; pdn_reff=0.666667
* __i__f_516_6 (combinational)
* __o0t_517_6 (state-holding): pup_reff=0.4; pdn_reff=1.33333
* __o0f_517_6 (state-holding): pup_reff=0.4; pdn_reff=1.33333
* O1_at_517_6 (state-holding): pup_reff=0.8; pdn_reff=0.666667
* __i__t_517_6 (combinational)
* O1_af_517_6 (state-holding): pup_reff=0.8; pdn_reff=0.666667
* __i__f_517_6 (combinational)
* __o0t_518_6 (state-holding): pup_reff=0.4; pdn_reff=1.33333
* __o0f_518_6 (state-holding): pup_reff=0.4; pdn_reff=1.33333
* O1_at_518_6 (state-holding): pup_reff=0.8; pdn_reff=0.666667
* __i__t_518_6 (combinational)
* O1_af_518_6 (state-holding): pup_reff=0.8; pdn_reff=0.666667
* __i__f_518_6 (combinational)
* __o0t_519_6 (state-holding): pup_reff=0.4; pdn_reff=1.33333
* __o0f_519_6 (state-holding): pup_reff=0.4; pdn_reff=1.33333
* O1_at_519_6 (state-holding): pup_reff=0.8; pdn_reff=0.666667
* __i__t_519_6 (combinational)
* O1_af_519_6 (state-holding): pup_reff=0.8; pdn_reff=0.666667
* __i__f_519_6 (combinational)
* __o0t_520_6 (state-holding): pup_reff=0.4; pdn_reff=1.33333
* __o0f_520_6 (state-holding): pup_reff=0.4; pdn_reff=1.33333
* O1_at_520_6 (state-holding): pup_reff=0.8; pdn_reff=0.666667
* __i__t_520_6 (combinational)
* O1_af_520_6 (state-holding): pup_reff=0.8; pdn_reff=0.666667
* __i__f_520_6 (combinational)
* __o0t_521_6 (state-holding): pup_reff=0.4; pdn_reff=1.33333
* __o0f_521_6 (state-holding): pup_reff=0.4; pdn_reff=1.33333
* O1_at_521_6 (state-holding): pup_reff=0.8; pdn_reff=0.666667
* __i__t_521_6 (combinational)
* O1_af_521_6 (state-holding): pup_reff=0.8; pdn_reff=0.666667
* __i__f_521_6 (combinational)
* __o0t_522_6 (state-holding): pup_reff=0.4; pdn_reff=1.33333
* __o0f_522_6 (state-holding): pup_reff=0.4; pdn_reff=1.33333
* O1_at_522_6 (state-holding): pup_reff=0.8; pdn_reff=0.666667
* __i__t_522_6 (combinational)
* O1_af_522_6 (state-holding): pup_reff=0.8; pdn_reff=0.666667
* __i__f_522_6 (combinational)
* __o0t_523_6 (state-holding): pup_reff=0.4; pdn_reff=1.33333
* __o0f_523_6 (state-holding): pup_reff=0.4; pdn_reff=1.33333
* O1_at_523_6 (state-holding): pup_reff=0.8; pdn_reff=0.666667
* __i__t_523_6 (combinational)
* O1_af_523_6 (state-holding): pup_reff=0.8; pdn_reff=0.666667
* __i__f_523_6 (combinational)
* __o0t_524_6 (state-holding): pup_reff=0.4; pdn_reff=1.33333
* __o0f_524_6 (state-holding): pup_reff=0.4; pdn_reff=1.33333
* O1_at_524_6 (state-holding): pup_reff=0.8; pdn_reff=0.666667
* __i__t_524_6 (combinational)
* O1_af_524_6 (state-holding): pup_reff=0.8; pdn_reff=0.666667
* __i__f_524_6 (combinational)
* __o0t_525_6 (state-holding): pup_reff=0.4; pdn_reff=1.33333
* __o0f_525_6 (state-holding): pup_reff=0.4; pdn_reff=1.33333
* O1_at_525_6 (state-holding): pup_reff=0.8; pdn_reff=0.666667
* __i__t_525_6 (combinational)
* O1_af_525_6 (state-holding): pup_reff=0.8; pdn_reff=0.666667
* __i__f_525_6 (combinational)
* __o0t_526_6 (state-holding): pup_reff=0.4; pdn_reff=1.33333
* __o0f_526_6 (state-holding): pup_reff=0.4; pdn_reff=1.33333
* O1_at_526_6 (state-holding): pup_reff=0.8; pdn_reff=0.666667
* __i__t_526_6 (combinational)
* O1_af_526_6 (state-holding): pup_reff=0.8; pdn_reff=0.666667
* __i__f_526_6 (combinational)
* __o0t_527_6 (state-holding): pup_reff=0.4; pdn_reff=1.33333
* __o0f_527_6 (state-holding): pup_reff=0.4; pdn_reff=1.33333
* O1_at_527_6 (state-holding): pup_reff=0.8; pdn_reff=0.666667
* __i__t_527_6 (combinational)
* O1_af_527_6 (state-holding): pup_reff=0.8; pdn_reff=0.666667
* __i__f_527_6 (combinational)
* __o0t_528_6 (state-holding): pup_reff=0.4; pdn_reff=1.33333
* __o0f_528_6 (state-holding): pup_reff=0.4; pdn_reff=1.33333
* O1_at_528_6 (state-holding): pup_reff=0.8; pdn_reff=0.666667
* __i__t_528_6 (combinational)
* O1_af_528_6 (state-holding): pup_reff=0.8; pdn_reff=0.666667
* __i__f_528_6 (combinational)
* __o0t_529_6 (state-holding): pup_reff=0.4; pdn_reff=1.33333
* __o0f_529_6 (state-holding): pup_reff=0.4; pdn_reff=1.33333
* O1_at_529_6 (state-holding): pup_reff=0.8; pdn_reff=0.666667
* __i__t_529_6 (combinational)
* O1_af_529_6 (state-holding): pup_reff=0.8; pdn_reff=0.666667
* __i__f_529_6 (combinational)
* __o0t_530_6 (state-holding): pup_reff=0.4; pdn_reff=1.33333
* __o0f_530_6 (state-holding): pup_reff=0.4; pdn_reff=1.33333
* O1_at_530_6 (state-holding): pup_reff=0.8; pdn_reff=0.666667
* __i__t_530_6 (combinational)
* O1_af_530_6 (state-holding): pup_reff=0.8; pdn_reff=0.666667
* __i__f_530_6 (combinational)
* __o0t_531_6 (state-holding): pup_reff=0.4; pdn_reff=1.33333
* __o0f_531_6 (state-holding): pup_reff=0.4; pdn_reff=1.33333
* O1_at_531_6 (state-holding): pup_reff=0.8; pdn_reff=0.666667
* __i__t_531_6 (combinational)
* O1_af_531_6 (state-holding): pup_reff=0.8; pdn_reff=0.666667
* __i__f_531_6 (combinational)
* O0_at_50_6 (combinational)
* O0_af_50_6 (combinational)
* O0_at_51_6 (combinational)
* O0_af_51_6 (combinational)
* O0_at_52_6 (combinational)
* O0_af_52_6 (combinational)
* O0_at_53_6 (combinational)
* O0_af_53_6 (combinational)
* O0_at_54_6 (combinational)
* O0_af_54_6 (combinational)
* O0_at_55_6 (combinational)
* O0_af_55_6 (combinational)
* O0_at_56_6 (combinational)
* O0_af_56_6 (combinational)
* O0_at_57_6 (combinational)
* O0_af_57_6 (combinational)
* O0_at_58_6 (combinational)
* O0_af_58_6 (combinational)
* O0_at_59_6 (combinational)
* O0_af_59_6 (combinational)
* O0_at_510_6 (combinational)
* O0_af_510_6 (combinational)
* O0_at_511_6 (combinational)
* O0_af_511_6 (combinational)
* O0_at_512_6 (combinational)
* O0_af_512_6 (combinational)
* O0_at_513_6 (combinational)
* O0_af_513_6 (combinational)
* O0_at_514_6 (combinational)
* O0_af_514_6 (combinational)
* O0_at_515_6 (combinational)
* O0_af_515_6 (combinational)
* O0_at_516_6 (combinational)
* O0_af_516_6 (combinational)
* O0_at_517_6 (combinational)
* O0_af_517_6 (combinational)
* O0_at_518_6 (combinational)
* O0_af_518_6 (combinational)
* O0_at_519_6 (combinational)
* O0_af_519_6 (combinational)
* O0_at_520_6 (combinational)
* O0_af_520_6 (combinational)
* O0_at_521_6 (combinational)
* O0_af_521_6 (combinational)
* O0_at_522_6 (combinational)
* O0_af_522_6 (combinational)
* O0_at_523_6 (combinational)
* O0_af_523_6 (combinational)
* O0_at_524_6 (combinational)
* O0_af_524_6 (combinational)
* O0_at_525_6 (combinational)
* O0_af_525_6 (combinational)
* O0_at_526_6 (combinational)
* O0_af_526_6 (combinational)
* O0_at_527_6 (combinational)
* O0_af_527_6 (combinational)
* O0_at_528_6 (combinational)
* O0_af_528_6 (combinational)
* O0_at_529_6 (combinational)
* O0_af_529_6 (combinational)
* O0_at_530_6 (combinational)
* O0_af_530_6 (combinational)
* O0_at_531_6 (combinational)
* O0_af_531_6 (combinational)
*
* --- end node flags ---
*
M0_ Vdd __p #12 Vdd pmos W=0.1625U L=0.065U
M1_ Vdd __r __w0 Vdd pmos W=0.1625U L=0.065U
M2_ Vdd p #26 Vdd pmos W=0.1625U L=0.065U
M3_ Vdd __r __w1 Vdd pmos W=0.1625U L=0.065U
M4_ Vdd __i__a #30 Vdd pmos W=0.1625U L=0.065U
M5_ Vdd __w0 #35 Vdd pmos W=0.1625U L=0.065U
M6_ Vdd __r p Vdd pmos W=0.1625U L=0.065U
M7_ Vdd __w0 #39 Vdd pmos W=0.1625U L=0.065U
M8_ Vdd __w1 #39 Vdd pmos W=0.1625U L=0.065U
M9_ Vdd I_at_50_6 __o0t_50_6 Vdd pmos W=0.1625U L=0.065U
M10_ Vdd I_af_50_6 __o0f_50_6 Vdd pmos W=0.1625U L=0.065U
M11_ Vdd p #49 Vdd pmos W=0.1625U L=0.065U
M12_ Vdd p #52 Vdd pmos W=0.1625U L=0.065U
M13_ Vdd I_at_51_6 __o0t_51_6 Vdd pmos W=0.1625U L=0.065U
M14_ Vdd I_af_51_6 __o0f_51_6 Vdd pmos W=0.1625U L=0.065U
M15_ Vdd p #61 Vdd pmos W=0.1625U L=0.065U
M16_ Vdd p #64 Vdd pmos W=0.1625U L=0.065U
M17_ Vdd I_at_52_6 __o0t_52_6 Vdd pmos W=0.1625U L=0.065U
M18_ Vdd I_af_52_6 __o0f_52_6 Vdd pmos W=0.1625U L=0.065U
M19_ Vdd p #73 Vdd pmos W=0.1625U L=0.065U
M20_ Vdd p #76 Vdd pmos W=0.1625U L=0.065U
M21_ Vdd I_at_53_6 __o0t_53_6 Vdd pmos W=0.1625U L=0.065U
M22_ Vdd I_af_53_6 __o0f_53_6 Vdd pmos W=0.1625U L=0.065U
M23_ Vdd p #85 Vdd pmos W=0.1625U L=0.065U
M24_ Vdd p #88 Vdd pmos W=0.1625U L=0.065U
M25_ Vdd I_at_54_6 __o0t_54_6 Vdd pmos W=0.1625U L=0.065U
M26_ Vdd I_af_54_6 __o0f_54_6 Vdd pmos W=0.1625U L=0.065U
M27_ Vdd p #95 Vdd pmos W=0.1625U L=0.065U
M28_ Vdd p #98 Vdd pmos W=0.1625U L=0.065U
M29_ Vdd I_at_55_6 __o0t_55_6 Vdd pmos W=0.1625U L=0.065U
M30_ Vdd I_af_55_6 __o0f_55_6 Vdd pmos W=0.1625U L=0.065U
M31_ Vdd p #105 Vdd pmos W=0.1625U L=0.065U
M32_ Vdd p #108 Vdd pmos W=0.1625U L=0.065U
M33_ Vdd I_at_56_6 __o0t_56_6 Vdd pmos W=0.1625U L=0.065U
M34_ Vdd I_af_56_6 __o0f_56_6 Vdd pmos W=0.1625U L=0.065U
M35_ Vdd p #115 Vdd pmos W=0.1625U L=0.065U
M36_ Vdd p #118 Vdd pmos W=0.1625U L=0.065U
M37_ Vdd I_at_57_6 __o0t_57_6 Vdd pmos W=0.1625U L=0.065U
M38_ Vdd I_af_57_6 __o0f_57_6 Vdd pmos W=0.1625U L=0.065U
M39_ Vdd p #125 Vdd pmos W=0.1625U L=0.065U
M40_ Vdd p #128 Vdd pmos W=0.1625U L=0.065U
M41_ Vdd I_at_58_6 __o0t_58_6 Vdd pmos W=0.1625U L=0.065U
M42_ Vdd I_af_58_6 __o0f_58_6 Vdd pmos W=0.1625U L=0.065U
M43_ Vdd p #137 Vdd pmos W=0.1625U L=0.065U
M44_ Vdd p #140 Vdd pmos W=0.1625U L=0.065U
M45_ Vdd I_at_59_6 __o0t_59_6 Vdd pmos W=0.1625U L=0.065U
M46_ Vdd I_af_59_6 __o0f_59_6 Vdd pmos W=0.1625U L=0.065U
M47_ Vdd p #149 Vdd pmos W=0.1625U L=0.065U
M48_ Vdd p #152 Vdd pmos W=0.1625U L=0.065U
M49_ Vdd I_at_510_6 __o0t_510_6 Vdd pmos W=0.1625U L=0.065U
M50_ Vdd I_af_510_6 __o0f_510_6 Vdd pmos W=0.1625U L=0.065U
M51_ Vdd p #161 Vdd pmos W=0.1625U L=0.065U
M52_ Vdd p #164 Vdd pmos W=0.1625U L=0.065U
M53_ Vdd I_at_511_6 __o0t_511_6 Vdd pmos W=0.1625U L=0.065U
M54_ Vdd I_af_511_6 __o0f_511_6 Vdd pmos W=0.1625U L=0.065U
M55_ Vdd p #173 Vdd pmos W=0.1625U L=0.065U
M56_ Vdd p #176 Vdd pmos W=0.1625U L=0.065U
M57_ Vdd I_at_512_6 __o0t_512_6 Vdd pmos W=0.1625U L=0.065U
M58_ Vdd I_af_512_6 __o0f_512_6 Vdd pmos W=0.1625U L=0.065U
M59_ Vdd p #185 Vdd pmos W=0.1625U L=0.065U
M60_ Vdd p #188 Vdd pmos W=0.1625U L=0.065U
M61_ Vdd I_at_513_6 __o0t_513_6 Vdd pmos W=0.1625U L=0.065U
M62_ Vdd I_af_513_6 __o0f_513_6 Vdd pmos W=0.1625U L=0.065U
M63_ Vdd p #197 Vdd pmos W=0.1625U L=0.065U
M64_ Vdd p #200 Vdd pmos W=0.1625U L=0.065U
M65_ Vdd I_at_514_6 __o0t_514_6 Vdd pmos W=0.1625U L=0.065U
M66_ Vdd I_af_514_6 __o0f_514_6 Vdd pmos W=0.1625U L=0.065U
M67_ Vdd p #209 Vdd pmos W=0.1625U L=0.065U
M68_ Vdd p #212 Vdd pmos W=0.1625U L=0.065U
M69_ Vdd I_at_515_6 __o0t_515_6 Vdd pmos W=0.1625U L=0.065U
M70_ Vdd I_af_515_6 __o0f_515_6 Vdd pmos W=0.1625U L=0.065U
M71_ Vdd p #221 Vdd pmos W=0.1625U L=0.065U
M72_ Vdd p #224 Vdd pmos W=0.1625U L=0.065U
M73_ Vdd I_at_516_6 __o0t_516_6 Vdd pmos W=0.1625U L=0.065U
M74_ Vdd I_af_516_6 __o0f_516_6 Vdd pmos W=0.1625U L=0.065U
M75_ Vdd p #233 Vdd pmos W=0.1625U L=0.065U
M76_ Vdd p #236 Vdd pmos W=0.1625U L=0.065U
M77_ Vdd I_at_517_6 __o0t_517_6 Vdd pmos W=0.1625U L=0.065U
M78_ Vdd I_af_517_6 __o0f_517_6 Vdd pmos W=0.1625U L=0.065U
M79_ Vdd p #245 Vdd pmos W=0.1625U L=0.065U
M80_ Vdd p #248 Vdd pmos W=0.1625U L=0.065U
M81_ Vdd I_at_518_6 __o0t_518_6 Vdd pmos W=0.1625U L=0.065U
M82_ Vdd I_af_518_6 __o0f_518_6 Vdd pmos W=0.1625U L=0.065U
M83_ Vdd p #257 Vdd pmos W=0.1625U L=0.065U
M84_ Vdd p #260 Vdd pmos W=0.1625U L=0.065U
M85_ Vdd I_at_519_6 __o0t_519_6 Vdd pmos W=0.1625U L=0.065U
M86_ Vdd I_af_519_6 __o0f_519_6 Vdd pmos W=0.1625U L=0.065U
M87_ Vdd p #269 Vdd pmos W=0.1625U L=0.065U
M88_ Vdd p #272 Vdd pmos W=0.1625U L=0.065U
M89_ Vdd I_at_520_6 __o0t_520_6 Vdd pmos W=0.1625U L=0.065U
M90_ Vdd I_af_520_6 __o0f_520_6 Vdd pmos W=0.1625U L=0.065U
M91_ Vdd p #281 Vdd pmos W=0.1625U L=0.065U
M92_ Vdd p #284 Vdd pmos W=0.1625U L=0.065U
M93_ Vdd I_at_521_6 __o0t_521_6 Vdd pmos W=0.1625U L=0.065U
M94_ Vdd I_af_521_6 __o0f_521_6 Vdd pmos W=0.1625U L=0.065U
M95_ Vdd p #293 Vdd pmos W=0.1625U L=0.065U
M96_ Vdd p #296 Vdd pmos W=0.1625U L=0.065U
M97_ Vdd I_at_522_6 __o0t_522_6 Vdd pmos W=0.1625U L=0.065U
M98_ Vdd I_af_522_6 __o0f_522_6 Vdd pmos W=0.1625U L=0.065U
M99_ Vdd p #305 Vdd pmos W=0.1625U L=0.065U
M100_ Vdd p #308 Vdd pmos W=0.1625U L=0.065U
M101_ Vdd I_at_523_6 __o0t_523_6 Vdd pmos W=0.1625U L=0.065U
M102_ Vdd I_af_523_6 __o0f_523_6 Vdd pmos W=0.1625U L=0.065U
M103_ Vdd p #317 Vdd pmos W=0.1625U L=0.065U
M104_ Vdd p #320 Vdd pmos W=0.1625U L=0.065U
M105_ Vdd I_at_524_6 __o0t_524_6 Vdd pmos W=0.1625U L=0.065U
M106_ Vdd I_af_524_6 __o0f_524_6 Vdd pmos W=0.1625U L=0.065U
M107_ Vdd p #329 Vdd pmos W=0.1625U L=0.065U
M108_ Vdd p #332 Vdd pmos W=0.1625U L=0.065U
M109_ Vdd I_at_525_6 __o0t_525_6 Vdd pmos W=0.1625U L=0.065U
M110_ Vdd I_af_525_6 __o0f_525_6 Vdd pmos W=0.1625U L=0.065U
M111_ Vdd p #341 Vdd pmos W=0.1625U L=0.065U
M112_ Vdd p #344 Vdd pmos W=0.1625U L=0.065U
M113_ Vdd I_at_526_6 __o0t_526_6 Vdd pmos W=0.1625U L=0.065U
M114_ Vdd I_af_526_6 __o0f_526_6 Vdd pmos W=0.1625U L=0.065U
M115_ Vdd p #353 Vdd pmos W=0.1625U L=0.065U
M116_ Vdd p #356 Vdd pmos W=0.1625U L=0.065U
M117_ Vdd I_at_527_6 __o0t_527_6 Vdd pmos W=0.1625U L=0.065U
M118_ Vdd I_af_527_6 __o0f_527_6 Vdd pmos W=0.1625U L=0.065U
M119_ Vdd p #365 Vdd pmos W=0.1625U L=0.065U
M120_ Vdd p #368 Vdd pmos W=0.1625U L=0.065U
M121_ Vdd I_at_528_6 __o0t_528_6 Vdd pmos W=0.1625U L=0.065U
M122_ Vdd I_af_528_6 __o0f_528_6 Vdd pmos W=0.1625U L=0.065U
M123_ Vdd p #377 Vdd pmos W=0.1625U L=0.065U
M124_ Vdd p #380 Vdd pmos W=0.1625U L=0.065U
M125_ Vdd I_at_529_6 __o0t_529_6 Vdd pmos W=0.1625U L=0.065U
M126_ Vdd I_af_529_6 __o0f_529_6 Vdd pmos W=0.1625U L=0.065U
M127_ Vdd p #389 Vdd pmos W=0.1625U L=0.065U
M128_ Vdd p #392 Vdd pmos W=0.1625U L=0.065U
M129_ Vdd I_at_530_6 __o0t_530_6 Vdd pmos W=0.1625U L=0.065U
M130_ Vdd I_af_530_6 __o0f_530_6 Vdd pmos W=0.1625U L=0.065U
M131_ Vdd p #401 Vdd pmos W=0.1625U L=0.065U
M132_ Vdd p #404 Vdd pmos W=0.1625U L=0.065U
M133_ Vdd I_at_531_6 __o0t_531_6 Vdd pmos W=0.1625U L=0.065U
M134_ Vdd I_af_531_6 __o0f_531_6 Vdd pmos W=0.1625U L=0.065U
M135_ Vdd p #413 Vdd pmos W=0.1625U L=0.065U
M136_ Vdd p #416 Vdd pmos W=0.1625U L=0.065U
M137_ Vdd p __p Vdd pmos W=0.1625U L=0.065U
M138_ Vdd a __a Vdd pmos W=0.1625U L=0.065U
M139_ Vdd I_aa __i__a Vdd pmos W=0.1625U L=0.065U
M140_ Vdd reset __r Vdd pmos W=0.1625U L=0.065U
M141_ Vdd __w1 w1 Vdd pmos W=0.1625U L=0.065U
M142_ Vdd O0_aa __o0a Vdd pmos W=0.1625U L=0.065U
M143_ Vdd O1_aa __o1a Vdd pmos W=0.1625U L=0.065U
M144_ Vdd I_at_50_6 __i__t_50_6 Vdd pmos W=0.1625U L=0.065U
M145_ Vdd I_af_50_6 __i__f_50_6 Vdd pmos W=0.1625U L=0.065U
M146_ Vdd __o0t_50_6 O0_at_50_6 Vdd pmos W=0.1625U L=0.065U
M147_ Vdd __o0f_50_6 O0_af_50_6 Vdd pmos W=0.1625U L=0.065U
M148_ Vdd I_at_51_6 __i__t_51_6 Vdd pmos W=0.1625U L=0.065U
M149_ Vdd I_af_51_6 __i__f_51_6 Vdd pmos W=0.1625U L=0.065U
M150_ Vdd __o0t_51_6 O0_at_51_6 Vdd pmos W=0.1625U L=0.065U
M151_ Vdd __o0f_51_6 O0_af_51_6 Vdd pmos W=0.1625U L=0.065U
M152_ Vdd I_at_52_6 __i__t_52_6 Vdd pmos W=0.1625U L=0.065U
M153_ Vdd I_af_52_6 __i__f_52_6 Vdd pmos W=0.1625U L=0.065U
M154_ Vdd __o0t_52_6 O0_at_52_6 Vdd pmos W=0.1625U L=0.065U
M155_ Vdd __o0f_52_6 O0_af_52_6 Vdd pmos W=0.1625U L=0.065U
M156_ Vdd I_at_53_6 __i__t_53_6 Vdd pmos W=0.1625U L=0.065U
M157_ Vdd I_af_53_6 __i__f_53_6 Vdd pmos W=0.1625U L=0.065U
M158_ Vdd __o0t_53_6 O0_at_53_6 Vdd pmos W=0.1625U L=0.065U
M159_ Vdd __o0f_53_6 O0_af_53_6 Vdd pmos W=0.1625U L=0.065U
M160_ Vdd I_at_54_6 __i__t_54_6 Vdd pmos W=0.1625U L=0.065U
M161_ Vdd I_af_54_6 __i__f_54_6 Vdd pmos W=0.1625U L=0.065U
M162_ Vdd __o0t_54_6 O0_at_54_6 Vdd pmos W=0.1625U L=0.065U
M163_ Vdd __o0f_54_6 O0_af_54_6 Vdd pmos W=0.1625U L=0.065U
M164_ Vdd I_at_55_6 __i__t_55_6 Vdd pmos W=0.1625U L=0.065U
M165_ Vdd I_af_55_6 __i__f_55_6 Vdd pmos W=0.1625U L=0.065U
M166_ Vdd __o0t_55_6 O0_at_55_6 Vdd pmos W=0.1625U L=0.065U
M167_ Vdd __o0f_55_6 O0_af_55_6 Vdd pmos W=0.1625U L=0.065U
M168_ Vdd I_at_56_6 __i__t_56_6 Vdd pmos W=0.1625U L=0.065U
M169_ Vdd I_af_56_6 __i__f_56_6 Vdd pmos W=0.1625U L=0.065U
M170_ Vdd __o0t_56_6 O0_at_56_6 Vdd pmos W=0.1625U L=0.065U
M171_ Vdd __o0f_56_6 O0_af_56_6 Vdd pmos W=0.1625U L=0.065U
M172_ Vdd I_at_57_6 __i__t_57_6 Vdd pmos W=0.1625U L=0.065U
M173_ Vdd I_af_57_6 __i__f_57_6 Vdd pmos W=0.1625U L=0.065U
M174_ Vdd __o0t_57_6 O0_at_57_6 Vdd pmos W=0.1625U L=0.065U
M175_ Vdd __o0f_57_6 O0_af_57_6 Vdd pmos W=0.1625U L=0.065U
M176_ Vdd I_at_58_6 __i__t_58_6 Vdd pmos W=0.1625U L=0.065U
M177_ Vdd I_af_58_6 __i__f_58_6 Vdd pmos W=0.1625U L=0.065U
M178_ Vdd __o0t_58_6 O0_at_58_6 Vdd pmos W=0.1625U L=0.065U
M179_ Vdd __o0f_58_6 O0_af_58_6 Vdd pmos W=0.1625U L=0.065U
M180_ Vdd I_at_59_6 __i__t_59_6 Vdd pmos W=0.1625U L=0.065U
M181_ Vdd I_af_59_6 __i__f_59_6 Vdd pmos W=0.1625U L=0.065U
M182_ Vdd __o0t_59_6 O0_at_59_6 Vdd pmos W=0.1625U L=0.065U
M183_ Vdd __o0f_59_6 O0_af_59_6 Vdd pmos W=0.1625U L=0.065U
M184_ Vdd I_at_510_6 __i__t_510_6 Vdd pmos W=0.1625U L=0.065U
M185_ Vdd I_af_510_6 __i__f_510_6 Vdd pmos W=0.1625U L=0.065U
M186_ Vdd __o0t_510_6 O0_at_510_6 Vdd pmos W=0.1625U L=0.065U
M187_ Vdd __o0f_510_6 O0_af_510_6 Vdd pmos W=0.1625U L=0.065U
M188_ Vdd I_at_511_6 __i__t_511_6 Vdd pmos W=0.1625U L=0.065U
M189_ Vdd I_af_511_6 __i__f_511_6 Vdd pmos W=0.1625U L=0.065U
M190_ Vdd __o0t_511_6 O0_at_511_6 Vdd pmos W=0.1625U L=0.065U
M191_ Vdd __o0f_511_6 O0_af_511_6 Vdd pmos W=0.1625U L=0.065U
M192_ Vdd I_at_512_6 __i__t_512_6 Vdd pmos W=0.1625U L=0.065U
M193_ Vdd I_af_512_6 __i__f_512_6 Vdd pmos W=0.1625U L=0.065U
M194_ Vdd __o0t_512_6 O0_at_512_6 Vdd pmos W=0.1625U L=0.065U
M195_ Vdd __o0f_512_6 O0_af_512_6 Vdd pmos W=0.1625U L=0.065U
M196_ Vdd I_at_513_6 __i__t_513_6 Vdd pmos W=0.1625U L=0.065U
M197_ Vdd I_af_513_6 __i__f_513_6 Vdd pmos W=0.1625U L=0.065U
M198_ Vdd __o0t_513_6 O0_at_513_6 Vdd pmos W=0.1625U L=0.065U
M199_ Vdd __o0f_513_6 O0_af_513_6 Vdd pmos W=0.1625U L=0.065U
M200_ Vdd I_at_514_6 __i__t_514_6 Vdd pmos W=0.1625U L=0.065U
M201_ Vdd I_af_514_6 __i__f_514_6 Vdd pmos W=0.1625U L=0.065U
M202_ Vdd __o0t_514_6 O0_at_514_6 Vdd pmos W=0.1625U L=0.065U
M203_ Vdd __o0f_514_6 O0_af_514_6 Vdd pmos W=0.1625U L=0.065U
M204_ Vdd I_at_515_6 __i__t_515_6 Vdd pmos W=0.1625U L=0.065U
M205_ Vdd I_af_515_6 __i__f_515_6 Vdd pmos W=0.1625U L=0.065U
M206_ Vdd __o0t_515_6 O0_at_515_6 Vdd pmos W=0.1625U L=0.065U
M207_ Vdd __o0f_515_6 O0_af_515_6 Vdd pmos W=0.1625U L=0.065U
M208_ Vdd I_at_516_6 __i__t_516_6 Vdd pmos W=0.1625U L=0.065U
M209_ Vdd I_af_516_6 __i__f_516_6 Vdd pmos W=0.1625U L=0.065U
M210_ Vdd __o0t_516_6 O0_at_516_6 Vdd pmos W=0.1625U L=0.065U
M211_ Vdd __o0f_516_6 O0_af_516_6 Vdd pmos W=0.1625U L=0.065U
M212_ Vdd I_at_517_6 __i__t_517_6 Vdd pmos W=0.1625U L=0.065U
M213_ Vdd I_af_517_6 __i__f_517_6 Vdd pmos W=0.1625U L=0.065U
M214_ Vdd __o0t_517_6 O0_at_517_6 Vdd pmos W=0.1625U L=0.065U
M215_ Vdd __o0f_517_6 O0_af_517_6 Vdd pmos W=0.1625U L=0.065U
M216_ Vdd I_at_518_6 __i__t_518_6 Vdd pmos W=0.1625U L=0.065U
M217_ Vdd I_af_518_6 __i__f_518_6 Vdd pmos W=0.1625U L=0.065U
M218_ Vdd __o0t_518_6 O0_at_518_6 Vdd pmos W=0.1625U L=0.065U
M219_ Vdd __o0f_518_6 O0_af_518_6 Vdd pmos W=0.1625U L=0.065U
M220_ Vdd I_at_519_6 __i__t_519_6 Vdd pmos W=0.1625U L=0.065U
M221_ Vdd I_af_519_6 __i__f_519_6 Vdd pmos W=0.1625U L=0.065U
M222_ Vdd __o0t_519_6 O0_at_519_6 Vdd pmos W=0.1625U L=0.065U
M223_ Vdd __o0f_519_6 O0_af_519_6 Vdd pmos W=0.1625U L=0.065U
M224_ Vdd I_at_520_6 __i__t_520_6 Vdd pmos W=0.1625U L=0.065U
M225_ Vdd I_af_520_6 __i__f_520_6 Vdd pmos W=0.1625U L=0.065U
M226_ Vdd __o0t_520_6 O0_at_520_6 Vdd pmos W=0.1625U L=0.065U
M227_ Vdd __o0f_520_6 O0_af_520_6 Vdd pmos W=0.1625U L=0.065U
M228_ Vdd I_at_521_6 __i__t_521_6 Vdd pmos W=0.1625U L=0.065U
M229_ Vdd I_af_521_6 __i__f_521_6 Vdd pmos W=0.1625U L=0.065U
M230_ Vdd __o0t_521_6 O0_at_521_6 Vdd pmos W=0.1625U L=0.065U
M231_ Vdd __o0f_521_6 O0_af_521_6 Vdd pmos W=0.1625U L=0.065U
M232_ Vdd I_at_522_6 __i__t_522_6 Vdd pmos W=0.1625U L=0.065U
M233_ Vdd I_af_522_6 __i__f_522_6 Vdd pmos W=0.1625U L=0.065U
M234_ Vdd __o0t_522_6 O0_at_522_6 Vdd pmos W=0.1625U L=0.065U
M235_ Vdd __o0f_522_6 O0_af_522_6 Vdd pmos W=0.1625U L=0.065U
M236_ Vdd I_at_523_6 __i__t_523_6 Vdd pmos W=0.1625U L=0.065U
M237_ Vdd I_af_523_6 __i__f_523_6 Vdd pmos W=0.1625U L=0.065U
M238_ Vdd __o0t_523_6 O0_at_523_6 Vdd pmos W=0.1625U L=0.065U
M239_ Vdd __o0f_523_6 O0_af_523_6 Vdd pmos W=0.1625U L=0.065U
M240_ Vdd I_at_524_6 __i__t_524_6 Vdd pmos W=0.1625U L=0.065U
M241_ Vdd I_af_524_6 __i__f_524_6 Vdd pmos W=0.1625U L=0.065U
M242_ Vdd __o0t_524_6 O0_at_524_6 Vdd pmos W=0.1625U L=0.065U
M243_ Vdd __o0f_524_6 O0_af_524_6 Vdd pmos W=0.1625U L=0.065U
M244_ Vdd I_at_525_6 __i__t_525_6 Vdd pmos W=0.1625U L=0.065U
M245_ Vdd I_af_525_6 __i__f_525_6 Vdd pmos W=0.1625U L=0.065U
M246_ Vdd __o0t_525_6 O0_at_525_6 Vdd pmos W=0.1625U L=0.065U
M247_ Vdd __o0f_525_6 O0_af_525_6 Vdd pmos W=0.1625U L=0.065U
M248_ Vdd I_at_526_6 __i__t_526_6 Vdd pmos W=0.1625U L=0.065U
M249_ Vdd I_af_526_6 __i__f_526_6 Vdd pmos W=0.1625U L=0.065U
M250_ Vdd __o0t_526_6 O0_at_526_6 Vdd pmos W=0.1625U L=0.065U
M251_ Vdd __o0f_526_6 O0_af_526_6 Vdd pmos W=0.1625U L=0.065U
M252_ Vdd I_at_527_6 __i__t_527_6 Vdd pmos W=0.1625U L=0.065U
M253_ Vdd I_af_527_6 __i__f_527_6 Vdd pmos W=0.1625U L=0.065U
M254_ Vdd __o0t_527_6 O0_at_527_6 Vdd pmos W=0.1625U L=0.065U
M255_ Vdd __o0f_527_6 O0_af_527_6 Vdd pmos W=0.1625U L=0.065U
M256_ Vdd I_at_528_6 __i__t_528_6 Vdd pmos W=0.1625U L=0.065U
M257_ Vdd I_af_528_6 __i__f_528_6 Vdd pmos W=0.1625U L=0.065U
M258_ Vdd __o0t_528_6 O0_at_528_6 Vdd pmos W=0.1625U L=0.065U
M259_ Vdd __o0f_528_6 O0_af_528_6 Vdd pmos W=0.1625U L=0.065U
M260_ Vdd I_at_529_6 __i__t_529_6 Vdd pmos W=0.1625U L=0.065U
M261_ Vdd I_af_529_6 __i__f_529_6 Vdd pmos W=0.1625U L=0.065U
M262_ Vdd __o0t_529_6 O0_at_529_6 Vdd pmos W=0.1625U L=0.065U
M263_ Vdd __o0f_529_6 O0_af_529_6 Vdd pmos W=0.1625U L=0.065U
M264_ Vdd I_at_530_6 __i__t_530_6 Vdd pmos W=0.1625U L=0.065U
M265_ Vdd I_af_530_6 __i__f_530_6 Vdd pmos W=0.1625U L=0.065U
M266_ Vdd __o0t_530_6 O0_at_530_6 Vdd pmos W=0.1625U L=0.065U
M267_ Vdd __o0f_530_6 O0_af_530_6 Vdd pmos W=0.1625U L=0.065U
M268_ Vdd I_at_531_6 __i__t_531_6 Vdd pmos W=0.1625U L=0.065U
M269_ Vdd I_af_531_6 __i__f_531_6 Vdd pmos W=0.1625U L=0.065U
M270_ Vdd __o0t_531_6 O0_at_531_6 Vdd pmos W=0.1625U L=0.065U
M271_ Vdd __o0f_531_6 O0_af_531_6 Vdd pmos W=0.1625U L=0.065U
M272_ Vdd __w0 #fb483# Vdd pmos W=0.1625U L=0.13U
M273_ Vdd p #fb486# Vdd pmos W=0.1625U L=0.13U
M274_keeper Vdd GND #484 Vdd pmos W=0.0975U L=0.585U
M275_ Vdd __w1 #fb489# Vdd pmos W=0.1625U L=0.13U
M276_keeper Vdd GND #487 Vdd pmos W=0.0975U L=0.585U
M277_ Vdd a #fb492# Vdd pmos W=0.1625U L=0.13U
M278_keeper Vdd GND #490 Vdd pmos W=0.0975U L=1.56U
M279_ Vdd I_aa #fb495# Vdd pmos W=0.1625U L=0.13U
M280_keeper Vdd GND #493 Vdd pmos W=0.0975U L=0.585U
M281_ Vdd __o0t_50_6 #fb498# Vdd pmos W=0.1625U L=0.13U
M282_keeper Vdd GND #496 Vdd pmos W=0.0975U L=0.91U
M283_ Vdd __o0f_50_6 #fb501# Vdd pmos W=0.1625U L=0.13U
M284_keeper Vdd GND #499 Vdd pmos W=0.0975U L=0.585U
M285_ Vdd O1_at_50_6 #fb504# Vdd pmos W=0.1625U L=0.13U
M286_keeper Vdd GND #502 Vdd pmos W=0.0975U L=0.585U
M287_ Vdd O1_af_50_6 #fb507# Vdd pmos W=0.1625U L=0.13U
M288_keeper Vdd GND #505 Vdd pmos W=0.0975U L=0.26U
M289_ Vdd __o0t_51_6 #fb510# Vdd pmos W=0.1625U L=0.13U
M290_keeper Vdd GND #508 Vdd pmos W=0.0975U L=0.26U
M291_ Vdd __o0f_51_6 #fb513# Vdd pmos W=0.1625U L=0.13U
M292_keeper Vdd GND #511 Vdd pmos W=0.0975U L=0.585U
M293_ Vdd O1_at_51_6 #fb516# Vdd pmos W=0.1625U L=0.13U
M294_keeper Vdd GND #514 Vdd pmos W=0.0975U L=0.585U
M295_ Vdd O1_af_51_6 #fb519# Vdd pmos W=0.1625U L=0.13U
M296_keeper Vdd GND #517 Vdd pmos W=0.0975U L=0.26U
M297_ Vdd __o0t_52_6 #fb522# Vdd pmos W=0.1625U L=0.13U
M298_keeper Vdd GND #520 Vdd pmos W=0.0975U L=0.26U
M299_ Vdd __o0f_52_6 #fb525# Vdd pmos W=0.1625U L=0.13U
M300_keeper Vdd GND #523 Vdd pmos W=0.0975U L=0.585U
M301_ Vdd O1_at_52_6 #fb528# Vdd pmos W=0.1625U L=0.13U
M302_keeper Vdd GND #526 Vdd pmos W=0.0975U L=0.585U
M303_ Vdd O1_af_52_6 #fb531# Vdd pmos W=0.1625U L=0.13U
M304_keeper Vdd GND #529 Vdd pmos W=0.0975U L=0.26U
M305_ Vdd __o0t_53_6 #fb534# Vdd pmos W=0.1625U L=0.13U
M306_keeper Vdd GND #532 Vdd pmos W=0.0975U L=0.26U
M307_ Vdd __o0f_53_6 #fb537# Vdd pmos W=0.1625U L=0.13U
M308_keeper Vdd GND #535 Vdd pmos W=0.0975U L=0.585U
M309_ Vdd O1_at_53_6 #fb540# Vdd pmos W=0.1625U L=0.13U
M310_keeper Vdd GND #538 Vdd pmos W=0.0975U L=0.585U
M311_ Vdd O1_af_53_6 #fb543# Vdd pmos W=0.1625U L=0.13U
M312_keeper Vdd GND #541 Vdd pmos W=0.0975U L=0.26U
M313_ Vdd __o0t_54_6 #fb546# Vdd pmos W=0.1625U L=0.13U
M314_keeper Vdd GND #544 Vdd pmos W=0.0975U L=0.26U
M315_ Vdd __o0f_54_6 #fb549# Vdd pmos W=0.1625U L=0.13U
M316_keeper Vdd GND #547 Vdd pmos W=0.0975U L=0.585U
M317_ Vdd O1_at_54_6 #fb552# Vdd pmos W=0.1625U L=0.13U
M318_keeper Vdd GND #550 Vdd pmos W=0.0975U L=0.585U
M319_ Vdd O1_af_54_6 #fb555# Vdd pmos W=0.1625U L=0.13U
M320_keeper Vdd GND #553 Vdd pmos W=0.0975U L=0.26U
M321_ Vdd __o0t_55_6 #fb558# Vdd pmos W=0.1625U L=0.13U
M322_keeper Vdd GND #556 Vdd pmos W=0.0975U L=0.26U
M323_ Vdd __o0f_55_6 #fb561# Vdd pmos W=0.1625U L=0.13U
M324_keeper Vdd GND #559 Vdd pmos W=0.0975U L=0.585U
M325_ Vdd O1_at_55_6 #fb564# Vdd pmos W=0.1625U L=0.13U
M326_keeper Vdd GND #562 Vdd pmos W=0.0975U L=0.585U
M327_ Vdd O1_af_55_6 #fb567# Vdd pmos W=0.1625U L=0.13U
M328_keeper Vdd GND #565 Vdd pmos W=0.0975U L=0.26U
M329_ Vdd __o0t_56_6 #fb570# Vdd pmos W=0.1625U L=0.13U
M330_keeper Vdd GND #568 Vdd pmos W=0.0975U L=0.26U
M331_ Vdd __o0f_56_6 #fb573# Vdd pmos W=0.1625U L=0.13U
M332_keeper Vdd GND #571 Vdd pmos W=0.0975U L=0.585U
M333_ Vdd O1_at_56_6 #fb576# Vdd pmos W=0.1625U L=0.13U
M334_keeper Vdd GND #574 Vdd pmos W=0.0975U L=0.585U
M335_ Vdd O1_af_56_6 #fb579# Vdd pmos W=0.1625U L=0.13U
M336_keeper Vdd GND #577 Vdd pmos W=0.0975U L=0.26U
M337_ Vdd __o0t_57_6 #fb582# Vdd pmos W=0.1625U L=0.13U
M338_keeper Vdd GND #580 Vdd pmos W=0.0975U L=0.26U
M339_ Vdd __o0f_57_6 #fb585# Vdd pmos W=0.1625U L=0.13U
M340_keeper Vdd GND #583 Vdd pmos W=0.0975U L=0.585U
M341_ Vdd O1_at_57_6 #fb588# Vdd pmos W=0.1625U L=0.13U
M342_keeper Vdd GND #586 Vdd pmos W=0.0975U L=0.585U
M343_ Vdd O1_af_57_6 #fb591# Vdd pmos W=0.1625U L=0.13U
M344_keeper Vdd GND #589 Vdd pmos W=0.0975U L=0.26U
M345_ Vdd __o0t_58_6 #fb594# Vdd pmos W=0.1625U L=0.13U
M346_keeper Vdd GND #592 Vdd pmos W=0.0975U L=0.26U
M347_ Vdd __o0f_58_6 #fb597# Vdd pmos W=0.1625U L=0.13U
M348_keeper Vdd GND #595 Vdd pmos W=0.0975U L=0.585U
M349_ Vdd O1_at_58_6 #fb600# Vdd pmos W=0.1625U L=0.13U
M350_keeper Vdd GND #598 Vdd pmos W=0.0975U L=0.585U
M351_ Vdd O1_af_58_6 #fb603# Vdd pmos W=0.1625U L=0.13U
M352_keeper Vdd GND #601 Vdd pmos W=0.0975U L=0.26U
M353_ Vdd __o0t_59_6 #fb606# Vdd pmos W=0.1625U L=0.13U
M354_keeper Vdd GND #604 Vdd pmos W=0.0975U L=0.26U
M355_ Vdd __o0f_59_6 #fb609# Vdd pmos W=0.1625U L=0.13U
M356_keeper Vdd GND #607 Vdd pmos W=0.0975U L=0.585U
M357_ Vdd O1_at_59_6 #fb612# Vdd pmos W=0.1625U L=0.13U
M358_keeper Vdd GND #610 Vdd pmos W=0.0975U L=0.585U
M359_ Vdd O1_af_59_6 #fb615# Vdd pmos W=0.1625U L=0.13U
M360_keeper Vdd GND #613 Vdd pmos W=0.0975U L=0.26U
M361_ Vdd __o0t_510_6 #fb618# Vdd pmos W=0.1625U L=0.13U
M362_keeper Vdd GND #616 Vdd pmos W=0.0975U L=0.26U
M363_ Vdd __o0f_510_6 #fb621# Vdd pmos W=0.1625U L=0.13U
M364_keeper Vdd GND #619 Vdd pmos W=0.0975U L=0.585U
M365_ Vdd O1_at_510_6 #fb624# Vdd pmos W=0.1625U L=0.13U
M366_keeper Vdd GND #622 Vdd pmos W=0.0975U L=0.585U
M367_ Vdd O1_af_510_6 #fb627# Vdd pmos W=0.1625U L=0.13U
M368_keeper Vdd GND #625 Vdd pmos W=0.0975U L=0.26U
M369_ Vdd __o0t_511_6 #fb630# Vdd pmos W=0.1625U L=0.13U
M370_keeper Vdd GND #628 Vdd pmos W=0.0975U L=0.26U
M371_ Vdd __o0f_511_6 #fb633# Vdd pmos W=0.1625U L=0.13U
M372_keeper Vdd GND #631 Vdd pmos W=0.0975U L=0.585U
M373_ Vdd O1_at_511_6 #fb636# Vdd pmos W=0.1625U L=0.13U
M374_keeper Vdd GND #634 Vdd pmos W=0.0975U L=0.585U
M375_ Vdd O1_af_511_6 #fb639# Vdd pmos W=0.1625U L=0.13U
M376_keeper Vdd GND #637 Vdd pmos W=0.0975U L=0.26U
M377_ Vdd __o0t_512_6 #fb642# Vdd pmos W=0.1625U L=0.13U
M378_keeper Vdd GND #640 Vdd pmos W=0.0975U L=0.26U
M379_ Vdd __o0f_512_6 #fb645# Vdd pmos W=0.1625U L=0.13U
M380_keeper Vdd GND #643 Vdd pmos W=0.0975U L=0.585U
M381_ Vdd O1_at_512_6 #fb648# Vdd pmos W=0.1625U L=0.13U
M382_keeper Vdd GND #646 Vdd pmos W=0.0975U L=0.585U
M383_ Vdd O1_af_512_6 #fb651# Vdd pmos W=0.1625U L=0.13U
M384_keeper Vdd GND #649 Vdd pmos W=0.0975U L=0.26U
M385_ Vdd __o0t_513_6 #fb654# Vdd pmos W=0.1625U L=0.13U
M386_keeper Vdd GND #652 Vdd pmos W=0.0975U L=0.26U
M387_ Vdd __o0f_513_6 #fb657# Vdd pmos W=0.1625U L=0.13U
M388_keeper Vdd GND #655 Vdd pmos W=0.0975U L=0.585U
M389_ Vdd O1_at_513_6 #fb660# Vdd pmos W=0.1625U L=0.13U
M390_keeper Vdd GND #658 Vdd pmos W=0.0975U L=0.585U
M391_ Vdd O1_af_513_6 #fb663# Vdd pmos W=0.1625U L=0.13U
M392_keeper Vdd GND #661 Vdd pmos W=0.0975U L=0.26U
M393_ Vdd __o0t_514_6 #fb666# Vdd pmos W=0.1625U L=0.13U
M394_keeper Vdd GND #664 Vdd pmos W=0.0975U L=0.26U
M395_ Vdd __o0f_514_6 #fb669# Vdd pmos W=0.1625U L=0.13U
M396_keeper Vdd GND #667 Vdd pmos W=0.0975U L=0.585U
M397_ Vdd O1_at_514_6 #fb672# Vdd pmos W=0.1625U L=0.13U
M398_keeper Vdd GND #670 Vdd pmos W=0.0975U L=0.585U
M399_ Vdd O1_af_514_6 #fb675# Vdd pmos W=0.1625U L=0.13U
M400_keeper Vdd GND #673 Vdd pmos W=0.0975U L=0.26U
M401_ Vdd __o0t_515_6 #fb678# Vdd pmos W=0.1625U L=0.13U
M402_keeper Vdd GND #676 Vdd pmos W=0.0975U L=0.26U
M403_ Vdd __o0f_515_6 #fb681# Vdd pmos W=0.1625U L=0.13U
M404_keeper Vdd GND #679 Vdd pmos W=0.0975U L=0.585U
M405_ Vdd O1_at_515_6 #fb684# Vdd pmos W=0.1625U L=0.13U
M406_keeper Vdd GND #682 Vdd pmos W=0.0975U L=0.585U
M407_ Vdd O1_af_515_6 #fb687# Vdd pmos W=0.1625U L=0.13U
M408_keeper Vdd GND #685 Vdd pmos W=0.0975U L=0.26U
M409_ Vdd __o0t_516_6 #fb690# Vdd pmos W=0.1625U L=0.13U
M410_keeper Vdd GND #688 Vdd pmos W=0.0975U L=0.26U
M411_ Vdd __o0f_516_6 #fb693# Vdd pmos W=0.1625U L=0.13U
M412_keeper Vdd GND #691 Vdd pmos W=0.0975U L=0.585U
M413_ Vdd O1_at_516_6 #fb696# Vdd pmos W=0.1625U L=0.13U
M414_keeper Vdd GND #694 Vdd pmos W=0.0975U L=0.585U
M415_ Vdd O1_af_516_6 #fb699# Vdd pmos W=0.1625U L=0.13U
M416_keeper Vdd GND #697 Vdd pmos W=0.0975U L=0.26U
M417_ Vdd __o0t_517_6 #fb702# Vdd pmos W=0.1625U L=0.13U
M418_keeper Vdd GND #700 Vdd pmos W=0.0975U L=0.26U
M419_ Vdd __o0f_517_6 #fb705# Vdd pmos W=0.1625U L=0.13U
M420_keeper Vdd GND #703 Vdd pmos W=0.0975U L=0.585U
M421_ Vdd O1_at_517_6 #fb708# Vdd pmos W=0.1625U L=0.13U
M422_keeper Vdd GND #706 Vdd pmos W=0.0975U L=0.585U
M423_ Vdd O1_af_517_6 #fb711# Vdd pmos W=0.1625U L=0.13U
M424_keeper Vdd GND #709 Vdd pmos W=0.0975U L=0.26U
M425_ Vdd __o0t_518_6 #fb714# Vdd pmos W=0.1625U L=0.13U
M426_keeper Vdd GND #712 Vdd pmos W=0.0975U L=0.26U
M427_ Vdd __o0f_518_6 #fb717# Vdd pmos W=0.1625U L=0.13U
M428_keeper Vdd GND #715 Vdd pmos W=0.0975U L=0.585U
M429_ Vdd O1_at_518_6 #fb720# Vdd pmos W=0.1625U L=0.13U
M430_keeper Vdd GND #718 Vdd pmos W=0.0975U L=0.585U
M431_ Vdd O1_af_518_6 #fb723# Vdd pmos W=0.1625U L=0.13U
M432_keeper Vdd GND #721 Vdd pmos W=0.0975U L=0.26U
M433_ Vdd __o0t_519_6 #fb726# Vdd pmos W=0.1625U L=0.13U
M434_keeper Vdd GND #724 Vdd pmos W=0.0975U L=0.26U
M435_ Vdd __o0f_519_6 #fb729# Vdd pmos W=0.1625U L=0.13U
M436_keeper Vdd GND #727 Vdd pmos W=0.0975U L=0.585U
M437_ Vdd O1_at_519_6 #fb732# Vdd pmos W=0.1625U L=0.13U
M438_keeper Vdd GND #730 Vdd pmos W=0.0975U L=0.585U
M439_ Vdd O1_af_519_6 #fb735# Vdd pmos W=0.1625U L=0.13U
M440_keeper Vdd GND #733 Vdd pmos W=0.0975U L=0.26U
M441_ Vdd __o0t_520_6 #fb738# Vdd pmos W=0.1625U L=0.13U
M442_keeper Vdd GND #736 Vdd pmos W=0.0975U L=0.26U
M443_ Vdd __o0f_520_6 #fb741# Vdd pmos W=0.1625U L=0.13U
M444_keeper Vdd GND #739 Vdd pmos W=0.0975U L=0.585U
M445_ Vdd O1_at_520_6 #fb744# Vdd pmos W=0.1625U L=0.13U
M446_keeper Vdd GND #742 Vdd pmos W=0.0975U L=0.585U
M447_ Vdd O1_af_520_6 #fb747# Vdd pmos W=0.1625U L=0.13U
M448_keeper Vdd GND #745 Vdd pmos W=0.0975U L=0.26U
M449_ Vdd __o0t_521_6 #fb750# Vdd pmos W=0.1625U L=0.13U
M450_keeper Vdd GND #748 Vdd pmos W=0.0975U L=0.26U
M451_ Vdd __o0f_521_6 #fb753# Vdd pmos W=0.1625U L=0.13U
M452_keeper Vdd GND #751 Vdd pmos W=0.0975U L=0.585U
M453_ Vdd O1_at_521_6 #fb756# Vdd pmos W=0.1625U L=0.13U
M454_keeper Vdd GND #754 Vdd pmos W=0.0975U L=0.585U
M455_ Vdd O1_af_521_6 #fb759# Vdd pmos W=0.1625U L=0.13U
M456_keeper Vdd GND #757 Vdd pmos W=0.0975U L=0.26U
M457_ Vdd __o0t_522_6 #fb762# Vdd pmos W=0.1625U L=0.13U
M458_keeper Vdd GND #760 Vdd pmos W=0.0975U L=0.26U
M459_ Vdd __o0f_522_6 #fb765# Vdd pmos W=0.1625U L=0.13U
M460_keeper Vdd GND #763 Vdd pmos W=0.0975U L=0.585U
M461_ Vdd O1_at_522_6 #fb768# Vdd pmos W=0.1625U L=0.13U
M462_keeper Vdd GND #766 Vdd pmos W=0.0975U L=0.585U
M463_ Vdd O1_af_522_6 #fb771# Vdd pmos W=0.1625U L=0.13U
M464_keeper Vdd GND #769 Vdd pmos W=0.0975U L=0.26U
M465_ Vdd __o0t_523_6 #fb774# Vdd pmos W=0.1625U L=0.13U
M466_keeper Vdd GND #772 Vdd pmos W=0.0975U L=0.26U
M467_ Vdd __o0f_523_6 #fb777# Vdd pmos W=0.1625U L=0.13U
M468_keeper Vdd GND #775 Vdd pmos W=0.0975U L=0.585U
M469_ Vdd O1_at_523_6 #fb780# Vdd pmos W=0.1625U L=0.13U
M470_keeper Vdd GND #778 Vdd pmos W=0.0975U L=0.585U
M471_ Vdd O1_af_523_6 #fb783# Vdd pmos W=0.1625U L=0.13U
M472_keeper Vdd GND #781 Vdd pmos W=0.0975U L=0.26U
M473_ Vdd __o0t_524_6 #fb786# Vdd pmos W=0.1625U L=0.13U
M474_keeper Vdd GND #784 Vdd pmos W=0.0975U L=0.26U
M475_ Vdd __o0f_524_6 #fb789# Vdd pmos W=0.1625U L=0.13U
M476_keeper Vdd GND #787 Vdd pmos W=0.0975U L=0.585U
M477_ Vdd O1_at_524_6 #fb792# Vdd pmos W=0.1625U L=0.13U
M478_keeper Vdd GND #790 Vdd pmos W=0.0975U L=0.585U
M479_ Vdd O1_af_524_6 #fb795# Vdd pmos W=0.1625U L=0.13U
M480_keeper Vdd GND #793 Vdd pmos W=0.0975U L=0.26U
M481_ Vdd __o0t_525_6 #fb798# Vdd pmos W=0.1625U L=0.13U
M482_keeper Vdd GND #796 Vdd pmos W=0.0975U L=0.26U
M483_ Vdd __o0f_525_6 #fb801# Vdd pmos W=0.1625U L=0.13U
M484_keeper Vdd GND #799 Vdd pmos W=0.0975U L=0.585U
M485_ Vdd O1_at_525_6 #fb804# Vdd pmos W=0.1625U L=0.13U
M486_keeper Vdd GND #802 Vdd pmos W=0.0975U L=0.585U
M487_ Vdd O1_af_525_6 #fb807# Vdd pmos W=0.1625U L=0.13U
M488_keeper Vdd GND #805 Vdd pmos W=0.0975U L=0.26U
M489_ Vdd __o0t_526_6 #fb810# Vdd pmos W=0.1625U L=0.13U
M490_keeper Vdd GND #808 Vdd pmos W=0.0975U L=0.26U
M491_ Vdd __o0f_526_6 #fb813# Vdd pmos W=0.1625U L=0.13U
M492_keeper Vdd GND #811 Vdd pmos W=0.0975U L=0.585U
M493_ Vdd O1_at_526_6 #fb816# Vdd pmos W=0.1625U L=0.13U
M494_keeper Vdd GND #814 Vdd pmos W=0.0975U L=0.585U
M495_ Vdd O1_af_526_6 #fb819# Vdd pmos W=0.1625U L=0.13U
M496_keeper Vdd GND #817 Vdd pmos W=0.0975U L=0.26U
M497_ Vdd __o0t_527_6 #fb822# Vdd pmos W=0.1625U L=0.13U
M498_keeper Vdd GND #820 Vdd pmos W=0.0975U L=0.26U
M499_ Vdd __o0f_527_6 #fb825# Vdd pmos W=0.1625U L=0.13U
M500_keeper Vdd GND #823 Vdd pmos W=0.0975U L=0.585U
M501_ Vdd O1_at_527_6 #fb828# Vdd pmos W=0.1625U L=0.13U
M502_keeper Vdd GND #826 Vdd pmos W=0.0975U L=0.585U
M503_ Vdd O1_af_527_6 #fb831# Vdd pmos W=0.1625U L=0.13U
M504_keeper Vdd GND #829 Vdd pmos W=0.0975U L=0.26U
M505_ Vdd __o0t_528_6 #fb834# Vdd pmos W=0.1625U L=0.13U
M506_keeper Vdd GND #832 Vdd pmos W=0.0975U L=0.26U
M507_ Vdd __o0f_528_6 #fb837# Vdd pmos W=0.1625U L=0.13U
M508_keeper Vdd GND #835 Vdd pmos W=0.0975U L=0.585U
M509_ Vdd O1_at_528_6 #fb840# Vdd pmos W=0.1625U L=0.13U
M510_keeper Vdd GND #838 Vdd pmos W=0.0975U L=0.585U
M511_ Vdd O1_af_528_6 #fb843# Vdd pmos W=0.1625U L=0.13U
M512_keeper Vdd GND #841 Vdd pmos W=0.0975U L=0.26U
M513_ Vdd __o0t_529_6 #fb846# Vdd pmos W=0.1625U L=0.13U
M514_keeper Vdd GND #844 Vdd pmos W=0.0975U L=0.26U
M515_ Vdd __o0f_529_6 #fb849# Vdd pmos W=0.1625U L=0.13U
M516_keeper Vdd GND #847 Vdd pmos W=0.0975U L=0.585U
M517_ Vdd O1_at_529_6 #fb852# Vdd pmos W=0.1625U L=0.13U
M518_keeper Vdd GND #850 Vdd pmos W=0.0975U L=0.585U
M519_ Vdd O1_af_529_6 #fb855# Vdd pmos W=0.1625U L=0.13U
M520_keeper Vdd GND #853 Vdd pmos W=0.0975U L=0.26U
M521_ Vdd __o0t_530_6 #fb858# Vdd pmos W=0.1625U L=0.13U
M522_keeper Vdd GND #856 Vdd pmos W=0.0975U L=0.26U
M523_ Vdd __o0f_530_6 #fb861# Vdd pmos W=0.1625U L=0.13U
M524_keeper Vdd GND #859 Vdd pmos W=0.0975U L=0.585U
M525_ Vdd O1_at_530_6 #fb864# Vdd pmos W=0.1625U L=0.13U
M526_keeper Vdd GND #862 Vdd pmos W=0.0975U L=0.585U
M527_ Vdd O1_af_530_6 #fb867# Vdd pmos W=0.1625U L=0.13U
M528_keeper Vdd GND #865 Vdd pmos W=0.0975U L=0.26U
M529_ Vdd __o0t_531_6 #fb870# Vdd pmos W=0.1625U L=0.13U
M530_keeper Vdd GND #868 Vdd pmos W=0.0975U L=0.26U
M531_ Vdd __o0f_531_6 #fb873# Vdd pmos W=0.1625U L=0.13U
M532_keeper Vdd GND #871 Vdd pmos W=0.0975U L=0.585U
M533_ Vdd O1_at_531_6 #fb876# Vdd pmos W=0.1625U L=0.13U
M534_keeper Vdd GND #874 Vdd pmos W=0.0975U L=0.585U
M535_ Vdd O1_af_531_6 #fb879# Vdd pmos W=0.1625U L=0.13U
M536_keeper Vdd GND #877 Vdd pmos W=0.0975U L=0.26U
M537_keeper Vdd GND #880 Vdd pmos W=0.0975U L=0.26U
M538_ GND I_at_50_6 #3 GND nmos W=0.0975U L=0.065U
M539_ GND I_at_57_6 #6 GND nmos W=0.0975U L=0.065U
M540_ GND I_at_56_6 #6 GND nmos W=0.0975U L=0.065U
M541_ GND I_at_55_6 #6 GND nmos W=0.0975U L=0.065U
M542_ GND I_at_54_6 #6 GND nmos W=0.0975U L=0.065U
M543_ GND I_af_50_6 #16 GND nmos W=0.0975U L=0.065U
M544_ GND I_af_57_6 #21 GND nmos W=0.0975U L=0.065U
M545_ GND __w0 #34 GND nmos W=0.0975U L=0.065U
M546_ GND w1 #36 GND nmos W=0.0975U L=0.065U
M547_ GND __w0 #43 GND nmos W=0.0975U L=0.065U
M548_ GND p #45 GND nmos W=0.0975U L=0.065U
M549_ GND p #47 GND nmos W=0.0975U L=0.065U
M550_ GND __i__t_50_6 O1_at_50_6 GND nmos W=0.0975U L=0.065U
M551_ GND __i__f_50_6 O1_af_50_6 GND nmos W=0.0975U L=0.065U
M552_ GND p #55 GND nmos W=0.0975U L=0.065U
M553_ GND p #58 GND nmos W=0.0975U L=0.065U
M554_ GND __i__t_51_6 O1_at_51_6 GND nmos W=0.0975U L=0.065U
M555_ GND __i__f_51_6 O1_af_51_6 GND nmos W=0.0975U L=0.065U
M556_ GND p #67 GND nmos W=0.0975U L=0.065U
M557_ GND p #70 GND nmos W=0.0975U L=0.065U
M558_ GND __i__t_52_6 O1_at_52_6 GND nmos W=0.0975U L=0.065U
M559_ GND __i__f_52_6 O1_af_52_6 GND nmos W=0.0975U L=0.065U
M560_ GND p #79 GND nmos W=0.0975U L=0.065U
M561_ GND p #82 GND nmos W=0.0975U L=0.065U
M562_ GND __i__t_53_6 O1_at_53_6 GND nmos W=0.0975U L=0.065U
M563_ GND __i__f_53_6 O1_af_53_6 GND nmos W=0.0975U L=0.065U
M564_ GND p #91 GND nmos W=0.0975U L=0.065U
M565_ GND p #93 GND nmos W=0.0975U L=0.065U
M566_ GND __i__t_54_6 O1_at_54_6 GND nmos W=0.0975U L=0.065U
M567_ GND __i__f_54_6 O1_af_54_6 GND nmos W=0.0975U L=0.065U
M568_ GND p #101 GND nmos W=0.0975U L=0.065U
M569_ GND p #103 GND nmos W=0.0975U L=0.065U
M570_ GND __i__t_55_6 O1_at_55_6 GND nmos W=0.0975U L=0.065U
M571_ GND __i__f_55_6 O1_af_55_6 GND nmos W=0.0975U L=0.065U
M572_ GND p #111 GND nmos W=0.0975U L=0.065U
M573_ GND p #113 GND nmos W=0.0975U L=0.065U
M574_ GND __i__t_56_6 O1_at_56_6 GND nmos W=0.0975U L=0.065U
M575_ GND __i__f_56_6 O1_af_56_6 GND nmos W=0.0975U L=0.065U
M576_ GND p #121 GND nmos W=0.0975U L=0.065U
M577_ GND p #123 GND nmos W=0.0975U L=0.065U
M578_ GND __i__t_57_6 O1_at_57_6 GND nmos W=0.0975U L=0.065U
M579_ GND __i__f_57_6 O1_af_57_6 GND nmos W=0.0975U L=0.065U
M580_ GND p #131 GND nmos W=0.0975U L=0.065U
M581_ GND p #134 GND nmos W=0.0975U L=0.065U
M582_ GND __i__t_58_6 O1_at_58_6 GND nmos W=0.0975U L=0.065U
M583_ GND __i__f_58_6 O1_af_58_6 GND nmos W=0.0975U L=0.065U
M584_ GND p #143 GND nmos W=0.0975U L=0.065U
M585_ GND p #146 GND nmos W=0.0975U L=0.065U
M586_ GND __i__t_59_6 O1_at_59_6 GND nmos W=0.0975U L=0.065U
M587_ GND __i__f_59_6 O1_af_59_6 GND nmos W=0.0975U L=0.065U
M588_ GND p #155 GND nmos W=0.0975U L=0.065U
M589_ GND p #158 GND nmos W=0.0975U L=0.065U
M590_ GND __i__t_510_6 O1_at_510_6 GND nmos W=0.0975U L=0.065U
M591_ GND __i__f_510_6 O1_af_510_6 GND nmos W=0.0975U L=0.065U
M592_ GND p #167 GND nmos W=0.0975U L=0.065U
M593_ GND p #170 GND nmos W=0.0975U L=0.065U
M594_ GND __i__t_511_6 O1_at_511_6 GND nmos W=0.0975U L=0.065U
M595_ GND __i__f_511_6 O1_af_511_6 GND nmos W=0.0975U L=0.065U
M596_ GND p #179 GND nmos W=0.0975U L=0.065U
M597_ GND p #182 GND nmos W=0.0975U L=0.065U
M598_ GND __i__t_512_6 O1_at_512_6 GND nmos W=0.0975U L=0.065U
M599_ GND __i__f_512_6 O1_af_512_6 GND nmos W=0.0975U L=0.065U
M600_ GND p #191 GND nmos W=0.0975U L=0.065U
M601_ GND p #194 GND nmos W=0.0975U L=0.065U
M602_ GND __i__t_513_6 O1_at_513_6 GND nmos W=0.0975U L=0.065U
M603_ GND __i__f_513_6 O1_af_513_6 GND nmos W=0.0975U L=0.065U
M604_ GND p #203 GND nmos W=0.0975U L=0.065U
M605_ GND p #206 GND nmos W=0.0975U L=0.065U
M606_ GND __i__t_514_6 O1_at_514_6 GND nmos W=0.0975U L=0.065U
M607_ GND __i__f_514_6 O1_af_514_6 GND nmos W=0.0975U L=0.065U
M608_ GND p #215 GND nmos W=0.0975U L=0.065U
M609_ GND p #218 GND nmos W=0.0975U L=0.065U
M610_ GND __i__t_515_6 O1_at_515_6 GND nmos W=0.0975U L=0.065U
M611_ GND __i__f_515_6 O1_af_515_6 GND nmos W=0.0975U L=0.065U
M612_ GND p #227 GND nmos W=0.0975U L=0.065U
M613_ GND p #230 GND nmos W=0.0975U L=0.065U
M614_ GND __i__t_516_6 O1_at_516_6 GND nmos W=0.0975U L=0.065U
M615_ GND __i__f_516_6 O1_af_516_6 GND nmos W=0.0975U L=0.065U
M616_ GND p #239 GND nmos W=0.0975U L=0.065U
M617_ GND p #242 GND nmos W=0.0975U L=0.065U
M618_ GND __i__t_517_6 O1_at_517_6 GND nmos W=0.0975U L=0.065U
M619_ GND __i__f_517_6 O1_af_517_6 GND nmos W=0.0975U L=0.065U
M620_ GND p #251 GND nmos W=0.0975U L=0.065U
M621_ GND p #254 GND nmos W=0.0975U L=0.065U
M622_ GND __i__t_518_6 O1_at_518_6 GND nmos W=0.0975U L=0.065U
M623_ GND __i__f_518_6 O1_af_518_6 GND nmos W=0.0975U L=0.065U
M624_ GND p #263 GND nmos W=0.0975U L=0.065U
M625_ GND p #266 GND nmos W=0.0975U L=0.065U
M626_ GND __i__t_519_6 O1_at_519_6 GND nmos W=0.0975U L=0.065U
M627_ GND __i__f_519_6 O1_af_519_6 GND nmos W=0.0975U L=0.065U
M628_ GND p #275 GND nmos W=0.0975U L=0.065U
M629_ GND p #278 GND nmos W=0.0975U L=0.065U
M630_ GND __i__t_520_6 O1_at_520_6 GND nmos W=0.0975U L=0.065U
M631_ GND __i__f_520_6 O1_af_520_6 GND nmos W=0.0975U L=0.065U
M632_ GND p #287 GND nmos W=0.0975U L=0.065U
M633_ GND p #290 GND nmos W=0.0975U L=0.065U
M634_ GND __i__t_521_6 O1_at_521_6 GND nmos W=0.0975U L=0.065U
M635_ GND __i__f_521_6 O1_af_521_6 GND nmos W=0.0975U L=0.065U
M636_ GND p #299 GND nmos W=0.0975U L=0.065U
M637_ GND p #302 GND nmos W=0.0975U L=0.065U
M638_ GND __i__t_522_6 O1_at_522_6 GND nmos W=0.0975U L=0.065U
M639_ GND __i__f_522_6 O1_af_522_6 GND nmos W=0.0975U L=0.065U
M640_ GND p #311 GND nmos W=0.0975U L=0.065U
M641_ GND p #314 GND nmos W=0.0975U L=0.065U
M642_ GND __i__t_523_6 O1_at_523_6 GND nmos W=0.0975U L=0.065U
M643_ GND __i__f_523_6 O1_af_523_6 GND nmos W=0.0975U L=0.065U
M644_ GND p #323 GND nmos W=0.0975U L=0.065U
M645_ GND p #326 GND nmos W=0.0975U L=0.065U
M646_ GND __i__t_524_6 O1_at_524_6 GND nmos W=0.0975U L=0.065U
M647_ GND __i__f_524_6 O1_af_524_6 GND nmos W=0.0975U L=0.065U
M648_ GND p #335 GND nmos W=0.0975U L=0.065U
M649_ GND p #338 GND nmos W=0.0975U L=0.065U
M650_ GND __i__t_525_6 O1_at_525_6 GND nmos W=0.0975U L=0.065U
M651_ GND __i__f_525_6 O1_af_525_6 GND nmos W=0.0975U L=0.065U
M652_ GND p #347 GND nmos W=0.0975U L=0.065U
M653_ GND p #350 GND nmos W=0.0975U L=0.065U
M654_ GND __i__t_526_6 O1_at_526_6 GND nmos W=0.0975U L=0.065U
M655_ GND __i__f_526_6 O1_af_526_6 GND nmos W=0.0975U L=0.065U
M656_ GND p #359 GND nmos W=0.0975U L=0.065U
M657_ GND p #362 GND nmos W=0.0975U L=0.065U
M658_ GND __i__t_527_6 O1_at_527_6 GND nmos W=0.0975U L=0.065U
M659_ GND __i__f_527_6 O1_af_527_6 GND nmos W=0.0975U L=0.065U
M660_ GND p #371 GND nmos W=0.0975U L=0.065U
M661_ GND p #374 GND nmos W=0.0975U L=0.065U
M662_ GND __i__t_528_6 O1_at_528_6 GND nmos W=0.0975U L=0.065U
M663_ GND __i__f_528_6 O1_af_528_6 GND nmos W=0.0975U L=0.065U
M664_ GND p #383 GND nmos W=0.0975U L=0.065U
M665_ GND p #386 GND nmos W=0.0975U L=0.065U
M666_ GND __i__t_529_6 O1_at_529_6 GND nmos W=0.0975U L=0.065U
M667_ GND __i__f_529_6 O1_af_529_6 GND nmos W=0.0975U L=0.065U
M668_ GND p #395 GND nmos W=0.0975U L=0.065U
M669_ GND p #398 GND nmos W=0.0975U L=0.065U
M670_ GND __i__t_530_6 O1_at_530_6 GND nmos W=0.0975U L=0.065U
M671_ GND __i__f_530_6 O1_af_530_6 GND nmos W=0.0975U L=0.065U
M672_ GND p #407 GND nmos W=0.0975U L=0.065U
M673_ GND p #410 GND nmos W=0.0975U L=0.065U
M674_ GND __i__t_531_6 O1_at_531_6 GND nmos W=0.0975U L=0.065U
M675_ GND __i__f_531_6 O1_af_531_6 GND nmos W=0.0975U L=0.065U
M676_ GND p __p GND nmos W=0.0975U L=0.065U
M677_ GND a __a GND nmos W=0.0975U L=0.065U
M678_ GND I_aa __i__a GND nmos W=0.0975U L=0.065U
M679_ GND reset __r GND nmos W=0.0975U L=0.065U
M680_ GND __w1 w1 GND nmos W=0.0975U L=0.065U
M681_ GND O0_aa __o0a GND nmos W=0.0975U L=0.065U
M682_ GND O1_aa __o1a GND nmos W=0.0975U L=0.065U
M683_ GND I_at_50_6 __i__t_50_6 GND nmos W=0.0975U L=0.065U
M684_ GND I_af_50_6 __i__f_50_6 GND nmos W=0.0975U L=0.065U
M685_ GND __o0t_50_6 O0_at_50_6 GND nmos W=0.0975U L=0.065U
M686_ GND __o0f_50_6 O0_af_50_6 GND nmos W=0.0975U L=0.065U
M687_ GND I_at_51_6 __i__t_51_6 GND nmos W=0.0975U L=0.065U
M688_ GND I_af_51_6 __i__f_51_6 GND nmos W=0.0975U L=0.065U
M689_ GND __o0t_51_6 O0_at_51_6 GND nmos W=0.0975U L=0.065U
M690_ GND __o0f_51_6 O0_af_51_6 GND nmos W=0.0975U L=0.065U
M691_ GND I_at_52_6 __i__t_52_6 GND nmos W=0.0975U L=0.065U
M692_ GND I_af_52_6 __i__f_52_6 GND nmos W=0.0975U L=0.065U
M693_ GND __o0t_52_6 O0_at_52_6 GND nmos W=0.0975U L=0.065U
M694_ GND __o0f_52_6 O0_af_52_6 GND nmos W=0.0975U L=0.065U
M695_ GND I_at_53_6 __i__t_53_6 GND nmos W=0.0975U L=0.065U
M696_ GND I_af_53_6 __i__f_53_6 GND nmos W=0.0975U L=0.065U
M697_ GND __o0t_53_6 O0_at_53_6 GND nmos W=0.0975U L=0.065U
M698_ GND __o0f_53_6 O0_af_53_6 GND nmos W=0.0975U L=0.065U
M699_ GND I_at_54_6 __i__t_54_6 GND nmos W=0.0975U L=0.065U
M700_ GND I_af_54_6 __i__f_54_6 GND nmos W=0.0975U L=0.065U
M701_ GND __o0t_54_6 O0_at_54_6 GND nmos W=0.0975U L=0.065U
M702_ GND __o0f_54_6 O0_af_54_6 GND nmos W=0.0975U L=0.065U
M703_ GND I_at_55_6 __i__t_55_6 GND nmos W=0.0975U L=0.065U
M704_ GND I_af_55_6 __i__f_55_6 GND nmos W=0.0975U L=0.065U
M705_ GND __o0t_55_6 O0_at_55_6 GND nmos W=0.0975U L=0.065U
M706_ GND __o0f_55_6 O0_af_55_6 GND nmos W=0.0975U L=0.065U
M707_ GND I_at_56_6 __i__t_56_6 GND nmos W=0.0975U L=0.065U
M708_ GND I_af_56_6 __i__f_56_6 GND nmos W=0.0975U L=0.065U
M709_ GND __o0t_56_6 O0_at_56_6 GND nmos W=0.0975U L=0.065U
M710_ GND __o0f_56_6 O0_af_56_6 GND nmos W=0.0975U L=0.065U
M711_ GND I_at_57_6 __i__t_57_6 GND nmos W=0.0975U L=0.065U
M712_ GND I_af_57_6 __i__f_57_6 GND nmos W=0.0975U L=0.065U
M713_ GND __o0t_57_6 O0_at_57_6 GND nmos W=0.0975U L=0.065U
M714_ GND __o0f_57_6 O0_af_57_6 GND nmos W=0.0975U L=0.065U
M715_ GND I_at_58_6 __i__t_58_6 GND nmos W=0.0975U L=0.065U
M716_ GND I_af_58_6 __i__f_58_6 GND nmos W=0.0975U L=0.065U
M717_ GND __o0t_58_6 O0_at_58_6 GND nmos W=0.0975U L=0.065U
M718_ GND __o0f_58_6 O0_af_58_6 GND nmos W=0.0975U L=0.065U
M719_ GND I_at_59_6 __i__t_59_6 GND nmos W=0.0975U L=0.065U
M720_ GND I_af_59_6 __i__f_59_6 GND nmos W=0.0975U L=0.065U
M721_ GND __o0t_59_6 O0_at_59_6 GND nmos W=0.0975U L=0.065U
M722_ GND __o0f_59_6 O0_af_59_6 GND nmos W=0.0975U L=0.065U
M723_ GND I_at_510_6 __i__t_510_6 GND nmos W=0.0975U L=0.065U
M724_ GND I_af_510_6 __i__f_510_6 GND nmos W=0.0975U L=0.065U
M725_ GND __o0t_510_6 O0_at_510_6 GND nmos W=0.0975U L=0.065U
M726_ GND __o0f_510_6 O0_af_510_6 GND nmos W=0.0975U L=0.065U
M727_ GND I_at_511_6 __i__t_511_6 GND nmos W=0.0975U L=0.065U
M728_ GND I_af_511_6 __i__f_511_6 GND nmos W=0.0975U L=0.065U
M729_ GND __o0t_511_6 O0_at_511_6 GND nmos W=0.0975U L=0.065U
M730_ GND __o0f_511_6 O0_af_511_6 GND nmos W=0.0975U L=0.065U
M731_ GND I_at_512_6 __i__t_512_6 GND nmos W=0.0975U L=0.065U
M732_ GND I_af_512_6 __i__f_512_6 GND nmos W=0.0975U L=0.065U
M733_ GND __o0t_512_6 O0_at_512_6 GND nmos W=0.0975U L=0.065U
M734_ GND __o0f_512_6 O0_af_512_6 GND nmos W=0.0975U L=0.065U
M735_ GND I_at_513_6 __i__t_513_6 GND nmos W=0.0975U L=0.065U
M736_ GND I_af_513_6 __i__f_513_6 GND nmos W=0.0975U L=0.065U
M737_ GND __o0t_513_6 O0_at_513_6 GND nmos W=0.0975U L=0.065U
M738_ GND __o0f_513_6 O0_af_513_6 GND nmos W=0.0975U L=0.065U
M739_ GND I_at_514_6 __i__t_514_6 GND nmos W=0.0975U L=0.065U
M740_ GND I_af_514_6 __i__f_514_6 GND nmos W=0.0975U L=0.065U
M741_ GND __o0t_514_6 O0_at_514_6 GND nmos W=0.0975U L=0.065U
M742_ GND __o0f_514_6 O0_af_514_6 GND nmos W=0.0975U L=0.065U
M743_ GND I_at_515_6 __i__t_515_6 GND nmos W=0.0975U L=0.065U
M744_ GND I_af_515_6 __i__f_515_6 GND nmos W=0.0975U L=0.065U
M745_ GND __o0t_515_6 O0_at_515_6 GND nmos W=0.0975U L=0.065U
M746_ GND __o0f_515_6 O0_af_515_6 GND nmos W=0.0975U L=0.065U
M747_ GND I_at_516_6 __i__t_516_6 GND nmos W=0.0975U L=0.065U
M748_ GND I_af_516_6 __i__f_516_6 GND nmos W=0.0975U L=0.065U
M749_ GND __o0t_516_6 O0_at_516_6 GND nmos W=0.0975U L=0.065U
M750_ GND __o0f_516_6 O0_af_516_6 GND nmos W=0.0975U L=0.065U
M751_ GND I_at_517_6 __i__t_517_6 GND nmos W=0.0975U L=0.065U
M752_ GND I_af_517_6 __i__f_517_6 GND nmos W=0.0975U L=0.065U
M753_ GND __o0t_517_6 O0_at_517_6 GND nmos W=0.0975U L=0.065U
M754_ GND __o0f_517_6 O0_af_517_6 GND nmos W=0.0975U L=0.065U
M755_ GND I_at_518_6 __i__t_518_6 GND nmos W=0.0975U L=0.065U
M756_ GND I_af_518_6 __i__f_518_6 GND nmos W=0.0975U L=0.065U
M757_ GND __o0t_518_6 O0_at_518_6 GND nmos W=0.0975U L=0.065U
M758_ GND __o0f_518_6 O0_af_518_6 GND nmos W=0.0975U L=0.065U
M759_ GND I_at_519_6 __i__t_519_6 GND nmos W=0.0975U L=0.065U
M760_ GND I_af_519_6 __i__f_519_6 GND nmos W=0.0975U L=0.065U
M761_ GND __o0t_519_6 O0_at_519_6 GND nmos W=0.0975U L=0.065U
M762_ GND __o0f_519_6 O0_af_519_6 GND nmos W=0.0975U L=0.065U
M763_ GND I_at_520_6 __i__t_520_6 GND nmos W=0.0975U L=0.065U
M764_ GND I_af_520_6 __i__f_520_6 GND nmos W=0.0975U L=0.065U
M765_ GND __o0t_520_6 O0_at_520_6 GND nmos W=0.0975U L=0.065U
M766_ GND __o0f_520_6 O0_af_520_6 GND nmos W=0.0975U L=0.065U
M767_ GND I_at_521_6 __i__t_521_6 GND nmos W=0.0975U L=0.065U
M768_ GND I_af_521_6 __i__f_521_6 GND nmos W=0.0975U L=0.065U
M769_ GND __o0t_521_6 O0_at_521_6 GND nmos W=0.0975U L=0.065U
M770_ GND __o0f_521_6 O0_af_521_6 GND nmos W=0.0975U L=0.065U
M771_ GND I_at_522_6 __i__t_522_6 GND nmos W=0.0975U L=0.065U
M772_ GND I_af_522_6 __i__f_522_6 GND nmos W=0.0975U L=0.065U
M773_ GND __o0t_522_6 O0_at_522_6 GND nmos W=0.0975U L=0.065U
M774_ GND __o0f_522_6 O0_af_522_6 GND nmos W=0.0975U L=0.065U
M775_ GND I_at_523_6 __i__t_523_6 GND nmos W=0.0975U L=0.065U
M776_ GND I_af_523_6 __i__f_523_6 GND nmos W=0.0975U L=0.065U
M777_ GND __o0t_523_6 O0_at_523_6 GND nmos W=0.0975U L=0.065U
M778_ GND __o0f_523_6 O0_af_523_6 GND nmos W=0.0975U L=0.065U
M779_ GND I_at_524_6 __i__t_524_6 GND nmos W=0.0975U L=0.065U
M780_ GND I_af_524_6 __i__f_524_6 GND nmos W=0.0975U L=0.065U
M781_ GND __o0t_524_6 O0_at_524_6 GND nmos W=0.0975U L=0.065U
M782_ GND __o0f_524_6 O0_af_524_6 GND nmos W=0.0975U L=0.065U
M783_ GND I_at_525_6 __i__t_525_6 GND nmos W=0.0975U L=0.065U
M784_ GND I_af_525_6 __i__f_525_6 GND nmos W=0.0975U L=0.065U
M785_ GND __o0t_525_6 O0_at_525_6 GND nmos W=0.0975U L=0.065U
M786_ GND __o0f_525_6 O0_af_525_6 GND nmos W=0.0975U L=0.065U
M787_ GND I_at_526_6 __i__t_526_6 GND nmos W=0.0975U L=0.065U
M788_ GND I_af_526_6 __i__f_526_6 GND nmos W=0.0975U L=0.065U
M789_ GND __o0t_526_6 O0_at_526_6 GND nmos W=0.0975U L=0.065U
M790_ GND __o0f_526_6 O0_af_526_6 GND nmos W=0.0975U L=0.065U
M791_ GND I_at_527_6 __i__t_527_6 GND nmos W=0.0975U L=0.065U
M792_ GND I_af_527_6 __i__f_527_6 GND nmos W=0.0975U L=0.065U
M793_ GND __o0t_527_6 O0_at_527_6 GND nmos W=0.0975U L=0.065U
M794_ GND __o0f_527_6 O0_af_527_6 GND nmos W=0.0975U L=0.065U
M795_ GND I_at_528_6 __i__t_528_6 GND nmos W=0.0975U L=0.065U
M796_ GND I_af_528_6 __i__f_528_6 GND nmos W=0.0975U L=0.065U
M797_ GND __o0t_528_6 O0_at_528_6 GND nmos W=0.0975U L=0.065U
M798_ GND __o0f_528_6 O0_af_528_6 GND nmos W=0.0975U L=0.065U
M799_ GND I_at_529_6 __i__t_529_6 GND nmos W=0.0975U L=0.065U
M800_ GND I_af_529_6 __i__f_529_6 GND nmos W=0.0975U L=0.065U
M801_ GND __o0t_529_6 O0_at_529_6 GND nmos W=0.0975U L=0.065U
M802_ GND __o0f_529_6 O0_af_529_6 GND nmos W=0.0975U L=0.065U
M803_ GND I_at_530_6 __i__t_530_6 GND nmos W=0.0975U L=0.065U
M804_ GND I_af_530_6 __i__f_530_6 GND nmos W=0.0975U L=0.065U
M805_ GND __o0t_530_6 O0_at_530_6 GND nmos W=0.0975U L=0.065U
M806_ GND __o0f_530_6 O0_af_530_6 GND nmos W=0.0975U L=0.065U
M807_ GND I_at_531_6 __i__t_531_6 GND nmos W=0.0975U L=0.065U
M808_ GND I_af_531_6 __i__f_531_6 GND nmos W=0.0975U L=0.065U
M809_ GND __o0t_531_6 O0_at_531_6 GND nmos W=0.0975U L=0.065U
M810_ GND __o0f_531_6 O0_af_531_6 GND nmos W=0.0975U L=0.065U
M811_ GND __w0 #fb483# GND nmos W=0.0975U L=0.13U
M812_ GND p #fb486# GND nmos W=0.0975U L=0.13U
M813_keeper GND Vdd #485 GND nmos W=0.0975U L=1.495U
M814_ GND __w1 #fb489# GND nmos W=0.0975U L=0.13U
M815_keeper GND Vdd #488 GND nmos W=0.0975U L=1.495U
M816_ GND a #fb492# GND nmos W=0.0975U L=0.13U
M817_keeper GND Vdd #491 GND nmos W=0.0975U L=1.495U
M818_ GND I_aa #fb495# GND nmos W=0.0975U L=0.13U
M819_keeper GND Vdd #494 GND nmos W=0.0975U L=3.055U
M820_ GND __o0t_50_6 #fb498# GND nmos W=0.0975U L=0.13U
M821_keeper GND Vdd #497 GND nmos W=0.0975U L=1.495U
M822_ GND __o0f_50_6 #fb501# GND nmos W=0.0975U L=0.13U
M823_keeper GND Vdd #500 GND nmos W=0.0975U L=0.715U
M824_ GND O1_at_50_6 #fb504# GND nmos W=0.0975U L=0.13U
M825_keeper GND Vdd #503 GND nmos W=0.0975U L=0.715U
M826_ GND O1_af_50_6 #fb507# GND nmos W=0.0975U L=0.13U
M827_keeper GND Vdd #506 GND nmos W=0.0975U L=1.495U
M828_ GND __o0t_51_6 #fb510# GND nmos W=0.0975U L=0.13U
M829_keeper GND Vdd #509 GND nmos W=0.0975U L=1.495U
M830_ GND __o0f_51_6 #fb513# GND nmos W=0.0975U L=0.13U
M831_keeper GND Vdd #512 GND nmos W=0.0975U L=0.715U
M832_ GND O1_at_51_6 #fb516# GND nmos W=0.0975U L=0.13U
M833_keeper GND Vdd #515 GND nmos W=0.0975U L=0.715U
M834_ GND O1_af_51_6 #fb519# GND nmos W=0.0975U L=0.13U
M835_keeper GND Vdd #518 GND nmos W=0.0975U L=1.495U
M836_ GND __o0t_52_6 #fb522# GND nmos W=0.0975U L=0.13U
M837_keeper GND Vdd #521 GND nmos W=0.0975U L=1.495U
M838_ GND __o0f_52_6 #fb525# GND nmos W=0.0975U L=0.13U
M839_keeper GND Vdd #524 GND nmos W=0.0975U L=0.715U
M840_ GND O1_at_52_6 #fb528# GND nmos W=0.0975U L=0.13U
M841_keeper GND Vdd #527 GND nmos W=0.0975U L=0.715U
M842_ GND O1_af_52_6 #fb531# GND nmos W=0.0975U L=0.13U
M843_keeper GND Vdd #530 GND nmos W=0.0975U L=1.495U
M844_ GND __o0t_53_6 #fb534# GND nmos W=0.0975U L=0.13U
M845_keeper GND Vdd #533 GND nmos W=0.0975U L=1.495U
M846_ GND __o0f_53_6 #fb537# GND nmos W=0.0975U L=0.13U
M847_keeper GND Vdd #536 GND nmos W=0.0975U L=0.715U
M848_ GND O1_at_53_6 #fb540# GND nmos W=0.0975U L=0.13U
M849_keeper GND Vdd #539 GND nmos W=0.0975U L=0.715U
M850_ GND O1_af_53_6 #fb543# GND nmos W=0.0975U L=0.13U
M851_keeper GND Vdd #542 GND nmos W=0.0975U L=1.495U
M852_ GND __o0t_54_6 #fb546# GND nmos W=0.0975U L=0.13U
M853_keeper GND Vdd #545 GND nmos W=0.0975U L=1.495U
M854_ GND __o0f_54_6 #fb549# GND nmos W=0.0975U L=0.13U
M855_keeper GND Vdd #548 GND nmos W=0.0975U L=0.715U
M856_ GND O1_at_54_6 #fb552# GND nmos W=0.0975U L=0.13U
M857_keeper GND Vdd #551 GND nmos W=0.0975U L=0.715U
M858_ GND O1_af_54_6 #fb555# GND nmos W=0.0975U L=0.13U
M859_keeper GND Vdd #554 GND nmos W=0.0975U L=1.495U
M860_ GND __o0t_55_6 #fb558# GND nmos W=0.0975U L=0.13U
M861_keeper GND Vdd #557 GND nmos W=0.0975U L=1.495U
M862_ GND __o0f_55_6 #fb561# GND nmos W=0.0975U L=0.13U
M863_keeper GND Vdd #560 GND nmos W=0.0975U L=0.715U
M864_ GND O1_at_55_6 #fb564# GND nmos W=0.0975U L=0.13U
M865_keeper GND Vdd #563 GND nmos W=0.0975U L=0.715U
M866_ GND O1_af_55_6 #fb567# GND nmos W=0.0975U L=0.13U
M867_keeper GND Vdd #566 GND nmos W=0.0975U L=1.495U
M868_ GND __o0t_56_6 #fb570# GND nmos W=0.0975U L=0.13U
M869_keeper GND Vdd #569 GND nmos W=0.0975U L=1.495U
M870_ GND __o0f_56_6 #fb573# GND nmos W=0.0975U L=0.13U
M871_keeper GND Vdd #572 GND nmos W=0.0975U L=0.715U
M872_ GND O1_at_56_6 #fb576# GND nmos W=0.0975U L=0.13U
M873_keeper GND Vdd #575 GND nmos W=0.0975U L=0.715U
M874_ GND O1_af_56_6 #fb579# GND nmos W=0.0975U L=0.13U
M875_keeper GND Vdd #578 GND nmos W=0.0975U L=1.495U
M876_ GND __o0t_57_6 #fb582# GND nmos W=0.0975U L=0.13U
M877_keeper GND Vdd #581 GND nmos W=0.0975U L=1.495U
M878_ GND __o0f_57_6 #fb585# GND nmos W=0.0975U L=0.13U
M879_keeper GND Vdd #584 GND nmos W=0.0975U L=0.715U
M880_ GND O1_at_57_6 #fb588# GND nmos W=0.0975U L=0.13U
M881_keeper GND Vdd #587 GND nmos W=0.0975U L=0.715U
M882_ GND O1_af_57_6 #fb591# GND nmos W=0.0975U L=0.13U
M883_keeper GND Vdd #590 GND nmos W=0.0975U L=1.495U
M884_ GND __o0t_58_6 #fb594# GND nmos W=0.0975U L=0.13U
M885_keeper GND Vdd #593 GND nmos W=0.0975U L=1.495U
M886_ GND __o0f_58_6 #fb597# GND nmos W=0.0975U L=0.13U
M887_keeper GND Vdd #596 GND nmos W=0.0975U L=0.715U
M888_ GND O1_at_58_6 #fb600# GND nmos W=0.0975U L=0.13U
M889_keeper GND Vdd #599 GND nmos W=0.0975U L=0.715U
M890_ GND O1_af_58_6 #fb603# GND nmos W=0.0975U L=0.13U
M891_keeper GND Vdd #602 GND nmos W=0.0975U L=1.495U
M892_ GND __o0t_59_6 #fb606# GND nmos W=0.0975U L=0.13U
M893_keeper GND Vdd #605 GND nmos W=0.0975U L=1.495U
M894_ GND __o0f_59_6 #fb609# GND nmos W=0.0975U L=0.13U
M895_keeper GND Vdd #608 GND nmos W=0.0975U L=0.715U
M896_ GND O1_at_59_6 #fb612# GND nmos W=0.0975U L=0.13U
M897_keeper GND Vdd #611 GND nmos W=0.0975U L=0.715U
M898_ GND O1_af_59_6 #fb615# GND nmos W=0.0975U L=0.13U
M899_keeper GND Vdd #614 GND nmos W=0.0975U L=1.495U
M900_ GND __o0t_510_6 #fb618# GND nmos W=0.0975U L=0.13U
M901_keeper GND Vdd #617 GND nmos W=0.0975U L=1.495U
M902_ GND __o0f_510_6 #fb621# GND nmos W=0.0975U L=0.13U
M903_keeper GND Vdd #620 GND nmos W=0.0975U L=0.715U
M904_ GND O1_at_510_6 #fb624# GND nmos W=0.0975U L=0.13U
M905_keeper GND Vdd #623 GND nmos W=0.0975U L=0.715U
M906_ GND O1_af_510_6 #fb627# GND nmos W=0.0975U L=0.13U
M907_keeper GND Vdd #626 GND nmos W=0.0975U L=1.495U
M908_ GND __o0t_511_6 #fb630# GND nmos W=0.0975U L=0.13U
M909_keeper GND Vdd #629 GND nmos W=0.0975U L=1.495U
M910_ GND __o0f_511_6 #fb633# GND nmos W=0.0975U L=0.13U
M911_keeper GND Vdd #632 GND nmos W=0.0975U L=0.715U
M912_ GND O1_at_511_6 #fb636# GND nmos W=0.0975U L=0.13U
M913_keeper GND Vdd #635 GND nmos W=0.0975U L=0.715U
M914_ GND O1_af_511_6 #fb639# GND nmos W=0.0975U L=0.13U
M915_keeper GND Vdd #638 GND nmos W=0.0975U L=1.495U
M916_ GND __o0t_512_6 #fb642# GND nmos W=0.0975U L=0.13U
M917_keeper GND Vdd #641 GND nmos W=0.0975U L=1.495U
M918_ GND __o0f_512_6 #fb645# GND nmos W=0.0975U L=0.13U
M919_keeper GND Vdd #644 GND nmos W=0.0975U L=0.715U
M920_ GND O1_at_512_6 #fb648# GND nmos W=0.0975U L=0.13U
M921_keeper GND Vdd #647 GND nmos W=0.0975U L=0.715U
M922_ GND O1_af_512_6 #fb651# GND nmos W=0.0975U L=0.13U
M923_keeper GND Vdd #650 GND nmos W=0.0975U L=1.495U
M924_ GND __o0t_513_6 #fb654# GND nmos W=0.0975U L=0.13U
M925_keeper GND Vdd #653 GND nmos W=0.0975U L=1.495U
M926_ GND __o0f_513_6 #fb657# GND nmos W=0.0975U L=0.13U
M927_keeper GND Vdd #656 GND nmos W=0.0975U L=0.715U
M928_ GND O1_at_513_6 #fb660# GND nmos W=0.0975U L=0.13U
M929_keeper GND Vdd #659 GND nmos W=0.0975U L=0.715U
M930_ GND O1_af_513_6 #fb663# GND nmos W=0.0975U L=0.13U
M931_keeper GND Vdd #662 GND nmos W=0.0975U L=1.495U
M932_ GND __o0t_514_6 #fb666# GND nmos W=0.0975U L=0.13U
M933_keeper GND Vdd #665 GND nmos W=0.0975U L=1.495U
M934_ GND __o0f_514_6 #fb669# GND nmos W=0.0975U L=0.13U
M935_keeper GND Vdd #668 GND nmos W=0.0975U L=0.715U
M936_ GND O1_at_514_6 #fb672# GND nmos W=0.0975U L=0.13U
M937_keeper GND Vdd #671 GND nmos W=0.0975U L=0.715U
M938_ GND O1_af_514_6 #fb675# GND nmos W=0.0975U L=0.13U
M939_keeper GND Vdd #674 GND nmos W=0.0975U L=1.495U
M940_ GND __o0t_515_6 #fb678# GND nmos W=0.0975U L=0.13U
M941_keeper GND Vdd #677 GND nmos W=0.0975U L=1.495U
M942_ GND __o0f_515_6 #fb681# GND nmos W=0.0975U L=0.13U
M943_keeper GND Vdd #680 GND nmos W=0.0975U L=0.715U
M944_ GND O1_at_515_6 #fb684# GND nmos W=0.0975U L=0.13U
M945_keeper GND Vdd #683 GND nmos W=0.0975U L=0.715U
M946_ GND O1_af_515_6 #fb687# GND nmos W=0.0975U L=0.13U
M947_keeper GND Vdd #686 GND nmos W=0.0975U L=1.495U
M948_ GND __o0t_516_6 #fb690# GND nmos W=0.0975U L=0.13U
M949_keeper GND Vdd #689 GND nmos W=0.0975U L=1.495U
M950_ GND __o0f_516_6 #fb693# GND nmos W=0.0975U L=0.13U
M951_keeper GND Vdd #692 GND nmos W=0.0975U L=0.715U
M952_ GND O1_at_516_6 #fb696# GND nmos W=0.0975U L=0.13U
M953_keeper GND Vdd #695 GND nmos W=0.0975U L=0.715U
M954_ GND O1_af_516_6 #fb699# GND nmos W=0.0975U L=0.13U
M955_keeper GND Vdd #698 GND nmos W=0.0975U L=1.495U
M956_ GND __o0t_517_6 #fb702# GND nmos W=0.0975U L=0.13U
M957_keeper GND Vdd #701 GND nmos W=0.0975U L=1.495U
M958_ GND __o0f_517_6 #fb705# GND nmos W=0.0975U L=0.13U
M959_keeper GND Vdd #704 GND nmos W=0.0975U L=0.715U
M960_ GND O1_at_517_6 #fb708# GND nmos W=0.0975U L=0.13U
M961_keeper GND Vdd #707 GND nmos W=0.0975U L=0.715U
M962_ GND O1_af_517_6 #fb711# GND nmos W=0.0975U L=0.13U
M963_keeper GND Vdd #710 GND nmos W=0.0975U L=1.495U
M964_ GND __o0t_518_6 #fb714# GND nmos W=0.0975U L=0.13U
M965_keeper GND Vdd #713 GND nmos W=0.0975U L=1.495U
M966_ GND __o0f_518_6 #fb717# GND nmos W=0.0975U L=0.13U
M967_keeper GND Vdd #716 GND nmos W=0.0975U L=0.715U
M968_ GND O1_at_518_6 #fb720# GND nmos W=0.0975U L=0.13U
M969_keeper GND Vdd #719 GND nmos W=0.0975U L=0.715U
M970_ GND O1_af_518_6 #fb723# GND nmos W=0.0975U L=0.13U
M971_keeper GND Vdd #722 GND nmos W=0.0975U L=1.495U
M972_ GND __o0t_519_6 #fb726# GND nmos W=0.0975U L=0.13U
M973_keeper GND Vdd #725 GND nmos W=0.0975U L=1.495U
M974_ GND __o0f_519_6 #fb729# GND nmos W=0.0975U L=0.13U
M975_keeper GND Vdd #728 GND nmos W=0.0975U L=0.715U
M976_ GND O1_at_519_6 #fb732# GND nmos W=0.0975U L=0.13U
M977_keeper GND Vdd #731 GND nmos W=0.0975U L=0.715U
M978_ GND O1_af_519_6 #fb735# GND nmos W=0.0975U L=0.13U
M979_keeper GND Vdd #734 GND nmos W=0.0975U L=1.495U
M980_ GND __o0t_520_6 #fb738# GND nmos W=0.0975U L=0.13U
M981_keeper GND Vdd #737 GND nmos W=0.0975U L=1.495U
M982_ GND __o0f_520_6 #fb741# GND nmos W=0.0975U L=0.13U
M983_keeper GND Vdd #740 GND nmos W=0.0975U L=0.715U
M984_ GND O1_at_520_6 #fb744# GND nmos W=0.0975U L=0.13U
M985_keeper GND Vdd #743 GND nmos W=0.0975U L=0.715U
M986_ GND O1_af_520_6 #fb747# GND nmos W=0.0975U L=0.13U
M987_keeper GND Vdd #746 GND nmos W=0.0975U L=1.495U
M988_ GND __o0t_521_6 #fb750# GND nmos W=0.0975U L=0.13U
M989_keeper GND Vdd #749 GND nmos W=0.0975U L=1.495U
M990_ GND __o0f_521_6 #fb753# GND nmos W=0.0975U L=0.13U
M991_keeper GND Vdd #752 GND nmos W=0.0975U L=0.715U
M992_ GND O1_at_521_6 #fb756# GND nmos W=0.0975U L=0.13U
M993_keeper GND Vdd #755 GND nmos W=0.0975U L=0.715U
M994_ GND O1_af_521_6 #fb759# GND nmos W=0.0975U L=0.13U
M995_keeper GND Vdd #758 GND nmos W=0.0975U L=1.495U
M996_ GND __o0t_522_6 #fb762# GND nmos W=0.0975U L=0.13U
M997_keeper GND Vdd #761 GND nmos W=0.0975U L=1.495U
M998_ GND __o0f_522_6 #fb765# GND nmos W=0.0975U L=0.13U
M999_keeper GND Vdd #764 GND nmos W=0.0975U L=0.715U
M1000_ GND O1_at_522_6 #fb768# GND nmos W=0.0975U L=0.13U
M1001_keeper GND Vdd #767 GND nmos W=0.0975U L=0.715U
M1002_ GND O1_af_522_6 #fb771# GND nmos W=0.0975U L=0.13U
M1003_keeper GND Vdd #770 GND nmos W=0.0975U L=1.495U
M1004_ GND __o0t_523_6 #fb774# GND nmos W=0.0975U L=0.13U
M1005_keeper GND Vdd #773 GND nmos W=0.0975U L=1.495U
M1006_ GND __o0f_523_6 #fb777# GND nmos W=0.0975U L=0.13U
M1007_keeper GND Vdd #776 GND nmos W=0.0975U L=0.715U
M1008_ GND O1_at_523_6 #fb780# GND nmos W=0.0975U L=0.13U
M1009_keeper GND Vdd #779 GND nmos W=0.0975U L=0.715U
M1010_ GND O1_af_523_6 #fb783# GND nmos W=0.0975U L=0.13U
M1011_keeper GND Vdd #782 GND nmos W=0.0975U L=1.495U
M1012_ GND __o0t_524_6 #fb786# GND nmos W=0.0975U L=0.13U
M1013_keeper GND Vdd #785 GND nmos W=0.0975U L=1.495U
M1014_ GND __o0f_524_6 #fb789# GND nmos W=0.0975U L=0.13U
M1015_keeper GND Vdd #788 GND nmos W=0.0975U L=0.715U
M1016_ GND O1_at_524_6 #fb792# GND nmos W=0.0975U L=0.13U
M1017_keeper GND Vdd #791 GND nmos W=0.0975U L=0.715U
M1018_ GND O1_af_524_6 #fb795# GND nmos W=0.0975U L=0.13U
M1019_keeper GND Vdd #794 GND nmos W=0.0975U L=1.495U
M1020_ GND __o0t_525_6 #fb798# GND nmos W=0.0975U L=0.13U
M1021_keeper GND Vdd #797 GND nmos W=0.0975U L=1.495U
M1022_ GND __o0f_525_6 #fb801# GND nmos W=0.0975U L=0.13U
M1023_keeper GND Vdd #800 GND nmos W=0.0975U L=0.715U
M1024_ GND O1_at_525_6 #fb804# GND nmos W=0.0975U L=0.13U
M1025_keeper GND Vdd #803 GND nmos W=0.0975U L=0.715U
M1026_ GND O1_af_525_6 #fb807# GND nmos W=0.0975U L=0.13U
M1027_keeper GND Vdd #806 GND nmos W=0.0975U L=1.495U
M1028_ GND __o0t_526_6 #fb810# GND nmos W=0.0975U L=0.13U
M1029_keeper GND Vdd #809 GND nmos W=0.0975U L=1.495U
M1030_ GND __o0f_526_6 #fb813# GND nmos W=0.0975U L=0.13U
M1031_keeper GND Vdd #812 GND nmos W=0.0975U L=0.715U
M1032_ GND O1_at_526_6 #fb816# GND nmos W=0.0975U L=0.13U
M1033_keeper GND Vdd #815 GND nmos W=0.0975U L=0.715U
M1034_ GND O1_af_526_6 #fb819# GND nmos W=0.0975U L=0.13U
M1035_keeper GND Vdd #818 GND nmos W=0.0975U L=1.495U
M1036_ GND __o0t_527_6 #fb822# GND nmos W=0.0975U L=0.13U
M1037_keeper GND Vdd #821 GND nmos W=0.0975U L=1.495U
M1038_ GND __o0f_527_6 #fb825# GND nmos W=0.0975U L=0.13U
M1039_keeper GND Vdd #824 GND nmos W=0.0975U L=0.715U
M1040_ GND O1_at_527_6 #fb828# GND nmos W=0.0975U L=0.13U
M1041_keeper GND Vdd #827 GND nmos W=0.0975U L=0.715U
M1042_ GND O1_af_527_6 #fb831# GND nmos W=0.0975U L=0.13U
M1043_keeper GND Vdd #830 GND nmos W=0.0975U L=1.495U
M1044_ GND __o0t_528_6 #fb834# GND nmos W=0.0975U L=0.13U
M1045_keeper GND Vdd #833 GND nmos W=0.0975U L=1.495U
M1046_ GND __o0f_528_6 #fb837# GND nmos W=0.0975U L=0.13U
M1047_keeper GND Vdd #836 GND nmos W=0.0975U L=0.715U
M1048_ GND O1_at_528_6 #fb840# GND nmos W=0.0975U L=0.13U
M1049_keeper GND Vdd #839 GND nmos W=0.0975U L=0.715U
M1050_ GND O1_af_528_6 #fb843# GND nmos W=0.0975U L=0.13U
M1051_keeper GND Vdd #842 GND nmos W=0.0975U L=1.495U
M1052_ GND __o0t_529_6 #fb846# GND nmos W=0.0975U L=0.13U
M1053_keeper GND Vdd #845 GND nmos W=0.0975U L=1.495U
M1054_ GND __o0f_529_6 #fb849# GND nmos W=0.0975U L=0.13U
M1055_keeper GND Vdd #848 GND nmos W=0.0975U L=0.715U
M1056_ GND O1_at_529_6 #fb852# GND nmos W=0.0975U L=0.13U
M1057_keeper GND Vdd #851 GND nmos W=0.0975U L=0.715U
M1058_ GND O1_af_529_6 #fb855# GND nmos W=0.0975U L=0.13U
M1059_keeper GND Vdd #854 GND nmos W=0.0975U L=1.495U
M1060_ GND __o0t_530_6 #fb858# GND nmos W=0.0975U L=0.13U
M1061_keeper GND Vdd #857 GND nmos W=0.0975U L=1.495U
M1062_ GND __o0f_530_6 #fb861# GND nmos W=0.0975U L=0.13U
M1063_keeper GND Vdd #860 GND nmos W=0.0975U L=0.715U
M1064_ GND O1_at_530_6 #fb864# GND nmos W=0.0975U L=0.13U
M1065_keeper GND Vdd #863 GND nmos W=0.0975U L=0.715U
M1066_ GND O1_af_530_6 #fb867# GND nmos W=0.0975U L=0.13U
M1067_keeper GND Vdd #866 GND nmos W=0.0975U L=1.495U
M1068_ GND __o0t_531_6 #fb870# GND nmos W=0.0975U L=0.13U
M1069_keeper GND Vdd #869 GND nmos W=0.0975U L=1.495U
M1070_ GND __o0f_531_6 #fb873# GND nmos W=0.0975U L=0.13U
M1071_keeper GND Vdd #872 GND nmos W=0.0975U L=0.715U
M1072_ GND O1_at_531_6 #fb876# GND nmos W=0.0975U L=0.13U
M1073_keeper GND Vdd #875 GND nmos W=0.0975U L=0.715U
M1074_ GND O1_af_531_6 #fb879# GND nmos W=0.0975U L=0.13U
M1075_keeper GND Vdd #878 GND nmos W=0.0975U L=1.495U
M1076_keeper GND Vdd #881 GND nmos W=0.0975U L=1.495U
M1077_ #3 __p __w0 GND nmos W=0.0975U L=0.065U
M1078_ #6 p __w0 GND nmos W=0.0975U L=0.065U
M1079_ #12 __a __w0 Vdd pmos W=0.1625U L=0.065U
M1080_keeper #484 #fb483# __w0 Vdd pmos W=0.0975U L=0.065U
M1081_keeper #485 #fb483# __w0 GND nmos W=0.0975U L=0.065U
M1082_ #35 __a p Vdd pmos W=0.1625U L=0.065U
M1083_ #36 a p GND nmos W=0.0975U L=0.065U
M1084_keeper #487 #fb486# p Vdd pmos W=0.0975U L=0.065U
M1085_keeper #488 #fb486# p GND nmos W=0.0975U L=0.065U
M1086_ #16 __p __w1 GND nmos W=0.0975U L=0.065U
M1087_ #18 p __w1 GND nmos W=0.0975U L=0.065U
M1088_ #26 __a __w1 Vdd pmos W=0.1625U L=0.065U
M1089_keeper #490 #fb489# __w1 Vdd pmos W=0.0975U L=0.065U
M1090_keeper #491 #fb489# __w1 GND nmos W=0.0975U L=0.065U
M1091_ #19 I_af_54_6 #18 GND nmos W=0.0975U L=0.065U
M1092_ #20 I_af_55_6 #19 GND nmos W=0.0975U L=0.065U
M1093_ #21 I_af_56_6 #20 GND nmos W=0.0975U L=0.065U
M1094_ #28 __w0 a Vdd pmos W=0.1625U L=0.065U
M1095_ #28 __w1 a Vdd pmos W=0.1625U L=0.065U
M1096_ #34 __w1 a GND nmos W=0.0975U L=0.065U
M1097_keeper #493 #fb492# a Vdd pmos W=0.0975U L=0.065U
M1098_keeper #494 #fb492# a GND nmos W=0.0975U L=0.065U
M1099_ #29 O1_aa #28 Vdd pmos W=0.1625U L=0.065U
M1100_ #30 O0_aa #29 Vdd pmos W=0.1625U L=0.065U
M1101_ #39 __o0a I_aa Vdd pmos W=0.1625U L=0.065U
M1102_ #39 __o1a I_aa Vdd pmos W=0.1625U L=0.065U
M1103_ #42 __a I_aa GND nmos W=0.0975U L=0.065U
M1104_keeper #496 #fb495# I_aa Vdd pmos W=0.0975U L=0.065U
M1105_keeper #497 #fb495# I_aa GND nmos W=0.0975U L=0.065U
M1106_ #43 __w1 #42 GND nmos W=0.0975U L=0.065U
M1107_ #45 I_at_50_6 __o0t_50_6 GND nmos W=0.0975U L=0.065U
M1108_keeper #499 #fb498# __o0t_50_6 Vdd pmos W=0.0975U L=0.065U
M1109_keeper #500 #fb498# __o0t_50_6 GND nmos W=0.0975U L=0.065U
M1110_ #47 I_af_50_6 __o0f_50_6 GND nmos W=0.0975U L=0.065U
M1111_keeper #502 #fb501# __o0f_50_6 Vdd pmos W=0.0975U L=0.065U
M1112_keeper #503 #fb501# __o0f_50_6 GND nmos W=0.0975U L=0.065U
M1113_ #49 __i__t_50_6 O1_at_50_6 Vdd pmos W=0.1625U L=0.065U
M1114_keeper #505 #fb504# O1_at_50_6 Vdd pmos W=0.0975U L=0.065U
M1115_keeper #506 #fb504# O1_at_50_6 GND nmos W=0.0975U L=0.065U
M1116_ #52 __i__f_50_6 O1_af_50_6 Vdd pmos W=0.1625U L=0.065U
M1117_keeper #508 #fb507# O1_af_50_6 Vdd pmos W=0.0975U L=0.065U
M1118_keeper #509 #fb507# O1_af_50_6 GND nmos W=0.0975U L=0.065U
M1119_ #55 I_at_51_6 __o0t_51_6 GND nmos W=0.0975U L=0.065U
M1120_keeper #511 #fb510# __o0t_51_6 Vdd pmos W=0.0975U L=0.065U
M1121_keeper #512 #fb510# __o0t_51_6 GND nmos W=0.0975U L=0.065U
M1122_ #58 I_af_51_6 __o0f_51_6 GND nmos W=0.0975U L=0.065U
M1123_keeper #514 #fb513# __o0f_51_6 Vdd pmos W=0.0975U L=0.065U
M1124_keeper #515 #fb513# __o0f_51_6 GND nmos W=0.0975U L=0.065U
M1125_ #61 __i__t_51_6 O1_at_51_6 Vdd pmos W=0.1625U L=0.065U
M1126_keeper #517 #fb516# O1_at_51_6 Vdd pmos W=0.0975U L=0.065U
M1127_keeper #518 #fb516# O1_at_51_6 GND nmos W=0.0975U L=0.065U
M1128_ #64 __i__f_51_6 O1_af_51_6 Vdd pmos W=0.1625U L=0.065U
M1129_keeper #520 #fb519# O1_af_51_6 Vdd pmos W=0.0975U L=0.065U
M1130_keeper #521 #fb519# O1_af_51_6 GND nmos W=0.0975U L=0.065U
M1131_ #67 I_at_52_6 __o0t_52_6 GND nmos W=0.0975U L=0.065U
M1132_keeper #523 #fb522# __o0t_52_6 Vdd pmos W=0.0975U L=0.065U
M1133_keeper #524 #fb522# __o0t_52_6 GND nmos W=0.0975U L=0.065U
M1134_ #70 I_af_52_6 __o0f_52_6 GND nmos W=0.0975U L=0.065U
M1135_keeper #526 #fb525# __o0f_52_6 Vdd pmos W=0.0975U L=0.065U
M1136_keeper #527 #fb525# __o0f_52_6 GND nmos W=0.0975U L=0.065U
M1137_ #73 __i__t_52_6 O1_at_52_6 Vdd pmos W=0.1625U L=0.065U
M1138_keeper #529 #fb528# O1_at_52_6 Vdd pmos W=0.0975U L=0.065U
M1139_keeper #530 #fb528# O1_at_52_6 GND nmos W=0.0975U L=0.065U
M1140_ #76 __i__f_52_6 O1_af_52_6 Vdd pmos W=0.1625U L=0.065U
M1141_keeper #532 #fb531# O1_af_52_6 Vdd pmos W=0.0975U L=0.065U
M1142_keeper #533 #fb531# O1_af_52_6 GND nmos W=0.0975U L=0.065U
M1143_ #79 I_at_53_6 __o0t_53_6 GND nmos W=0.0975U L=0.065U
M1144_keeper #535 #fb534# __o0t_53_6 Vdd pmos W=0.0975U L=0.065U
M1145_keeper #536 #fb534# __o0t_53_6 GND nmos W=0.0975U L=0.065U
M1146_ #82 I_af_53_6 __o0f_53_6 GND nmos W=0.0975U L=0.065U
M1147_keeper #538 #fb537# __o0f_53_6 Vdd pmos W=0.0975U L=0.065U
M1148_keeper #539 #fb537# __o0f_53_6 GND nmos W=0.0975U L=0.065U
M1149_ #85 __i__t_53_6 O1_at_53_6 Vdd pmos W=0.1625U L=0.065U
M1150_keeper #541 #fb540# O1_at_53_6 Vdd pmos W=0.0975U L=0.065U
M1151_keeper #542 #fb540# O1_at_53_6 GND nmos W=0.0975U L=0.065U
M1152_ #88 __i__f_53_6 O1_af_53_6 Vdd pmos W=0.1625U L=0.065U
M1153_keeper #544 #fb543# O1_af_53_6 Vdd pmos W=0.0975U L=0.065U
M1154_keeper #545 #fb543# O1_af_53_6 GND nmos W=0.0975U L=0.065U
M1155_ #91 I_at_54_6 __o0t_54_6 GND nmos W=0.0975U L=0.065U
M1156_keeper #547 #fb546# __o0t_54_6 Vdd pmos W=0.0975U L=0.065U
M1157_keeper #548 #fb546# __o0t_54_6 GND nmos W=0.0975U L=0.065U
M1158_ #93 I_af_54_6 __o0f_54_6 GND nmos W=0.0975U L=0.065U
M1159_keeper #550 #fb549# __o0f_54_6 Vdd pmos W=0.0975U L=0.065U
M1160_keeper #551 #fb549# __o0f_54_6 GND nmos W=0.0975U L=0.065U
M1161_ #95 __i__t_54_6 O1_at_54_6 Vdd pmos W=0.1625U L=0.065U
M1162_keeper #553 #fb552# O1_at_54_6 Vdd pmos W=0.0975U L=0.065U
M1163_keeper #554 #fb552# O1_at_54_6 GND nmos W=0.0975U L=0.065U
M1164_ #98 __i__f_54_6 O1_af_54_6 Vdd pmos W=0.1625U L=0.065U
M1165_keeper #556 #fb555# O1_af_54_6 Vdd pmos W=0.0975U L=0.065U
M1166_keeper #557 #fb555# O1_af_54_6 GND nmos W=0.0975U L=0.065U
M1167_ #101 I_at_55_6 __o0t_55_6 GND nmos W=0.0975U L=0.065U
M1168_keeper #559 #fb558# __o0t_55_6 Vdd pmos W=0.0975U L=0.065U
M1169_keeper #560 #fb558# __o0t_55_6 GND nmos W=0.0975U L=0.065U
M1170_ #103 I_af_55_6 __o0f_55_6 GND nmos W=0.0975U L=0.065U
M1171_keeper #562 #fb561# __o0f_55_6 Vdd pmos W=0.0975U L=0.065U
M1172_keeper #563 #fb561# __o0f_55_6 GND nmos W=0.0975U L=0.065U
M1173_ #105 __i__t_55_6 O1_at_55_6 Vdd pmos W=0.1625U L=0.065U
M1174_keeper #565 #fb564# O1_at_55_6 Vdd pmos W=0.0975U L=0.065U
M1175_keeper #566 #fb564# O1_at_55_6 GND nmos W=0.0975U L=0.065U
M1176_ #108 __i__f_55_6 O1_af_55_6 Vdd pmos W=0.1625U L=0.065U
M1177_keeper #568 #fb567# O1_af_55_6 Vdd pmos W=0.0975U L=0.065U
M1178_keeper #569 #fb567# O1_af_55_6 GND nmos W=0.0975U L=0.065U
M1179_ #111 I_at_56_6 __o0t_56_6 GND nmos W=0.0975U L=0.065U
M1180_keeper #571 #fb570# __o0t_56_6 Vdd pmos W=0.0975U L=0.065U
M1181_keeper #572 #fb570# __o0t_56_6 GND nmos W=0.0975U L=0.065U
M1182_ #113 I_af_56_6 __o0f_56_6 GND nmos W=0.0975U L=0.065U
M1183_keeper #574 #fb573# __o0f_56_6 Vdd pmos W=0.0975U L=0.065U
M1184_keeper #575 #fb573# __o0f_56_6 GND nmos W=0.0975U L=0.065U
M1185_ #115 __i__t_56_6 O1_at_56_6 Vdd pmos W=0.1625U L=0.065U
M1186_keeper #577 #fb576# O1_at_56_6 Vdd pmos W=0.0975U L=0.065U
M1187_keeper #578 #fb576# O1_at_56_6 GND nmos W=0.0975U L=0.065U
M1188_ #118 __i__f_56_6 O1_af_56_6 Vdd pmos W=0.1625U L=0.065U
M1189_keeper #580 #fb579# O1_af_56_6 Vdd pmos W=0.0975U L=0.065U
M1190_keeper #581 #fb579# O1_af_56_6 GND nmos W=0.0975U L=0.065U
M1191_ #121 I_at_57_6 __o0t_57_6 GND nmos W=0.0975U L=0.065U
M1192_keeper #583 #fb582# __o0t_57_6 Vdd pmos W=0.0975U L=0.065U
M1193_keeper #584 #fb582# __o0t_57_6 GND nmos W=0.0975U L=0.065U
M1194_ #123 I_af_57_6 __o0f_57_6 GND nmos W=0.0975U L=0.065U
M1195_keeper #586 #fb585# __o0f_57_6 Vdd pmos W=0.0975U L=0.065U
M1196_keeper #587 #fb585# __o0f_57_6 GND nmos W=0.0975U L=0.065U
M1197_ #125 __i__t_57_6 O1_at_57_6 Vdd pmos W=0.1625U L=0.065U
M1198_keeper #589 #fb588# O1_at_57_6 Vdd pmos W=0.0975U L=0.065U
M1199_keeper #590 #fb588# O1_at_57_6 GND nmos W=0.0975U L=0.065U
M1200_ #128 __i__f_57_6 O1_af_57_6 Vdd pmos W=0.1625U L=0.065U
M1201_keeper #592 #fb591# O1_af_57_6 Vdd pmos W=0.0975U L=0.065U
M1202_keeper #593 #fb591# O1_af_57_6 GND nmos W=0.0975U L=0.065U
M1203_ #131 I_at_58_6 __o0t_58_6 GND nmos W=0.0975U L=0.065U
M1204_keeper #595 #fb594# __o0t_58_6 Vdd pmos W=0.0975U L=0.065U
M1205_keeper #596 #fb594# __o0t_58_6 GND nmos W=0.0975U L=0.065U
M1206_ #134 I_af_58_6 __o0f_58_6 GND nmos W=0.0975U L=0.065U
M1207_keeper #598 #fb597# __o0f_58_6 Vdd pmos W=0.0975U L=0.065U
M1208_keeper #599 #fb597# __o0f_58_6 GND nmos W=0.0975U L=0.065U
M1209_ #137 __i__t_58_6 O1_at_58_6 Vdd pmos W=0.1625U L=0.065U
M1210_keeper #601 #fb600# O1_at_58_6 Vdd pmos W=0.0975U L=0.065U
M1211_keeper #602 #fb600# O1_at_58_6 GND nmos W=0.0975U L=0.065U
M1212_ #140 __i__f_58_6 O1_af_58_6 Vdd pmos W=0.1625U L=0.065U
M1213_keeper #604 #fb603# O1_af_58_6 Vdd pmos W=0.0975U L=0.065U
M1214_keeper #605 #fb603# O1_af_58_6 GND nmos W=0.0975U L=0.065U
M1215_ #143 I_at_59_6 __o0t_59_6 GND nmos W=0.0975U L=0.065U
M1216_keeper #607 #fb606# __o0t_59_6 Vdd pmos W=0.0975U L=0.065U
M1217_keeper #608 #fb606# __o0t_59_6 GND nmos W=0.0975U L=0.065U
M1218_ #146 I_af_59_6 __o0f_59_6 GND nmos W=0.0975U L=0.065U
M1219_keeper #610 #fb609# __o0f_59_6 Vdd pmos W=0.0975U L=0.065U
M1220_keeper #611 #fb609# __o0f_59_6 GND nmos W=0.0975U L=0.065U
M1221_ #149 __i__t_59_6 O1_at_59_6 Vdd pmos W=0.1625U L=0.065U
M1222_keeper #613 #fb612# O1_at_59_6 Vdd pmos W=0.0975U L=0.065U
M1223_keeper #614 #fb612# O1_at_59_6 GND nmos W=0.0975U L=0.065U
M1224_ #152 __i__f_59_6 O1_af_59_6 Vdd pmos W=0.1625U L=0.065U
M1225_keeper #616 #fb615# O1_af_59_6 Vdd pmos W=0.0975U L=0.065U
M1226_keeper #617 #fb615# O1_af_59_6 GND nmos W=0.0975U L=0.065U
M1227_ #155 I_at_510_6 __o0t_510_6 GND nmos W=0.0975U L=0.065U
M1228_keeper #619 #fb618# __o0t_510_6 Vdd pmos W=0.0975U L=0.065U
M1229_keeper #620 #fb618# __o0t_510_6 GND nmos W=0.0975U L=0.065U
M1230_ #158 I_af_510_6 __o0f_510_6 GND nmos W=0.0975U L=0.065U
M1231_keeper #622 #fb621# __o0f_510_6 Vdd pmos W=0.0975U L=0.065U
M1232_keeper #623 #fb621# __o0f_510_6 GND nmos W=0.0975U L=0.065U
M1233_ #161 __i__t_510_6 O1_at_510_6 Vdd pmos W=0.1625U L=0.065U
M1234_keeper #625 #fb624# O1_at_510_6 Vdd pmos W=0.0975U L=0.065U
M1235_keeper #626 #fb624# O1_at_510_6 GND nmos W=0.0975U L=0.065U
M1236_ #164 __i__f_510_6 O1_af_510_6 Vdd pmos W=0.1625U L=0.065U
M1237_keeper #628 #fb627# O1_af_510_6 Vdd pmos W=0.0975U L=0.065U
M1238_keeper #629 #fb627# O1_af_510_6 GND nmos W=0.0975U L=0.065U
M1239_ #167 I_at_511_6 __o0t_511_6 GND nmos W=0.0975U L=0.065U
M1240_keeper #631 #fb630# __o0t_511_6 Vdd pmos W=0.0975U L=0.065U
M1241_keeper #632 #fb630# __o0t_511_6 GND nmos W=0.0975U L=0.065U
M1242_ #170 I_af_511_6 __o0f_511_6 GND nmos W=0.0975U L=0.065U
M1243_keeper #634 #fb633# __o0f_511_6 Vdd pmos W=0.0975U L=0.065U
M1244_keeper #635 #fb633# __o0f_511_6 GND nmos W=0.0975U L=0.065U
M1245_ #173 __i__t_511_6 O1_at_511_6 Vdd pmos W=0.1625U L=0.065U
M1246_keeper #637 #fb636# O1_at_511_6 Vdd pmos W=0.0975U L=0.065U
M1247_keeper #638 #fb636# O1_at_511_6 GND nmos W=0.0975U L=0.065U
M1248_ #176 __i__f_511_6 O1_af_511_6 Vdd pmos W=0.1625U L=0.065U
M1249_keeper #640 #fb639# O1_af_511_6 Vdd pmos W=0.0975U L=0.065U
M1250_keeper #641 #fb639# O1_af_511_6 GND nmos W=0.0975U L=0.065U
M1251_ #179 I_at_512_6 __o0t_512_6 GND nmos W=0.0975U L=0.065U
M1252_keeper #643 #fb642# __o0t_512_6 Vdd pmos W=0.0975U L=0.065U
M1253_keeper #644 #fb642# __o0t_512_6 GND nmos W=0.0975U L=0.065U
M1254_ #182 I_af_512_6 __o0f_512_6 GND nmos W=0.0975U L=0.065U
M1255_keeper #646 #fb645# __o0f_512_6 Vdd pmos W=0.0975U L=0.065U
M1256_keeper #647 #fb645# __o0f_512_6 GND nmos W=0.0975U L=0.065U
M1257_ #185 __i__t_512_6 O1_at_512_6 Vdd pmos W=0.1625U L=0.065U
M1258_keeper #649 #fb648# O1_at_512_6 Vdd pmos W=0.0975U L=0.065U
M1259_keeper #650 #fb648# O1_at_512_6 GND nmos W=0.0975U L=0.065U
M1260_ #188 __i__f_512_6 O1_af_512_6 Vdd pmos W=0.1625U L=0.065U
M1261_keeper #652 #fb651# O1_af_512_6 Vdd pmos W=0.0975U L=0.065U
M1262_keeper #653 #fb651# O1_af_512_6 GND nmos W=0.0975U L=0.065U
M1263_ #191 I_at_513_6 __o0t_513_6 GND nmos W=0.0975U L=0.065U
M1264_keeper #655 #fb654# __o0t_513_6 Vdd pmos W=0.0975U L=0.065U
M1265_keeper #656 #fb654# __o0t_513_6 GND nmos W=0.0975U L=0.065U
M1266_ #194 I_af_513_6 __o0f_513_6 GND nmos W=0.0975U L=0.065U
M1267_keeper #658 #fb657# __o0f_513_6 Vdd pmos W=0.0975U L=0.065U
M1268_keeper #659 #fb657# __o0f_513_6 GND nmos W=0.0975U L=0.065U
M1269_ #197 __i__t_513_6 O1_at_513_6 Vdd pmos W=0.1625U L=0.065U
M1270_keeper #661 #fb660# O1_at_513_6 Vdd pmos W=0.0975U L=0.065U
M1271_keeper #662 #fb660# O1_at_513_6 GND nmos W=0.0975U L=0.065U
M1272_ #200 __i__f_513_6 O1_af_513_6 Vdd pmos W=0.1625U L=0.065U
M1273_keeper #664 #fb663# O1_af_513_6 Vdd pmos W=0.0975U L=0.065U
M1274_keeper #665 #fb663# O1_af_513_6 GND nmos W=0.0975U L=0.065U
M1275_ #203 I_at_514_6 __o0t_514_6 GND nmos W=0.0975U L=0.065U
M1276_keeper #667 #fb666# __o0t_514_6 Vdd pmos W=0.0975U L=0.065U
M1277_keeper #668 #fb666# __o0t_514_6 GND nmos W=0.0975U L=0.065U
M1278_ #206 I_af_514_6 __o0f_514_6 GND nmos W=0.0975U L=0.065U
M1279_keeper #670 #fb669# __o0f_514_6 Vdd pmos W=0.0975U L=0.065U
M1280_keeper #671 #fb669# __o0f_514_6 GND nmos W=0.0975U L=0.065U
M1281_ #209 __i__t_514_6 O1_at_514_6 Vdd pmos W=0.1625U L=0.065U
M1282_keeper #673 #fb672# O1_at_514_6 Vdd pmos W=0.0975U L=0.065U
M1283_keeper #674 #fb672# O1_at_514_6 GND nmos W=0.0975U L=0.065U
M1284_ #212 __i__f_514_6 O1_af_514_6 Vdd pmos W=0.1625U L=0.065U
M1285_keeper #676 #fb675# O1_af_514_6 Vdd pmos W=0.0975U L=0.065U
M1286_keeper #677 #fb675# O1_af_514_6 GND nmos W=0.0975U L=0.065U
M1287_ #215 I_at_515_6 __o0t_515_6 GND nmos W=0.0975U L=0.065U
M1288_keeper #679 #fb678# __o0t_515_6 Vdd pmos W=0.0975U L=0.065U
M1289_keeper #680 #fb678# __o0t_515_6 GND nmos W=0.0975U L=0.065U
M1290_ #218 I_af_515_6 __o0f_515_6 GND nmos W=0.0975U L=0.065U
M1291_keeper #682 #fb681# __o0f_515_6 Vdd pmos W=0.0975U L=0.065U
M1292_keeper #683 #fb681# __o0f_515_6 GND nmos W=0.0975U L=0.065U
M1293_ #221 __i__t_515_6 O1_at_515_6 Vdd pmos W=0.1625U L=0.065U
M1294_keeper #685 #fb684# O1_at_515_6 Vdd pmos W=0.0975U L=0.065U
M1295_keeper #686 #fb684# O1_at_515_6 GND nmos W=0.0975U L=0.065U
M1296_ #224 __i__f_515_6 O1_af_515_6 Vdd pmos W=0.1625U L=0.065U
M1297_keeper #688 #fb687# O1_af_515_6 Vdd pmos W=0.0975U L=0.065U
M1298_keeper #689 #fb687# O1_af_515_6 GND nmos W=0.0975U L=0.065U
M1299_ #227 I_at_516_6 __o0t_516_6 GND nmos W=0.0975U L=0.065U
M1300_keeper #691 #fb690# __o0t_516_6 Vdd pmos W=0.0975U L=0.065U
M1301_keeper #692 #fb690# __o0t_516_6 GND nmos W=0.0975U L=0.065U
M1302_ #230 I_af_516_6 __o0f_516_6 GND nmos W=0.0975U L=0.065U
M1303_keeper #694 #fb693# __o0f_516_6 Vdd pmos W=0.0975U L=0.065U
M1304_keeper #695 #fb693# __o0f_516_6 GND nmos W=0.0975U L=0.065U
M1305_ #233 __i__t_516_6 O1_at_516_6 Vdd pmos W=0.1625U L=0.065U
M1306_keeper #697 #fb696# O1_at_516_6 Vdd pmos W=0.0975U L=0.065U
M1307_keeper #698 #fb696# O1_at_516_6 GND nmos W=0.0975U L=0.065U
M1308_ #236 __i__f_516_6 O1_af_516_6 Vdd pmos W=0.1625U L=0.065U
M1309_keeper #700 #fb699# O1_af_516_6 Vdd pmos W=0.0975U L=0.065U
M1310_keeper #701 #fb699# O1_af_516_6 GND nmos W=0.0975U L=0.065U
M1311_ #239 I_at_517_6 __o0t_517_6 GND nmos W=0.0975U L=0.065U
M1312_keeper #703 #fb702# __o0t_517_6 Vdd pmos W=0.0975U L=0.065U
M1313_keeper #704 #fb702# __o0t_517_6 GND nmos W=0.0975U L=0.065U
M1314_ #242 I_af_517_6 __o0f_517_6 GND nmos W=0.0975U L=0.065U
M1315_keeper #706 #fb705# __o0f_517_6 Vdd pmos W=0.0975U L=0.065U
M1316_keeper #707 #fb705# __o0f_517_6 GND nmos W=0.0975U L=0.065U
M1317_ #245 __i__t_517_6 O1_at_517_6 Vdd pmos W=0.1625U L=0.065U
M1318_keeper #709 #fb708# O1_at_517_6 Vdd pmos W=0.0975U L=0.065U
M1319_keeper #710 #fb708# O1_at_517_6 GND nmos W=0.0975U L=0.065U
M1320_ #248 __i__f_517_6 O1_af_517_6 Vdd pmos W=0.1625U L=0.065U
M1321_keeper #712 #fb711# O1_af_517_6 Vdd pmos W=0.0975U L=0.065U
M1322_keeper #713 #fb711# O1_af_517_6 GND nmos W=0.0975U L=0.065U
M1323_ #251 I_at_518_6 __o0t_518_6 GND nmos W=0.0975U L=0.065U
M1324_keeper #715 #fb714# __o0t_518_6 Vdd pmos W=0.0975U L=0.065U
M1325_keeper #716 #fb714# __o0t_518_6 GND nmos W=0.0975U L=0.065U
M1326_ #254 I_af_518_6 __o0f_518_6 GND nmos W=0.0975U L=0.065U
M1327_keeper #718 #fb717# __o0f_518_6 Vdd pmos W=0.0975U L=0.065U
M1328_keeper #719 #fb717# __o0f_518_6 GND nmos W=0.0975U L=0.065U
M1329_ #257 __i__t_518_6 O1_at_518_6 Vdd pmos W=0.1625U L=0.065U
M1330_keeper #721 #fb720# O1_at_518_6 Vdd pmos W=0.0975U L=0.065U
M1331_keeper #722 #fb720# O1_at_518_6 GND nmos W=0.0975U L=0.065U
M1332_ #260 __i__f_518_6 O1_af_518_6 Vdd pmos W=0.1625U L=0.065U
M1333_keeper #724 #fb723# O1_af_518_6 Vdd pmos W=0.0975U L=0.065U
M1334_keeper #725 #fb723# O1_af_518_6 GND nmos W=0.0975U L=0.065U
M1335_ #263 I_at_519_6 __o0t_519_6 GND nmos W=0.0975U L=0.065U
M1336_keeper #727 #fb726# __o0t_519_6 Vdd pmos W=0.0975U L=0.065U
M1337_keeper #728 #fb726# __o0t_519_6 GND nmos W=0.0975U L=0.065U
M1338_ #266 I_af_519_6 __o0f_519_6 GND nmos W=0.0975U L=0.065U
M1339_keeper #730 #fb729# __o0f_519_6 Vdd pmos W=0.0975U L=0.065U
M1340_keeper #731 #fb729# __o0f_519_6 GND nmos W=0.0975U L=0.065U
M1341_ #269 __i__t_519_6 O1_at_519_6 Vdd pmos W=0.1625U L=0.065U
M1342_keeper #733 #fb732# O1_at_519_6 Vdd pmos W=0.0975U L=0.065U
M1343_keeper #734 #fb732# O1_at_519_6 GND nmos W=0.0975U L=0.065U
M1344_ #272 __i__f_519_6 O1_af_519_6 Vdd pmos W=0.1625U L=0.065U
M1345_keeper #736 #fb735# O1_af_519_6 Vdd pmos W=0.0975U L=0.065U
M1346_keeper #737 #fb735# O1_af_519_6 GND nmos W=0.0975U L=0.065U
M1347_ #275 I_at_520_6 __o0t_520_6 GND nmos W=0.0975U L=0.065U
M1348_keeper #739 #fb738# __o0t_520_6 Vdd pmos W=0.0975U L=0.065U
M1349_keeper #740 #fb738# __o0t_520_6 GND nmos W=0.0975U L=0.065U
M1350_ #278 I_af_520_6 __o0f_520_6 GND nmos W=0.0975U L=0.065U
M1351_keeper #742 #fb741# __o0f_520_6 Vdd pmos W=0.0975U L=0.065U
M1352_keeper #743 #fb741# __o0f_520_6 GND nmos W=0.0975U L=0.065U
M1353_ #281 __i__t_520_6 O1_at_520_6 Vdd pmos W=0.1625U L=0.065U
M1354_keeper #745 #fb744# O1_at_520_6 Vdd pmos W=0.0975U L=0.065U
M1355_keeper #746 #fb744# O1_at_520_6 GND nmos W=0.0975U L=0.065U
M1356_ #284 __i__f_520_6 O1_af_520_6 Vdd pmos W=0.1625U L=0.065U
M1357_keeper #748 #fb747# O1_af_520_6 Vdd pmos W=0.0975U L=0.065U
M1358_keeper #749 #fb747# O1_af_520_6 GND nmos W=0.0975U L=0.065U
M1359_ #287 I_at_521_6 __o0t_521_6 GND nmos W=0.0975U L=0.065U
M1360_keeper #751 #fb750# __o0t_521_6 Vdd pmos W=0.0975U L=0.065U
M1361_keeper #752 #fb750# __o0t_521_6 GND nmos W=0.0975U L=0.065U
M1362_ #290 I_af_521_6 __o0f_521_6 GND nmos W=0.0975U L=0.065U
M1363_keeper #754 #fb753# __o0f_521_6 Vdd pmos W=0.0975U L=0.065U
M1364_keeper #755 #fb753# __o0f_521_6 GND nmos W=0.0975U L=0.065U
M1365_ #293 __i__t_521_6 O1_at_521_6 Vdd pmos W=0.1625U L=0.065U
M1366_keeper #757 #fb756# O1_at_521_6 Vdd pmos W=0.0975U L=0.065U
M1367_keeper #758 #fb756# O1_at_521_6 GND nmos W=0.0975U L=0.065U
M1368_ #296 __i__f_521_6 O1_af_521_6 Vdd pmos W=0.1625U L=0.065U
M1369_keeper #760 #fb759# O1_af_521_6 Vdd pmos W=0.0975U L=0.065U
M1370_keeper #761 #fb759# O1_af_521_6 GND nmos W=0.0975U L=0.065U
M1371_ #299 I_at_522_6 __o0t_522_6 GND nmos W=0.0975U L=0.065U
M1372_keeper #763 #fb762# __o0t_522_6 Vdd pmos W=0.0975U L=0.065U
M1373_keeper #764 #fb762# __o0t_522_6 GND nmos W=0.0975U L=0.065U
M1374_ #302 I_af_522_6 __o0f_522_6 GND nmos W=0.0975U L=0.065U
M1375_keeper #766 #fb765# __o0f_522_6 Vdd pmos W=0.0975U L=0.065U
M1376_keeper #767 #fb765# __o0f_522_6 GND nmos W=0.0975U L=0.065U
M1377_ #305 __i__t_522_6 O1_at_522_6 Vdd pmos W=0.1625U L=0.065U
M1378_keeper #769 #fb768# O1_at_522_6 Vdd pmos W=0.0975U L=0.065U
M1379_keeper #770 #fb768# O1_at_522_6 GND nmos W=0.0975U L=0.065U
M1380_ #308 __i__f_522_6 O1_af_522_6 Vdd pmos W=0.1625U L=0.065U
M1381_keeper #772 #fb771# O1_af_522_6 Vdd pmos W=0.0975U L=0.065U
M1382_keeper #773 #fb771# O1_af_522_6 GND nmos W=0.0975U L=0.065U
M1383_ #311 I_at_523_6 __o0t_523_6 GND nmos W=0.0975U L=0.065U
M1384_keeper #775 #fb774# __o0t_523_6 Vdd pmos W=0.0975U L=0.065U
M1385_keeper #776 #fb774# __o0t_523_6 GND nmos W=0.0975U L=0.065U
M1386_ #314 I_af_523_6 __o0f_523_6 GND nmos W=0.0975U L=0.065U
M1387_keeper #778 #fb777# __o0f_523_6 Vdd pmos W=0.0975U L=0.065U
M1388_keeper #779 #fb777# __o0f_523_6 GND nmos W=0.0975U L=0.065U
M1389_ #317 __i__t_523_6 O1_at_523_6 Vdd pmos W=0.1625U L=0.065U
M1390_keeper #781 #fb780# O1_at_523_6 Vdd pmos W=0.0975U L=0.065U
M1391_keeper #782 #fb780# O1_at_523_6 GND nmos W=0.0975U L=0.065U
M1392_ #320 __i__f_523_6 O1_af_523_6 Vdd pmos W=0.1625U L=0.065U
M1393_keeper #784 #fb783# O1_af_523_6 Vdd pmos W=0.0975U L=0.065U
M1394_keeper #785 #fb783# O1_af_523_6 GND nmos W=0.0975U L=0.065U
M1395_ #323 I_at_524_6 __o0t_524_6 GND nmos W=0.0975U L=0.065U
M1396_keeper #787 #fb786# __o0t_524_6 Vdd pmos W=0.0975U L=0.065U
M1397_keeper #788 #fb786# __o0t_524_6 GND nmos W=0.0975U L=0.065U
M1398_ #326 I_af_524_6 __o0f_524_6 GND nmos W=0.0975U L=0.065U
M1399_keeper #790 #fb789# __o0f_524_6 Vdd pmos W=0.0975U L=0.065U
M1400_keeper #791 #fb789# __o0f_524_6 GND nmos W=0.0975U L=0.065U
M1401_ #329 __i__t_524_6 O1_at_524_6 Vdd pmos W=0.1625U L=0.065U
M1402_keeper #793 #fb792# O1_at_524_6 Vdd pmos W=0.0975U L=0.065U
M1403_keeper #794 #fb792# O1_at_524_6 GND nmos W=0.0975U L=0.065U
M1404_ #332 __i__f_524_6 O1_af_524_6 Vdd pmos W=0.1625U L=0.065U
M1405_keeper #796 #fb795# O1_af_524_6 Vdd pmos W=0.0975U L=0.065U
M1406_keeper #797 #fb795# O1_af_524_6 GND nmos W=0.0975U L=0.065U
M1407_ #335 I_at_525_6 __o0t_525_6 GND nmos W=0.0975U L=0.065U
M1408_keeper #799 #fb798# __o0t_525_6 Vdd pmos W=0.0975U L=0.065U
M1409_keeper #800 #fb798# __o0t_525_6 GND nmos W=0.0975U L=0.065U
M1410_ #338 I_af_525_6 __o0f_525_6 GND nmos W=0.0975U L=0.065U
M1411_keeper #802 #fb801# __o0f_525_6 Vdd pmos W=0.0975U L=0.065U
M1412_keeper #803 #fb801# __o0f_525_6 GND nmos W=0.0975U L=0.065U
M1413_ #341 __i__t_525_6 O1_at_525_6 Vdd pmos W=0.1625U L=0.065U
M1414_keeper #805 #fb804# O1_at_525_6 Vdd pmos W=0.0975U L=0.065U
M1415_keeper #806 #fb804# O1_at_525_6 GND nmos W=0.0975U L=0.065U
M1416_ #344 __i__f_525_6 O1_af_525_6 Vdd pmos W=0.1625U L=0.065U
M1417_keeper #808 #fb807# O1_af_525_6 Vdd pmos W=0.0975U L=0.065U
M1418_keeper #809 #fb807# O1_af_525_6 GND nmos W=0.0975U L=0.065U
M1419_ #347 I_at_526_6 __o0t_526_6 GND nmos W=0.0975U L=0.065U
M1420_keeper #811 #fb810# __o0t_526_6 Vdd pmos W=0.0975U L=0.065U
M1421_keeper #812 #fb810# __o0t_526_6 GND nmos W=0.0975U L=0.065U
M1422_ #350 I_af_526_6 __o0f_526_6 GND nmos W=0.0975U L=0.065U
M1423_keeper #814 #fb813# __o0f_526_6 Vdd pmos W=0.0975U L=0.065U
M1424_keeper #815 #fb813# __o0f_526_6 GND nmos W=0.0975U L=0.065U
M1425_ #353 __i__t_526_6 O1_at_526_6 Vdd pmos W=0.1625U L=0.065U
M1426_keeper #817 #fb816# O1_at_526_6 Vdd pmos W=0.0975U L=0.065U
M1427_keeper #818 #fb816# O1_at_526_6 GND nmos W=0.0975U L=0.065U
M1428_ #356 __i__f_526_6 O1_af_526_6 Vdd pmos W=0.1625U L=0.065U
M1429_keeper #820 #fb819# O1_af_526_6 Vdd pmos W=0.0975U L=0.065U
M1430_keeper #821 #fb819# O1_af_526_6 GND nmos W=0.0975U L=0.065U
M1431_ #359 I_at_527_6 __o0t_527_6 GND nmos W=0.0975U L=0.065U
M1432_keeper #823 #fb822# __o0t_527_6 Vdd pmos W=0.0975U L=0.065U
M1433_keeper #824 #fb822# __o0t_527_6 GND nmos W=0.0975U L=0.065U
M1434_ #362 I_af_527_6 __o0f_527_6 GND nmos W=0.0975U L=0.065U
M1435_keeper #826 #fb825# __o0f_527_6 Vdd pmos W=0.0975U L=0.065U
M1436_keeper #827 #fb825# __o0f_527_6 GND nmos W=0.0975U L=0.065U
M1437_ #365 __i__t_527_6 O1_at_527_6 Vdd pmos W=0.1625U L=0.065U
M1438_keeper #829 #fb828# O1_at_527_6 Vdd pmos W=0.0975U L=0.065U
M1439_keeper #830 #fb828# O1_at_527_6 GND nmos W=0.0975U L=0.065U
M1440_ #368 __i__f_527_6 O1_af_527_6 Vdd pmos W=0.1625U L=0.065U
M1441_keeper #832 #fb831# O1_af_527_6 Vdd pmos W=0.0975U L=0.065U
M1442_keeper #833 #fb831# O1_af_527_6 GND nmos W=0.0975U L=0.065U
M1443_ #371 I_at_528_6 __o0t_528_6 GND nmos W=0.0975U L=0.065U
M1444_keeper #835 #fb834# __o0t_528_6 Vdd pmos W=0.0975U L=0.065U
M1445_keeper #836 #fb834# __o0t_528_6 GND nmos W=0.0975U L=0.065U
M1446_ #374 I_af_528_6 __o0f_528_6 GND nmos W=0.0975U L=0.065U
M1447_keeper #838 #fb837# __o0f_528_6 Vdd pmos W=0.0975U L=0.065U
M1448_keeper #839 #fb837# __o0f_528_6 GND nmos W=0.0975U L=0.065U
M1449_ #377 __i__t_528_6 O1_at_528_6 Vdd pmos W=0.1625U L=0.065U
M1450_keeper #841 #fb840# O1_at_528_6 Vdd pmos W=0.0975U L=0.065U
M1451_keeper #842 #fb840# O1_at_528_6 GND nmos W=0.0975U L=0.065U
M1452_ #380 __i__f_528_6 O1_af_528_6 Vdd pmos W=0.1625U L=0.065U
M1453_keeper #844 #fb843# O1_af_528_6 Vdd pmos W=0.0975U L=0.065U
M1454_keeper #845 #fb843# O1_af_528_6 GND nmos W=0.0975U L=0.065U
M1455_ #383 I_at_529_6 __o0t_529_6 GND nmos W=0.0975U L=0.065U
M1456_keeper #847 #fb846# __o0t_529_6 Vdd pmos W=0.0975U L=0.065U
M1457_keeper #848 #fb846# __o0t_529_6 GND nmos W=0.0975U L=0.065U
M1458_ #386 I_af_529_6 __o0f_529_6 GND nmos W=0.0975U L=0.065U
M1459_keeper #850 #fb849# __o0f_529_6 Vdd pmos W=0.0975U L=0.065U
M1460_keeper #851 #fb849# __o0f_529_6 GND nmos W=0.0975U L=0.065U
M1461_ #389 __i__t_529_6 O1_at_529_6 Vdd pmos W=0.1625U L=0.065U
M1462_keeper #853 #fb852# O1_at_529_6 Vdd pmos W=0.0975U L=0.065U
M1463_keeper #854 #fb852# O1_at_529_6 GND nmos W=0.0975U L=0.065U
M1464_ #392 __i__f_529_6 O1_af_529_6 Vdd pmos W=0.1625U L=0.065U
M1465_keeper #856 #fb855# O1_af_529_6 Vdd pmos W=0.0975U L=0.065U
M1466_keeper #857 #fb855# O1_af_529_6 GND nmos W=0.0975U L=0.065U
M1467_ #395 I_at_530_6 __o0t_530_6 GND nmos W=0.0975U L=0.065U
M1468_keeper #859 #fb858# __o0t_530_6 Vdd pmos W=0.0975U L=0.065U
M1469_keeper #860 #fb858# __o0t_530_6 GND nmos W=0.0975U L=0.065U
M1470_ #398 I_af_530_6 __o0f_530_6 GND nmos W=0.0975U L=0.065U
M1471_keeper #862 #fb861# __o0f_530_6 Vdd pmos W=0.0975U L=0.065U
M1472_keeper #863 #fb861# __o0f_530_6 GND nmos W=0.0975U L=0.065U
M1473_ #401 __i__t_530_6 O1_at_530_6 Vdd pmos W=0.1625U L=0.065U
M1474_keeper #865 #fb864# O1_at_530_6 Vdd pmos W=0.0975U L=0.065U
M1475_keeper #866 #fb864# O1_at_530_6 GND nmos W=0.0975U L=0.065U
M1476_ #404 __i__f_530_6 O1_af_530_6 Vdd pmos W=0.1625U L=0.065U
M1477_keeper #868 #fb867# O1_af_530_6 Vdd pmos W=0.0975U L=0.065U
M1478_keeper #869 #fb867# O1_af_530_6 GND nmos W=0.0975U L=0.065U
M1479_ #407 I_at_531_6 __o0t_531_6 GND nmos W=0.0975U L=0.065U
M1480_keeper #871 #fb870# __o0t_531_6 Vdd pmos W=0.0975U L=0.065U
M1481_keeper #872 #fb870# __o0t_531_6 GND nmos W=0.0975U L=0.065U
M1482_ #410 I_af_531_6 __o0f_531_6 GND nmos W=0.0975U L=0.065U
M1483_keeper #874 #fb873# __o0f_531_6 Vdd pmos W=0.0975U L=0.065U
M1484_keeper #875 #fb873# __o0f_531_6 GND nmos W=0.0975U L=0.065U
M1485_ #413 __i__t_531_6 O1_at_531_6 Vdd pmos W=0.1625U L=0.065U
M1486_keeper #877 #fb876# O1_at_531_6 Vdd pmos W=0.0975U L=0.065U
M1487_keeper #878 #fb876# O1_at_531_6 GND nmos W=0.0975U L=0.065U
M1488_ #416 __i__f_531_6 O1_af_531_6 Vdd pmos W=0.1625U L=0.065U
M1489_keeper #880 #fb879# O1_af_531_6 Vdd pmos W=0.0975U L=0.065U
M1490_keeper #881 #fb879# O1_af_531_6 GND nmos W=0.0975U L=0.065U
.ends
*---- end of process: InputRouter<> -----
*
*---- act defproc: MltcUnit<> -----
* raw ports:  reset I.t[0] I.t[1] I.t[2] I.t[3] I.t[4] I.t[5] I.t[6] I.t[7] I.t[8] I.t[9] I.t[10] I.t[11] I.t[12] I.t[13] I.t[14] I.t[15] I.t[16] I.t[17] I.t[18] I.t[19] I.t[20] I.t[21] I.t[22] I.t[23] I.t[24] I.t[25] I.t[26] I.t[27] I.t[28] I.t[29] I.t[30] I.t[31] I.f[0] I.f[1] I.f[2] I.f[3] I.f[4] I.f[5] I.f[6] I.f[7] I.f[8] I.f[9] I.f[10] I.f[11] I.f[12] I.f[13] I.f[14] I.f[15] I.f[16] I.f[17] I.f[18] I.f[19] I.f[20] I.f[21] I.f[22] I.f[23] I.f[24] I.f[25] I.f[26] I.f[27] I.f[28] I.f[29] I.f[30] I.f[31] I.a C0.t[0] C0.t[1] C0.t[2] C0.t[3] C0.t[4] C0.t[5] C0.t[6] C0.t[7] C0.t[8] C0.t[9] C0.t[10] C0.t[11] C0.t[12] C0.t[13] C0.t[14] C0.t[15] C0.t[16] C0.t[17] C0.t[18] C0.t[19] C0.t[20] C0.t[21] C0.t[22] C0.t[23] C0.t[24] C0.t[25] C0.t[26] C0.t[27] C0.t[28] C0.t[29] C0.t[30] C0.t[31] C0.f[0] C0.f[1] C0.f[2] C0.f[3] C0.f[4] C0.f[5] C0.f[6] C0.f[7] C0.f[8] C0.f[9] C0.f[10] C0.f[11] C0.f[12] C0.f[13] C0.f[14] C0.f[15] C0.f[16] C0.f[17] C0.f[18] C0.f[19] C0.f[20] C0.f[21] C0.f[22] C0.f[23] C0.f[24] C0.f[25] C0.f[26] C0.f[27] C0.f[28] C0.f[29] C0.f[30] C0.f[31] C0.a C1.t[0] C1.t[1] C1.t[2] C1.t[3] C1.t[4] C1.t[5] C1.t[6] C1.t[7] C1.t[8] C1.t[9] C1.t[10] C1.t[11] C1.t[12] C1.t[13] C1.t[14] C1.t[15] C1.t[16] C1.t[17] C1.t[18] C1.t[19] C1.t[20] C1.t[21] C1.t[22] C1.t[23] C1.t[24] C1.t[25] C1.t[26] C1.t[27] C1.t[28] C1.t[29] C1.t[30] C1.t[31] C1.f[0] C1.f[1] C1.f[2] C1.f[3] C1.f[4] C1.f[5] C1.f[6] C1.f[7] C1.f[8] C1.f[9] C1.f[10] C1.f[11] C1.f[12] C1.f[13] C1.f[14] C1.f[15] C1.f[16] C1.f[17] C1.f[18] C1.f[19] C1.f[20] C1.f[21] C1.f[22] C1.f[23] C1.f[24] C1.f[25] C1.f[26] C1.f[27] C1.f[28] C1.f[29] C1.f[30] C1.f[31] C1.a C2.t[0] C2.t[1] C2.t[2] C2.t[3] C2.t[4] C2.t[5] C2.t[6] C2.t[7] C2.t[8] C2.t[9] C2.t[10] C2.t[11] C2.t[12] C2.t[13] C2.t[14] C2.t[15] C2.t[16] C2.t[17] C2.t[18] C2.t[19] C2.t[20] C2.t[21] C2.t[22] C2.t[23] C2.t[24] C2.t[25] C2.t[26] C2.t[27] C2.t[28] C2.t[29] C2.t[30] C2.t[31] C2.f[0] C2.f[1] C2.f[2] C2.f[3] C2.f[4] C2.f[5] C2.f[6] C2.f[7] C2.f[8] C2.f[9] C2.f[10] C2.f[11] C2.f[12] C2.f[13] C2.f[14] C2.f[15] C2.f[16] C2.f[17] C2.f[18] C2.f[19] C2.f[20] C2.f[21] C2.f[22] C2.f[23] C2.f[24] C2.f[25] C2.f[26] C2.f[27] C2.f[28] C2.f[29] C2.f[30] C2.f[31] C2.a C3.t[0] C3.t[1] C3.t[2] C3.t[3] C3.t[4] C3.t[5] C3.t[6] C3.t[7] C3.t[8] C3.t[9] C3.t[10] C3.t[11] C3.t[12] C3.t[13] C3.t[14] C3.t[15] C3.t[16] C3.t[17] C3.t[18] C3.t[19] C3.t[20] C3.t[21] C3.t[22] C3.t[23] C3.t[24] C3.t[25] C3.t[26] C3.t[27] C3.t[28] C3.t[29] C3.t[30] C3.t[31] C3.f[0] C3.f[1] C3.f[2] C3.f[3] C3.f[4] C3.f[5] C3.f[6] C3.f[7] C3.f[8] C3.f[9] C3.f[10] C3.f[11] C3.f[12] C3.f[13] C3.f[14] C3.f[15] C3.f[16] C3.f[17] C3.f[18] C3.f[19] C3.f[20] C3.f[21] C3.f[22] C3.f[23] C3.f[24] C3.f[25] C3.f[26] C3.f[27] C3.f[28] C3.f[29] C3.f[30] C3.f[31] C3.a
*
.subckt MltcUnit reset I_at_50_6 I_at_51_6 I_at_52_6 I_at_53_6 I_at_54_6 I_at_55_6 I_at_56_6 I_at_57_6 I_at_58_6 I_at_59_6 I_at_510_6 I_at_511_6 I_at_512_6 I_at_513_6 I_at_514_6 I_at_515_6 I_at_516_6 I_at_517_6 I_at_518_6 I_at_519_6 I_at_520_6 I_at_521_6 I_at_522_6 I_at_523_6 I_at_524_6 I_at_525_6 I_at_526_6 I_at_527_6 I_at_528_6 I_at_529_6 I_at_530_6 I_at_531_6 I_af_50_6 I_af_51_6 I_af_52_6 I_af_53_6 I_af_54_6 I_af_55_6 I_af_56_6 I_af_57_6 I_af_58_6 I_af_59_6 I_af_510_6 I_af_511_6 I_af_512_6 I_af_513_6 I_af_514_6 I_af_515_6 I_af_516_6 I_af_517_6 I_af_518_6 I_af_519_6 I_af_520_6 I_af_521_6 I_af_522_6 I_af_523_6 I_af_524_6 I_af_525_6 I_af_526_6 I_af_527_6 I_af_528_6 I_af_529_6 I_af_530_6 I_af_531_6 I_aa C0_at_50_6 C0_at_51_6 C0_at_52_6 C0_at_53_6 C0_at_54_6 C0_at_55_6 C0_at_56_6 C0_at_57_6 C0_at_58_6 C0_at_59_6 C0_at_510_6 C0_at_511_6 C0_at_512_6 C0_at_513_6 C0_at_514_6 C0_at_515_6 C0_at_516_6 C0_at_517_6 C0_at_518_6 C0_at_519_6 C0_at_520_6 C0_at_521_6 C0_at_522_6 C0_at_523_6 C0_at_524_6 C0_at_525_6 C0_at_526_6 C0_at_527_6 C0_at_528_6 C0_at_529_6 C0_at_530_6 C0_at_531_6 C0_af_50_6 C0_af_51_6 C0_af_52_6 C0_af_53_6 C0_af_54_6 C0_af_55_6 C0_af_56_6 C0_af_57_6 C0_af_58_6 C0_af_59_6 C0_af_510_6 C0_af_511_6 C0_af_512_6 C0_af_513_6 C0_af_514_6 C0_af_515_6 C0_af_516_6 C0_af_517_6 C0_af_518_6 C0_af_519_6 C0_af_520_6 C0_af_521_6 C0_af_522_6 C0_af_523_6 C0_af_524_6 C0_af_525_6 C0_af_526_6 C0_af_527_6 C0_af_528_6 C0_af_529_6 C0_af_530_6 C0_af_531_6 C0_aa C1_at_50_6 C1_at_51_6 C1_at_52_6 C1_at_53_6 C1_at_54_6 C1_at_55_6 C1_at_56_6 C1_at_57_6 C1_at_58_6 C1_at_59_6 C1_at_510_6 C1_at_511_6 C1_at_512_6 C1_at_513_6 C1_at_514_6 C1_at_515_6 C1_at_516_6 C1_at_517_6 C1_at_518_6 C1_at_519_6 C1_at_520_6 C1_at_521_6 C1_at_522_6 C1_at_523_6 C1_at_524_6 C1_at_525_6 C1_at_526_6 C1_at_527_6 C1_at_528_6 C1_at_529_6 C1_at_530_6 C1_at_531_6 C1_af_50_6 C1_af_51_6 C1_af_52_6 C1_af_53_6 C1_af_54_6 C1_af_55_6 C1_af_56_6 C1_af_57_6 C1_af_58_6 C1_af_59_6 C1_af_510_6 C1_af_511_6 C1_af_512_6 C1_af_513_6 C1_af_514_6 C1_af_515_6 C1_af_516_6 C1_af_517_6 C1_af_518_6 C1_af_519_6 C1_af_520_6 C1_af_521_6 C1_af_522_6 C1_af_523_6 C1_af_524_6 C1_af_525_6 C1_af_526_6 C1_af_527_6 C1_af_528_6 C1_af_529_6 C1_af_530_6 C1_af_531_6 C1_aa C2_at_50_6 C2_at_51_6 C2_at_52_6 C2_at_53_6 C2_at_54_6 C2_at_55_6 C2_at_56_6 C2_at_57_6 C2_at_58_6 C2_at_59_6 C2_at_510_6 C2_at_511_6 C2_at_512_6 C2_at_513_6 C2_at_514_6 C2_at_515_6 C2_at_516_6 C2_at_517_6 C2_at_518_6 C2_at_519_6 C2_at_520_6 C2_at_521_6 C2_at_522_6 C2_at_523_6 C2_at_524_6 C2_at_525_6 C2_at_526_6 C2_at_527_6 C2_at_528_6 C2_at_529_6 C2_at_530_6 C2_at_531_6 C2_af_50_6 C2_af_51_6 C2_af_52_6 C2_af_53_6 C2_af_54_6 C2_af_55_6 C2_af_56_6 C2_af_57_6 C2_af_58_6 C2_af_59_6 C2_af_510_6 C2_af_511_6 C2_af_512_6 C2_af_513_6 C2_af_514_6 C2_af_515_6 C2_af_516_6 C2_af_517_6 C2_af_518_6 C2_af_519_6 C2_af_520_6 C2_af_521_6 C2_af_522_6 C2_af_523_6 C2_af_524_6 C2_af_525_6 C2_af_526_6 C2_af_527_6 C2_af_528_6 C2_af_529_6 C2_af_530_6 C2_af_531_6 C2_aa C3_at_50_6 C3_at_51_6 C3_at_52_6 C3_at_53_6 C3_at_54_6 C3_at_55_6 C3_at_56_6 C3_at_57_6 C3_at_58_6 C3_at_59_6 C3_at_510_6 C3_at_511_6 C3_at_512_6 C3_at_513_6 C3_at_514_6 C3_at_515_6 C3_at_516_6 C3_at_517_6 C3_at_518_6 C3_at_519_6 C3_at_520_6 C3_at_521_6 C3_at_522_6 C3_at_523_6 C3_at_524_6 C3_at_525_6 C3_at_526_6 C3_at_527_6 C3_at_528_6 C3_at_529_6 C3_at_530_6 C3_at_531_6 C3_af_50_6 C3_af_51_6 C3_af_52_6 C3_af_53_6 C3_af_54_6 C3_af_55_6 C3_af_56_6 C3_af_57_6 C3_af_58_6 C3_af_59_6 C3_af_510_6 C3_af_511_6 C3_af_512_6 C3_af_513_6 C3_af_514_6 C3_af_515_6 C3_af_516_6 C3_af_517_6 C3_af_518_6 C3_af_519_6 C3_af_520_6 C3_af_521_6 C3_af_522_6 C3_af_523_6 C3_af_524_6 C3_af_525_6 C3_af_526_6 C3_af_527_6 C3_af_528_6 C3_af_529_6 C3_af_530_6 C3_af_531_6 C3_aa
*.PININFO reset:I I_at_50_6:I I_at_51_6:I I_at_52_6:I I_at_53_6:I I_at_54_6:I I_at_55_6:I I_at_56_6:I I_at_57_6:I I_at_58_6:I I_at_59_6:I I_at_510_6:I I_at_511_6:I I_at_512_6:I I_at_513_6:I I_at_514_6:I I_at_515_6:I I_at_516_6:I I_at_517_6:I I_at_518_6:I I_at_519_6:I I_at_520_6:I I_at_521_6:I I_at_522_6:I I_at_523_6:I I_at_524_6:I I_at_525_6:I I_at_526_6:I I_at_527_6:I I_at_528_6:I I_at_529_6:I I_at_530_6:I I_at_531_6:I I_af_50_6:I I_af_51_6:I I_af_52_6:I I_af_53_6:I I_af_54_6:I I_af_55_6:I I_af_56_6:I I_af_57_6:I I_af_58_6:I I_af_59_6:I I_af_510_6:I I_af_511_6:I I_af_512_6:I I_af_513_6:I I_af_514_6:I I_af_515_6:I I_af_516_6:I I_af_517_6:I I_af_518_6:I I_af_519_6:I I_af_520_6:I I_af_521_6:I I_af_522_6:I I_af_523_6:I I_af_524_6:I I_af_525_6:I I_af_526_6:I I_af_527_6:I I_af_528_6:I I_af_529_6:I I_af_530_6:I I_af_531_6:I I_aa:O C0_at_50_6:O C0_at_51_6:O C0_at_52_6:O C0_at_53_6:O C0_at_54_6:O C0_at_55_6:O C0_at_56_6:O C0_at_57_6:O C0_at_58_6:O C0_at_59_6:O C0_at_510_6:O C0_at_511_6:O C0_at_512_6:O C0_at_513_6:O C0_at_514_6:O C0_at_515_6:O C0_at_516_6:O C0_at_517_6:O C0_at_518_6:O C0_at_519_6:O C0_at_520_6:O C0_at_521_6:O C0_at_522_6:O C0_at_523_6:O C0_at_524_6:O C0_at_525_6:O C0_at_526_6:O C0_at_527_6:O C0_at_528_6:O C0_at_529_6:O C0_at_530_6:O C0_at_531_6:O C0_af_50_6:O C0_af_51_6:O C0_af_52_6:O C0_af_53_6:O C0_af_54_6:O C0_af_55_6:O C0_af_56_6:O C0_af_57_6:O C0_af_58_6:O C0_af_59_6:O C0_af_510_6:O C0_af_511_6:O C0_af_512_6:O C0_af_513_6:O C0_af_514_6:O C0_af_515_6:O C0_af_516_6:O C0_af_517_6:O C0_af_518_6:O C0_af_519_6:O C0_af_520_6:O C0_af_521_6:O C0_af_522_6:O C0_af_523_6:O C0_af_524_6:O C0_af_525_6:O C0_af_526_6:O C0_af_527_6:O C0_af_528_6:O C0_af_529_6:O C0_af_530_6:O C0_af_531_6:O C0_aa:I C1_at_50_6:O C1_at_51_6:O C1_at_52_6:O C1_at_53_6:O C1_at_54_6:O C1_at_55_6:O C1_at_56_6:O C1_at_57_6:O C1_at_58_6:O C1_at_59_6:O C1_at_510_6:O C1_at_511_6:O C1_at_512_6:O C1_at_513_6:O C1_at_514_6:O C1_at_515_6:O C1_at_516_6:O C1_at_517_6:O C1_at_518_6:O C1_at_519_6:O C1_at_520_6:O C1_at_521_6:O C1_at_522_6:O C1_at_523_6:O C1_at_524_6:O C1_at_525_6:O C1_at_526_6:O C1_at_527_6:O C1_at_528_6:O C1_at_529_6:O C1_at_530_6:O C1_at_531_6:O C1_af_50_6:O C1_af_51_6:O C1_af_52_6:O C1_af_53_6:O C1_af_54_6:O C1_af_55_6:O C1_af_56_6:O C1_af_57_6:O C1_af_58_6:O C1_af_59_6:O C1_af_510_6:O C1_af_511_6:O C1_af_512_6:O C1_af_513_6:O C1_af_514_6:O C1_af_515_6:O C1_af_516_6:O C1_af_517_6:O C1_af_518_6:O C1_af_519_6:O C1_af_520_6:O C1_af_521_6:O C1_af_522_6:O C1_af_523_6:O C1_af_524_6:O C1_af_525_6:O C1_af_526_6:O C1_af_527_6:O C1_af_528_6:O C1_af_529_6:O C1_af_530_6:O C1_af_531_6:O C1_aa:I C2_at_50_6:O C2_at_51_6:O C2_at_52_6:O C2_at_53_6:O C2_at_54_6:O C2_at_55_6:O C2_at_56_6:O C2_at_57_6:O C2_at_58_6:O C2_at_59_6:O C2_at_510_6:O C2_at_511_6:O C2_at_512_6:O C2_at_513_6:O C2_at_514_6:O C2_at_515_6:O C2_at_516_6:O C2_at_517_6:O C2_at_518_6:O C2_at_519_6:O C2_at_520_6:O C2_at_521_6:O C2_at_522_6:O C2_at_523_6:O C2_at_524_6:O C2_at_525_6:O C2_at_526_6:O C2_at_527_6:O C2_at_528_6:O C2_at_529_6:O C2_at_530_6:O C2_at_531_6:O C2_af_50_6:O C2_af_51_6:O C2_af_52_6:O C2_af_53_6:O C2_af_54_6:O C2_af_55_6:O C2_af_56_6:O C2_af_57_6:O C2_af_58_6:O C2_af_59_6:O C2_af_510_6:O C2_af_511_6:O C2_af_512_6:O C2_af_513_6:O C2_af_514_6:O C2_af_515_6:O C2_af_516_6:O C2_af_517_6:O C2_af_518_6:O C2_af_519_6:O C2_af_520_6:O C2_af_521_6:O C2_af_522_6:O C2_af_523_6:O C2_af_524_6:O C2_af_525_6:O C2_af_526_6:O C2_af_527_6:O C2_af_528_6:O C2_af_529_6:O C2_af_530_6:O C2_af_531_6:O C2_aa:I C3_at_50_6:O C3_at_51_6:O C3_at_52_6:O C3_at_53_6:O C3_at_54_6:O C3_at_55_6:O C3_at_56_6:O C3_at_57_6:O C3_at_58_6:O C3_at_59_6:O C3_at_510_6:O C3_at_511_6:O C3_at_512_6:O C3_at_513_6:O C3_at_514_6:O C3_at_515_6:O C3_at_516_6:O C3_at_517_6:O C3_at_518_6:O C3_at_519_6:O C3_at_520_6:O C3_at_521_6:O C3_at_522_6:O C3_at_523_6:O C3_at_524_6:O C3_at_525_6:O C3_at_526_6:O C3_at_527_6:O C3_at_528_6:O C3_at_529_6:O C3_at_530_6:O C3_at_531_6:O C3_af_50_6:O C3_af_51_6:O C3_af_52_6:O C3_af_53_6:O C3_af_54_6:O C3_af_55_6:O C3_af_56_6:O C3_af_57_6:O C3_af_58_6:O C3_af_59_6:O C3_af_510_6:O C3_af_511_6:O C3_af_512_6:O C3_af_513_6:O C3_af_514_6:O C3_af_515_6:O C3_af_516_6:O C3_af_517_6:O C3_af_518_6:O C3_af_519_6:O C3_af_520_6:O C3_af_521_6:O C3_af_522_6:O C3_af_523_6:O C3_af_524_6:O C3_af_525_6:O C3_af_526_6:O C3_af_527_6:O C3_af_528_6:O C3_af_529_6:O C3_af_530_6:O C3_af_531_6:O C3_aa:I
*.POWER VDD Vdd
*.POWER GND GND
*.POWER NSUB GND
*.POWER PSUB Vdd
xDS1 reset QR_aOD1_at_50_6 QR_aOD1_at_51_6 QR_aOD1_at_52_6 QR_aOD1_at_53_6 QR_aOD1_af_50_6 QR_aOD1_af_51_6 QR_aOD1_af_52_6 QR_aOD1_af_53_6 QR_aOD1_aa M1_aI0_at_50_6 M1_aI0_at_51_6 M1_aI0_at_52_6 M1_aI0_at_53_6 M1_aI0_at_54_6 M1_aI0_at_55_6 M1_aI0_at_56_6 M1_aI0_at_57_6 M1_aI0_at_58_6 M1_aI0_at_59_6 M1_aI0_at_510_6 M1_aI0_at_511_6 M1_aI0_at_512_6 M1_aI0_at_513_6 M1_aI0_at_514_6 M1_aI0_at_515_6 M1_aI0_at_516_6 M1_aI0_at_517_6 M1_aI0_at_518_6 M1_aI0_at_519_6 M1_aI0_at_520_6 M1_aI0_at_521_6 M1_aI0_at_522_6 M1_aI0_at_523_6 M1_aI0_at_524_6 M1_aI0_at_525_6 M1_aI0_at_526_6 M1_aI0_at_527_6 M1_aI0_at_528_6 M1_aI0_at_529_6 M1_aI0_at_530_6 M1_aI0_at_531_6 M1_aI0_af_50_6 M1_aI0_af_51_6 M1_aI0_af_52_6 M1_aI0_af_53_6 M1_aI0_af_54_6 M1_aI0_af_55_6 M1_aI0_af_56_6 M1_aI0_af_57_6 M1_aI0_af_58_6 M1_aI0_af_59_6 M1_aI0_af_510_6 M1_aI0_af_511_6 M1_aI0_af_512_6 M1_aI0_af_513_6 M1_aI0_af_514_6 M1_aI0_af_515_6 M1_aI0_af_516_6 M1_aI0_af_517_6 M1_aI0_af_518_6 M1_aI0_af_519_6 M1_aI0_af_520_6 M1_aI0_af_521_6 M1_aI0_af_522_6 M1_aI0_af_523_6 M1_aI0_af_524_6 M1_aI0_af_525_6 M1_aI0_af_526_6 M1_aI0_af_527_6 M1_aI0_af_528_6 M1_aI0_af_529_6 M1_aI0_af_530_6 M1_aI0_af_531_6 M1_aI0_aa Deserializer
xCT2 reset QR_aOC2_at_50_6 QR_aOC2_at_51_6 QR_aOC2_at_52_6 QR_aOC2_at_53_6 QR_aOC2_af_50_6 QR_aOC2_af_51_6 QR_aOC2_af_52_6 QR_aOC2_af_53_6 QR_aOC2_aa QR_aCnt2_areq QR_aCnt2_at_50_6 QR_aCnt2_at_51_6 QR_aCnt2_at_52_6 QR_aCnt2_at_53_6 QR_aCnt2_at_54_6 QR_aCnt2_at_55_6 QR_aCnt2_at_56_6 QR_aCnt2_at_57_6 QR_aCnt2_af_50_6 QR_aCnt2_af_51_6 QR_aCnt2_af_52_6 QR_aCnt2_af_53_6 QR_aCnt2_af_54_6 QR_aCnt2_af_55_6 QR_aCnt2_af_56_6 QR_aCnt2_af_57_6 Counter
xDS2 reset QR_aOD2_at_50_6 QR_aOD2_at_51_6 QR_aOD2_at_52_6 QR_aOD2_at_53_6 QR_aOD2_af_50_6 QR_aOD2_af_51_6 QR_aOD2_af_52_6 QR_aOD2_af_53_6 QR_aOD2_aa M2_aI0_at_50_6 M2_aI0_at_51_6 M2_aI0_at_52_6 M2_aI0_at_53_6 M2_aI0_at_54_6 M2_aI0_at_55_6 M2_aI0_at_56_6 M2_aI0_at_57_6 M2_aI0_at_58_6 M2_aI0_at_59_6 M2_aI0_at_510_6 M2_aI0_at_511_6 M2_aI0_at_512_6 M2_aI0_at_513_6 M2_aI0_at_514_6 M2_aI0_at_515_6 M2_aI0_at_516_6 M2_aI0_at_517_6 M2_aI0_at_518_6 M2_aI0_at_519_6 M2_aI0_at_520_6 M2_aI0_at_521_6 M2_aI0_at_522_6 M2_aI0_at_523_6 M2_aI0_at_524_6 M2_aI0_at_525_6 M2_aI0_at_526_6 M2_aI0_at_527_6 M2_aI0_at_528_6 M2_aI0_at_529_6 M2_aI0_at_530_6 M2_aI0_at_531_6 M2_aI0_af_50_6 M2_aI0_af_51_6 M2_aI0_af_52_6 M2_aI0_af_53_6 M2_aI0_af_54_6 M2_aI0_af_55_6 M2_aI0_af_56_6 M2_aI0_af_57_6 M2_aI0_af_58_6 M2_aI0_af_59_6 M2_aI0_af_510_6 M2_aI0_af_511_6 M2_aI0_af_512_6 M2_aI0_af_513_6 M2_aI0_af_514_6 M2_aI0_af_515_6 M2_aI0_af_516_6 M2_aI0_af_517_6 M2_aI0_af_518_6 M2_aI0_af_519_6 M2_aI0_af_520_6 M2_aI0_af_521_6 M2_aI0_af_522_6 M2_aI0_af_523_6 M2_aI0_af_524_6 M2_aI0_af_525_6 M2_aI0_af_526_6 M2_aI0_af_527_6 M2_aI0_af_528_6 M2_aI0_af_529_6 M2_aI0_af_530_6 M2_aI0_af_531_6 M2_aI0_aa Deserializer
xDS3 reset QR_aOD3_at_50_6 QR_aOD3_at_51_6 QR_aOD3_at_52_6 QR_aOD3_at_53_6 QR_aOD3_af_50_6 QR_aOD3_af_51_6 QR_aOD3_af_52_6 QR_aOD3_af_53_6 QR_aOD3_aa M3_aI0_at_50_6 M3_aI0_at_51_6 M3_aI0_at_52_6 M3_aI0_at_53_6 M3_aI0_at_54_6 M3_aI0_at_55_6 M3_aI0_at_56_6 M3_aI0_at_57_6 M3_aI0_at_58_6 M3_aI0_at_59_6 M3_aI0_at_510_6 M3_aI0_at_511_6 M3_aI0_at_512_6 M3_aI0_at_513_6 M3_aI0_at_514_6 M3_aI0_at_515_6 M3_aI0_at_516_6 M3_aI0_at_517_6 M3_aI0_at_518_6 M3_aI0_at_519_6 M3_aI0_at_520_6 M3_aI0_at_521_6 M3_aI0_at_522_6 M3_aI0_at_523_6 M3_aI0_at_524_6 M3_aI0_at_525_6 M3_aI0_at_526_6 M3_aI0_at_527_6 M3_aI0_at_528_6 M3_aI0_at_529_6 M3_aI0_at_530_6 M3_aI0_at_531_6 M3_aI0_af_50_6 M3_aI0_af_51_6 M3_aI0_af_52_6 M3_aI0_af_53_6 M3_aI0_af_54_6 M3_aI0_af_55_6 M3_aI0_af_56_6 M3_aI0_af_57_6 M3_aI0_af_58_6 M3_aI0_af_59_6 M3_aI0_af_510_6 M3_aI0_af_511_6 M3_aI0_af_512_6 M3_aI0_af_513_6 M3_aI0_af_514_6 M3_aI0_af_515_6 M3_aI0_af_516_6 M3_aI0_af_517_6 M3_aI0_af_518_6 M3_aI0_af_519_6 M3_aI0_af_520_6 M3_aI0_af_521_6 M3_aI0_af_522_6 M3_aI0_af_523_6 M3_aI0_af_524_6 M3_aI0_af_525_6 M3_aI0_af_526_6 M3_aI0_af_527_6 M3_aI0_af_528_6 M3_aI0_af_529_6 M3_aI0_af_530_6 M3_aI0_af_531_6 M3_aI0_aa Deserializer
xSE reset IR_aO0_at_50_6 IR_aO0_at_51_6 IR_aO0_at_52_6 IR_aO0_at_53_6 IR_aO0_at_54_6 IR_aO0_at_55_6 IR_aO0_at_56_6 IR_aO0_at_57_6 IR_aO0_at_58_6 IR_aO0_at_59_6 IR_aO0_at_510_6 IR_aO0_at_511_6 IR_aO0_at_512_6 IR_aO0_at_513_6 IR_aO0_at_514_6 IR_aO0_at_515_6 IR_aO0_at_516_6 IR_aO0_at_517_6 IR_aO0_at_518_6 IR_aO0_at_519_6 IR_aO0_at_520_6 IR_aO0_at_521_6 IR_aO0_at_522_6 IR_aO0_at_523_6 IR_aO0_at_524_6 IR_aO0_at_525_6 IR_aO0_at_526_6 IR_aO0_at_527_6 IR_aO0_at_528_6 IR_aO0_at_529_6 IR_aO0_at_530_6 IR_aO0_at_531_6 IR_aO0_af_50_6 IR_aO0_af_51_6 IR_aO0_af_52_6 IR_aO0_af_53_6 IR_aO0_af_54_6 IR_aO0_af_55_6 IR_aO0_af_56_6 IR_aO0_af_57_6 IR_aO0_af_58_6 IR_aO0_af_59_6 IR_aO0_af_510_6 IR_aO0_af_511_6 IR_aO0_af_512_6 IR_aO0_af_513_6 IR_aO0_af_514_6 IR_aO0_af_515_6 IR_aO0_af_516_6 IR_aO0_af_517_6 IR_aO0_af_518_6 IR_aO0_af_519_6 IR_aO0_af_520_6 IR_aO0_af_521_6 IR_aO0_af_522_6 IR_aO0_af_523_6 IR_aO0_af_524_6 IR_aO0_af_525_6 IR_aO0_af_526_6 IR_aO0_af_527_6 IR_aO0_af_528_6 IR_aO0_af_529_6 IR_aO0_af_530_6 IR_aO0_af_531_6 IR_aO0_aa QR_aI_at_50_6 QR_aI_at_51_6 QR_aI_at_52_6 QR_aI_at_53_6 QR_aI_af_50_6 QR_aI_af_51_6 QR_aI_af_52_6 QR_aI_af_53_6 QR_aI_aa Serializer
xCT1 reset QR_aOC1_at_50_6 QR_aOC1_at_51_6 QR_aOC1_at_52_6 QR_aOC1_at_53_6 QR_aOC1_af_50_6 QR_aOC1_af_51_6 QR_aOC1_af_52_6 QR_aOC1_af_53_6 QR_aOC1_aa QR_aCnt1_areq QR_aCnt1_at_50_6 QR_aCnt1_at_51_6 QR_aCnt1_at_52_6 QR_aCnt1_at_53_6 QR_aCnt1_at_54_6 QR_aCnt1_at_55_6 QR_aCnt1_at_56_6 QR_aCnt1_at_57_6 QR_aCnt1_af_50_6 QR_aCnt1_af_51_6 QR_aCnt1_af_52_6 QR_aCnt1_af_53_6 QR_aCnt1_af_54_6 QR_aCnt1_af_55_6 QR_aCnt1_af_56_6 QR_aCnt1_af_57_6 Counter
xCT3 reset QR_aOC3_at_50_6 QR_aOC3_at_51_6 QR_aOC3_at_52_6 QR_aOC3_at_53_6 QR_aOC3_af_50_6 QR_aOC3_af_51_6 QR_aOC3_af_52_6 QR_aOC3_af_53_6 QR_aOC3_aa QR_aCnt3_areq QR_aCnt3_at_50_6 QR_aCnt3_at_51_6 QR_aCnt3_at_52_6 QR_aCnt3_at_53_6 QR_aCnt3_at_54_6 QR_aCnt3_at_55_6 QR_aCnt3_at_56_6 QR_aCnt3_at_57_6 QR_aCnt3_af_50_6 QR_aCnt3_af_51_6 QR_aCnt3_af_52_6 QR_aCnt3_af_53_6 QR_aCnt3_af_54_6 QR_aCnt3_af_55_6 QR_aCnt3_af_56_6 QR_aCnt3_af_57_6 Counter
xM3 M3_aI0_at_50_6 M3_aI0_at_51_6 M3_aI0_at_52_6 M3_aI0_at_53_6 M3_aI0_at_54_6 M3_aI0_at_55_6 M3_aI0_at_56_6 M3_aI0_at_57_6 M3_aI0_at_58_6 M3_aI0_at_59_6 M3_aI0_at_510_6 M3_aI0_at_511_6 M3_aI0_at_512_6 M3_aI0_at_513_6 M3_aI0_at_514_6 M3_aI0_at_515_6 M3_aI0_at_516_6 M3_aI0_at_517_6 M3_aI0_at_518_6 M3_aI0_at_519_6 M3_aI0_at_520_6 M3_aI0_at_521_6 M3_aI0_at_522_6 M3_aI0_at_523_6 M3_aI0_at_524_6 M3_aI0_at_525_6 M3_aI0_at_526_6 M3_aI0_at_527_6 M3_aI0_at_528_6 M3_aI0_at_529_6 M3_aI0_at_530_6 M3_aI0_at_531_6 M3_aI0_af_50_6 M3_aI0_af_51_6 M3_aI0_af_52_6 M3_aI0_af_53_6 M3_aI0_af_54_6 M3_aI0_af_55_6 M3_aI0_af_56_6 M3_aI0_af_57_6 M3_aI0_af_58_6 M3_aI0_af_59_6 M3_aI0_af_510_6 M3_aI0_af_511_6 M3_aI0_af_512_6 M3_aI0_af_513_6 M3_aI0_af_514_6 M3_aI0_af_515_6 M3_aI0_af_516_6 M3_aI0_af_517_6 M3_aI0_af_518_6 M3_aI0_af_519_6 M3_aI0_af_520_6 M3_aI0_af_521_6 M3_aI0_af_522_6 M3_aI0_af_523_6 M3_aI0_af_524_6 M3_aI0_af_525_6 M3_aI0_af_526_6 M3_aI0_af_527_6 M3_aI0_af_528_6 M3_aI0_af_529_6 M3_aI0_af_530_6 M3_aI0_af_531_6 M3_aI0_aa M3_aI1_at_50_6 M3_aI1_at_51_6 M3_aI1_at_52_6 M3_aI1_at_53_6 M3_aI1_at_54_6 M3_aI1_at_55_6 M3_aI1_at_56_6 M3_aI1_at_57_6 M3_aI1_at_58_6 M3_aI1_at_59_6 M3_aI1_at_510_6 M3_aI1_at_511_6 M3_aI1_at_512_6 M3_aI1_at_513_6 M3_aI1_at_514_6 M3_aI1_at_515_6 M3_aI1_at_516_6 M3_aI1_at_517_6 M3_aI1_at_518_6 M3_aI1_at_519_6 M3_aI1_at_520_6 M3_aI1_at_521_6 M3_aI1_at_522_6 M3_aI1_at_523_6 M3_aI1_at_524_6 M3_aI1_at_525_6 M3_aI1_at_526_6 M3_aI1_at_527_6 M3_aI1_at_528_6 M3_aI1_at_529_6 M3_aI1_at_530_6 M3_aI1_at_531_6 M3_aI1_af_50_6 M3_aI1_af_51_6 M3_aI1_af_52_6 M3_aI1_af_53_6 M3_aI1_af_54_6 M3_aI1_af_55_6 M3_aI1_af_56_6 M3_aI1_af_57_6 M3_aI1_af_58_6 M3_aI1_af_59_6 M3_aI1_af_510_6 M3_aI1_af_511_6 M3_aI1_af_512_6 M3_aI1_af_513_6 M3_aI1_af_514_6 M3_aI1_af_515_6 M3_aI1_af_516_6 M3_aI1_af_517_6 M3_aI1_af_518_6 M3_aI1_af_519_6 M3_aI1_af_520_6 M3_aI1_af_521_6 M3_aI1_af_522_6 M3_aI1_af_523_6 M3_aI1_af_524_6 M3_aI1_af_525_6 M3_aI1_af_526_6 M3_aI1_af_527_6 M3_aI1_af_528_6 M3_aI1_af_529_6 M3_aI1_af_530_6 M3_aI1_af_531_6 M3_aI1_aa C3_at_50_6 C3_at_51_6 C3_at_52_6 C3_at_53_6 C3_at_54_6 C3_at_55_6 C3_at_56_6 C3_at_57_6 C3_at_58_6 C3_at_59_6 C3_at_510_6 C3_at_511_6 C3_at_512_6 C3_at_513_6 C3_at_514_6 C3_at_515_6 C3_at_516_6 C3_at_517_6 C3_at_518_6 C3_at_519_6 C3_at_520_6 C3_at_521_6 C3_at_522_6 C3_at_523_6 C3_at_524_6 C3_at_525_6 C3_at_526_6 C3_at_527_6 C3_at_528_6 C3_at_529_6 C3_at_530_6 C3_at_531_6 C3_af_50_6 C3_af_51_6 C3_af_52_6 C3_af_53_6 C3_af_54_6 C3_af_55_6 C3_af_56_6 C3_af_57_6 C3_af_58_6 C3_af_59_6 C3_af_510_6 C3_af_511_6 C3_af_512_6 C3_af_513_6 C3_af_514_6 C3_af_515_6 C3_af_516_6 C3_af_517_6 C3_af_518_6 C3_af_519_6 C3_af_520_6 C3_af_521_6 C3_af_522_6 C3_af_523_6 C3_af_524_6 C3_af_525_6 C3_af_526_6 C3_af_527_6 C3_af_528_6 C3_af_529_6 C3_af_530_6 C3_af_531_6 C3_aa Merge_332_7t_4
xPD reset IR_aO1_at_50_6 IR_aO1_at_51_6 IR_aO1_at_52_6 IR_aO1_at_53_6 IR_aO1_at_54_6 IR_aO1_at_55_6 IR_aO1_at_56_6 IR_aO1_at_57_6 IR_aO1_at_58_6 IR_aO1_at_59_6 IR_aO1_at_510_6 IR_aO1_at_511_6 IR_aO1_at_512_6 IR_aO1_at_513_6 IR_aO1_at_514_6 IR_aO1_at_515_6 IR_aO1_at_516_6 IR_aO1_at_517_6 IR_aO1_at_518_6 IR_aO1_at_519_6 IR_aO1_at_520_6 IR_aO1_at_521_6 IR_aO1_at_522_6 IR_aO1_at_523_6 IR_aO1_at_524_6 IR_aO1_at_525_6 IR_aO1_at_526_6 IR_aO1_at_527_6 IR_aO1_at_528_6 IR_aO1_at_529_6 IR_aO1_at_530_6 IR_aO1_at_531_6 IR_aO1_af_50_6 IR_aO1_af_51_6 IR_aO1_af_52_6 IR_aO1_af_53_6 IR_aO1_af_54_6 IR_aO1_af_55_6 IR_aO1_af_56_6 IR_aO1_af_57_6 IR_aO1_af_58_6 IR_aO1_af_59_6 IR_aO1_af_510_6 IR_aO1_af_511_6 IR_aO1_af_512_6 IR_aO1_af_513_6 IR_aO1_af_514_6 IR_aO1_af_515_6 IR_aO1_af_516_6 IR_aO1_af_517_6 IR_aO1_af_518_6 IR_aO1_af_519_6 IR_aO1_af_520_6 IR_aO1_af_521_6 IR_aO1_af_522_6 IR_aO1_af_523_6 IR_aO1_af_524_6 IR_aO1_af_525_6 IR_aO1_af_526_6 IR_aO1_af_527_6 IR_aO1_af_528_6 IR_aO1_af_529_6 IR_aO1_af_530_6 IR_aO1_af_531_6 IR_aO1_aa PD_aCh_at_50_6 PD_aCh_at_51_6 PD_aCh_at_52_6 PD_aCh_at_53_6 PD_aCh_af_50_6 PD_aCh_af_51_6 PD_aCh_af_52_6 PD_aCh_af_53_6 PD_aCh_aa M0_aI1_at_50_6 M0_aI1_at_51_6 M0_aI1_at_52_6 M0_aI1_at_53_6 M0_aI1_at_54_6 M0_aI1_at_55_6 M0_aI1_at_56_6 M0_aI1_at_57_6 M0_aI1_at_58_6 M0_aI1_at_59_6 M0_aI1_at_510_6 M0_aI1_at_511_6 M0_aI1_at_512_6 M0_aI1_at_513_6 M0_aI1_at_514_6 M0_aI1_at_515_6 M0_aI1_at_516_6 M0_aI1_at_517_6 M0_aI1_at_518_6 M0_aI1_at_519_6 M0_aI1_at_520_6 M0_aI1_at_521_6 M0_aI1_at_522_6 M0_aI1_at_523_6 M0_aI1_at_524_6 M0_aI1_at_525_6 M0_aI1_at_526_6 M0_aI1_at_527_6 M0_aI1_at_528_6 M0_aI1_at_529_6 M0_aI1_at_530_6 M0_aI1_at_531_6 M0_aI1_af_50_6 M0_aI1_af_51_6 M0_aI1_af_52_6 M0_aI1_af_53_6 M0_aI1_af_54_6 M0_aI1_af_55_6 M0_aI1_af_56_6 M0_aI1_af_57_6 M0_aI1_af_58_6 M0_aI1_af_59_6 M0_aI1_af_510_6 M0_aI1_af_511_6 M0_aI1_af_512_6 M0_aI1_af_513_6 M0_aI1_af_514_6 M0_aI1_af_515_6 M0_aI1_af_516_6 M0_aI1_af_517_6 M0_aI1_af_518_6 M0_aI1_af_519_6 M0_aI1_af_520_6 M0_aI1_af_521_6 M0_aI1_af_522_6 M0_aI1_af_523_6 M0_aI1_af_524_6 M0_aI1_af_525_6 M0_aI1_af_526_6 M0_aI1_af_527_6 M0_aI1_af_528_6 M0_aI1_af_529_6 M0_aI1_af_530_6 M0_aI1_af_531_6 M0_aI1_aa M1_aI1_at_50_6 M1_aI1_at_51_6 M1_aI1_at_52_6 M1_aI1_at_53_6 M1_aI1_at_54_6 M1_aI1_at_55_6 M1_aI1_at_56_6 M1_aI1_at_57_6 M1_aI1_at_58_6 M1_aI1_at_59_6 M1_aI1_at_510_6 M1_aI1_at_511_6 M1_aI1_at_512_6 M1_aI1_at_513_6 M1_aI1_at_514_6 M1_aI1_at_515_6 M1_aI1_at_516_6 M1_aI1_at_517_6 M1_aI1_at_518_6 M1_aI1_at_519_6 M1_aI1_at_520_6 M1_aI1_at_521_6 M1_aI1_at_522_6 M1_aI1_at_523_6 M1_aI1_at_524_6 M1_aI1_at_525_6 M1_aI1_at_526_6 M1_aI1_at_527_6 M1_aI1_at_528_6 M1_aI1_at_529_6 M1_aI1_at_530_6 M1_aI1_at_531_6 M1_aI1_af_50_6 M1_aI1_af_51_6 M1_aI1_af_52_6 M1_aI1_af_53_6 M1_aI1_af_54_6 M1_aI1_af_55_6 M1_aI1_af_56_6 M1_aI1_af_57_6 M1_aI1_af_58_6 M1_aI1_af_59_6 M1_aI1_af_510_6 M1_aI1_af_511_6 M1_aI1_af_512_6 M1_aI1_af_513_6 M1_aI1_af_514_6 M1_aI1_af_515_6 M1_aI1_af_516_6 M1_aI1_af_517_6 M1_aI1_af_518_6 M1_aI1_af_519_6 M1_aI1_af_520_6 M1_aI1_af_521_6 M1_aI1_af_522_6 M1_aI1_af_523_6 M1_aI1_af_524_6 M1_aI1_af_525_6 M1_aI1_af_526_6 M1_aI1_af_527_6 M1_aI1_af_528_6 M1_aI1_af_529_6 M1_aI1_af_530_6 M1_aI1_af_531_6 M1_aI1_aa M2_aI1_at_50_6 M2_aI1_at_51_6 M2_aI1_at_52_6 M2_aI1_at_53_6 M2_aI1_at_54_6 M2_aI1_at_55_6 M2_aI1_at_56_6 M2_aI1_at_57_6 M2_aI1_at_58_6 M2_aI1_at_59_6 M2_aI1_at_510_6 M2_aI1_at_511_6 M2_aI1_at_512_6 M2_aI1_at_513_6 M2_aI1_at_514_6 M2_aI1_at_515_6 M2_aI1_at_516_6 M2_aI1_at_517_6 M2_aI1_at_518_6 M2_aI1_at_519_6 M2_aI1_at_520_6 M2_aI1_at_521_6 M2_aI1_at_522_6 M2_aI1_at_523_6 M2_aI1_at_524_6 M2_aI1_at_525_6 M2_aI1_at_526_6 M2_aI1_at_527_6 M2_aI1_at_528_6 M2_aI1_at_529_6 M2_aI1_at_530_6 M2_aI1_at_531_6 M2_aI1_af_50_6 M2_aI1_af_51_6 M2_aI1_af_52_6 M2_aI1_af_53_6 M2_aI1_af_54_6 M2_aI1_af_55_6 M2_aI1_af_56_6 M2_aI1_af_57_6 M2_aI1_af_58_6 M2_aI1_af_59_6 M2_aI1_af_510_6 M2_aI1_af_511_6 M2_aI1_af_512_6 M2_aI1_af_513_6 M2_aI1_af_514_6 M2_aI1_af_515_6 M2_aI1_af_516_6 M2_aI1_af_517_6 M2_aI1_af_518_6 M2_aI1_af_519_6 M2_aI1_af_520_6 M2_aI1_af_521_6 M2_aI1_af_522_6 M2_aI1_af_523_6 M2_aI1_af_524_6 M2_aI1_af_525_6 M2_aI1_af_526_6 M2_aI1_af_527_6 M2_aI1_af_528_6 M2_aI1_af_529_6 M2_aI1_af_530_6 M2_aI1_af_531_6 M2_aI1_aa M3_aI1_at_50_6 M3_aI1_at_51_6 M3_aI1_at_52_6 M3_aI1_at_53_6 M3_aI1_at_54_6 M3_aI1_at_55_6 M3_aI1_at_56_6 M3_aI1_at_57_6 M3_aI1_at_58_6 M3_aI1_at_59_6 M3_aI1_at_510_6 M3_aI1_at_511_6 M3_aI1_at_512_6 M3_aI1_at_513_6 M3_aI1_at_514_6 M3_aI1_at_515_6 M3_aI1_at_516_6 M3_aI1_at_517_6 M3_aI1_at_518_6 M3_aI1_at_519_6 M3_aI1_at_520_6 M3_aI1_at_521_6 M3_aI1_at_522_6 M3_aI1_at_523_6 M3_aI1_at_524_6 M3_aI1_at_525_6 M3_aI1_at_526_6 M3_aI1_at_527_6 M3_aI1_at_528_6 M3_aI1_at_529_6 M3_aI1_at_530_6 M3_aI1_at_531_6 M3_aI1_af_50_6 M3_aI1_af_51_6 M3_aI1_af_52_6 M3_aI1_af_53_6 M3_aI1_af_54_6 M3_aI1_af_55_6 M3_aI1_af_56_6 M3_aI1_af_57_6 M3_aI1_af_58_6 M3_aI1_af_59_6 M3_aI1_af_510_6 M3_aI1_af_511_6 M3_aI1_af_512_6 M3_aI1_af_513_6 M3_aI1_af_514_6 M3_aI1_af_515_6 M3_aI1_af_516_6 M3_aI1_af_517_6 M3_aI1_af_518_6 M3_aI1_af_519_6 M3_aI1_af_520_6 M3_aI1_af_521_6 M3_aI1_af_522_6 M3_aI1_af_523_6 M3_aI1_af_524_6 M3_aI1_af_525_6 M3_aI1_af_526_6 M3_aI1_af_527_6 M3_aI1_af_528_6 M3_aI1_af_529_6 M3_aI1_af_530_6 M3_aI1_af_531_6 M3_aI1_aa PayloadDispatch
xQR reset QR_aI_at_50_6 QR_aI_at_51_6 QR_aI_at_52_6 QR_aI_at_53_6 QR_aI_af_50_6 QR_aI_af_51_6 QR_aI_af_52_6 QR_aI_af_53_6 QR_aI_aa QR_aCnt0_areq QR_aCnt0_at_50_6 QR_aCnt0_at_51_6 QR_aCnt0_at_52_6 QR_aCnt0_at_53_6 QR_aCnt0_at_54_6 QR_aCnt0_at_55_6 QR_aCnt0_at_56_6 QR_aCnt0_at_57_6 QR_aCnt0_af_50_6 QR_aCnt0_af_51_6 QR_aCnt0_af_52_6 QR_aCnt0_af_53_6 QR_aCnt0_af_54_6 QR_aCnt0_af_55_6 QR_aCnt0_af_56_6 QR_aCnt0_af_57_6 QR_aCnt1_areq QR_aCnt1_at_50_6 QR_aCnt1_at_51_6 QR_aCnt1_at_52_6 QR_aCnt1_at_53_6 QR_aCnt1_at_54_6 QR_aCnt1_at_55_6 QR_aCnt1_at_56_6 QR_aCnt1_at_57_6 QR_aCnt1_af_50_6 QR_aCnt1_af_51_6 QR_aCnt1_af_52_6 QR_aCnt1_af_53_6 QR_aCnt1_af_54_6 QR_aCnt1_af_55_6 QR_aCnt1_af_56_6 QR_aCnt1_af_57_6 QR_aCnt2_areq QR_aCnt2_at_50_6 QR_aCnt2_at_51_6 QR_aCnt2_at_52_6 QR_aCnt2_at_53_6 QR_aCnt2_at_54_6 QR_aCnt2_at_55_6 QR_aCnt2_at_56_6 QR_aCnt2_at_57_6 QR_aCnt2_af_50_6 QR_aCnt2_af_51_6 QR_aCnt2_af_52_6 QR_aCnt2_af_53_6 QR_aCnt2_af_54_6 QR_aCnt2_af_55_6 QR_aCnt2_af_56_6 QR_aCnt2_af_57_6 QR_aCnt3_areq QR_aCnt3_at_50_6 QR_aCnt3_at_51_6 QR_aCnt3_at_52_6 QR_aCnt3_at_53_6 QR_aCnt3_at_54_6 QR_aCnt3_at_55_6 QR_aCnt3_at_56_6 QR_aCnt3_at_57_6 QR_aCnt3_af_50_6 QR_aCnt3_af_51_6 QR_aCnt3_af_52_6 QR_aCnt3_af_53_6 QR_aCnt3_af_54_6 QR_aCnt3_af_55_6 QR_aCnt3_af_56_6 QR_aCnt3_af_57_6 QR_aOC0_at_50_6 QR_aOC0_at_51_6 QR_aOC0_at_52_6 QR_aOC0_at_53_6 QR_aOC0_af_50_6 QR_aOC0_af_51_6 QR_aOC0_af_52_6 QR_aOC0_af_53_6 QR_aOC0_aa QR_aOC1_at_50_6 QR_aOC1_at_51_6 QR_aOC1_at_52_6 QR_aOC1_at_53_6 QR_aOC1_af_50_6 QR_aOC1_af_51_6 QR_aOC1_af_52_6 QR_aOC1_af_53_6 QR_aOC1_aa QR_aOC2_at_50_6 QR_aOC2_at_51_6 QR_aOC2_at_52_6 QR_aOC2_at_53_6 QR_aOC2_af_50_6 QR_aOC2_af_51_6 QR_aOC2_af_52_6 QR_aOC2_af_53_6 QR_aOC2_aa QR_aOC3_at_50_6 QR_aOC3_at_51_6 QR_aOC3_at_52_6 QR_aOC3_at_53_6 QR_aOC3_af_50_6 QR_aOC3_af_51_6 QR_aOC3_af_52_6 QR_aOC3_af_53_6 QR_aOC3_aa QR_aOD0_at_50_6 QR_aOD0_at_51_6 QR_aOD0_at_52_6 QR_aOD0_at_53_6 QR_aOD0_af_50_6 QR_aOD0_af_51_6 QR_aOD0_af_52_6 QR_aOD0_af_53_6 QR_aOD0_aa QR_aOD1_at_50_6 QR_aOD1_at_51_6 QR_aOD1_at_52_6 QR_aOD1_at_53_6 QR_aOD1_af_50_6 QR_aOD1_af_51_6 QR_aOD1_af_52_6 QR_aOD1_af_53_6 QR_aOD1_aa QR_aOD2_at_50_6 QR_aOD2_at_51_6 QR_aOD2_at_52_6 QR_aOD2_at_53_6 QR_aOD2_af_50_6 QR_aOD2_af_51_6 QR_aOD2_af_52_6 QR_aOD2_af_53_6 QR_aOD2_aa QR_aOD3_at_50_6 QR_aOD3_at_51_6 QR_aOD3_at_52_6 QR_aOD3_at_53_6 QR_aOD3_af_50_6 QR_aOD3_af_51_6 QR_aOD3_af_52_6 QR_aOD3_af_53_6 QR_aOD3_aa PD_aCh_at_50_6 PD_aCh_at_51_6 PD_aCh_at_52_6 PD_aCh_at_53_6 PD_aCh_af_50_6 PD_aCh_af_51_6 PD_aCh_af_52_6 PD_aCh_af_53_6 PD_aCh_aa QuadRouter
xM1 M1_aI0_at_50_6 M1_aI0_at_51_6 M1_aI0_at_52_6 M1_aI0_at_53_6 M1_aI0_at_54_6 M1_aI0_at_55_6 M1_aI0_at_56_6 M1_aI0_at_57_6 M1_aI0_at_58_6 M1_aI0_at_59_6 M1_aI0_at_510_6 M1_aI0_at_511_6 M1_aI0_at_512_6 M1_aI0_at_513_6 M1_aI0_at_514_6 M1_aI0_at_515_6 M1_aI0_at_516_6 M1_aI0_at_517_6 M1_aI0_at_518_6 M1_aI0_at_519_6 M1_aI0_at_520_6 M1_aI0_at_521_6 M1_aI0_at_522_6 M1_aI0_at_523_6 M1_aI0_at_524_6 M1_aI0_at_525_6 M1_aI0_at_526_6 M1_aI0_at_527_6 M1_aI0_at_528_6 M1_aI0_at_529_6 M1_aI0_at_530_6 M1_aI0_at_531_6 M1_aI0_af_50_6 M1_aI0_af_51_6 M1_aI0_af_52_6 M1_aI0_af_53_6 M1_aI0_af_54_6 M1_aI0_af_55_6 M1_aI0_af_56_6 M1_aI0_af_57_6 M1_aI0_af_58_6 M1_aI0_af_59_6 M1_aI0_af_510_6 M1_aI0_af_511_6 M1_aI0_af_512_6 M1_aI0_af_513_6 M1_aI0_af_514_6 M1_aI0_af_515_6 M1_aI0_af_516_6 M1_aI0_af_517_6 M1_aI0_af_518_6 M1_aI0_af_519_6 M1_aI0_af_520_6 M1_aI0_af_521_6 M1_aI0_af_522_6 M1_aI0_af_523_6 M1_aI0_af_524_6 M1_aI0_af_525_6 M1_aI0_af_526_6 M1_aI0_af_527_6 M1_aI0_af_528_6 M1_aI0_af_529_6 M1_aI0_af_530_6 M1_aI0_af_531_6 M1_aI0_aa M1_aI1_at_50_6 M1_aI1_at_51_6 M1_aI1_at_52_6 M1_aI1_at_53_6 M1_aI1_at_54_6 M1_aI1_at_55_6 M1_aI1_at_56_6 M1_aI1_at_57_6 M1_aI1_at_58_6 M1_aI1_at_59_6 M1_aI1_at_510_6 M1_aI1_at_511_6 M1_aI1_at_512_6 M1_aI1_at_513_6 M1_aI1_at_514_6 M1_aI1_at_515_6 M1_aI1_at_516_6 M1_aI1_at_517_6 M1_aI1_at_518_6 M1_aI1_at_519_6 M1_aI1_at_520_6 M1_aI1_at_521_6 M1_aI1_at_522_6 M1_aI1_at_523_6 M1_aI1_at_524_6 M1_aI1_at_525_6 M1_aI1_at_526_6 M1_aI1_at_527_6 M1_aI1_at_528_6 M1_aI1_at_529_6 M1_aI1_at_530_6 M1_aI1_at_531_6 M1_aI1_af_50_6 M1_aI1_af_51_6 M1_aI1_af_52_6 M1_aI1_af_53_6 M1_aI1_af_54_6 M1_aI1_af_55_6 M1_aI1_af_56_6 M1_aI1_af_57_6 M1_aI1_af_58_6 M1_aI1_af_59_6 M1_aI1_af_510_6 M1_aI1_af_511_6 M1_aI1_af_512_6 M1_aI1_af_513_6 M1_aI1_af_514_6 M1_aI1_af_515_6 M1_aI1_af_516_6 M1_aI1_af_517_6 M1_aI1_af_518_6 M1_aI1_af_519_6 M1_aI1_af_520_6 M1_aI1_af_521_6 M1_aI1_af_522_6 M1_aI1_af_523_6 M1_aI1_af_524_6 M1_aI1_af_525_6 M1_aI1_af_526_6 M1_aI1_af_527_6 M1_aI1_af_528_6 M1_aI1_af_529_6 M1_aI1_af_530_6 M1_aI1_af_531_6 M1_aI1_aa C1_at_50_6 C1_at_51_6 C1_at_52_6 C1_at_53_6 C1_at_54_6 C1_at_55_6 C1_at_56_6 C1_at_57_6 C1_at_58_6 C1_at_59_6 C1_at_510_6 C1_at_511_6 C1_at_512_6 C1_at_513_6 C1_at_514_6 C1_at_515_6 C1_at_516_6 C1_at_517_6 C1_at_518_6 C1_at_519_6 C1_at_520_6 C1_at_521_6 C1_at_522_6 C1_at_523_6 C1_at_524_6 C1_at_525_6 C1_at_526_6 C1_at_527_6 C1_at_528_6 C1_at_529_6 C1_at_530_6 C1_at_531_6 C1_af_50_6 C1_af_51_6 C1_af_52_6 C1_af_53_6 C1_af_54_6 C1_af_55_6 C1_af_56_6 C1_af_57_6 C1_af_58_6 C1_af_59_6 C1_af_510_6 C1_af_511_6 C1_af_512_6 C1_af_513_6 C1_af_514_6 C1_af_515_6 C1_af_516_6 C1_af_517_6 C1_af_518_6 C1_af_519_6 C1_af_520_6 C1_af_521_6 C1_af_522_6 C1_af_523_6 C1_af_524_6 C1_af_525_6 C1_af_526_6 C1_af_527_6 C1_af_528_6 C1_af_529_6 C1_af_530_6 C1_af_531_6 C1_aa Merge_332_7t_4
xM0 M0_aI0_at_50_6 M0_aI0_at_51_6 M0_aI0_at_52_6 M0_aI0_at_53_6 M0_aI0_at_54_6 M0_aI0_at_55_6 M0_aI0_at_56_6 M0_aI0_at_57_6 M0_aI0_at_58_6 M0_aI0_at_59_6 M0_aI0_at_510_6 M0_aI0_at_511_6 M0_aI0_at_512_6 M0_aI0_at_513_6 M0_aI0_at_514_6 M0_aI0_at_515_6 M0_aI0_at_516_6 M0_aI0_at_517_6 M0_aI0_at_518_6 M0_aI0_at_519_6 M0_aI0_at_520_6 M0_aI0_at_521_6 M0_aI0_at_522_6 M0_aI0_at_523_6 M0_aI0_at_524_6 M0_aI0_at_525_6 M0_aI0_at_526_6 M0_aI0_at_527_6 M0_aI0_at_528_6 M0_aI0_at_529_6 M0_aI0_at_530_6 M0_aI0_at_531_6 M0_aI0_af_50_6 M0_aI0_af_51_6 M0_aI0_af_52_6 M0_aI0_af_53_6 M0_aI0_af_54_6 M0_aI0_af_55_6 M0_aI0_af_56_6 M0_aI0_af_57_6 M0_aI0_af_58_6 M0_aI0_af_59_6 M0_aI0_af_510_6 M0_aI0_af_511_6 M0_aI0_af_512_6 M0_aI0_af_513_6 M0_aI0_af_514_6 M0_aI0_af_515_6 M0_aI0_af_516_6 M0_aI0_af_517_6 M0_aI0_af_518_6 M0_aI0_af_519_6 M0_aI0_af_520_6 M0_aI0_af_521_6 M0_aI0_af_522_6 M0_aI0_af_523_6 M0_aI0_af_524_6 M0_aI0_af_525_6 M0_aI0_af_526_6 M0_aI0_af_527_6 M0_aI0_af_528_6 M0_aI0_af_529_6 M0_aI0_af_530_6 M0_aI0_af_531_6 M0_aI0_aa M0_aI1_at_50_6 M0_aI1_at_51_6 M0_aI1_at_52_6 M0_aI1_at_53_6 M0_aI1_at_54_6 M0_aI1_at_55_6 M0_aI1_at_56_6 M0_aI1_at_57_6 M0_aI1_at_58_6 M0_aI1_at_59_6 M0_aI1_at_510_6 M0_aI1_at_511_6 M0_aI1_at_512_6 M0_aI1_at_513_6 M0_aI1_at_514_6 M0_aI1_at_515_6 M0_aI1_at_516_6 M0_aI1_at_517_6 M0_aI1_at_518_6 M0_aI1_at_519_6 M0_aI1_at_520_6 M0_aI1_at_521_6 M0_aI1_at_522_6 M0_aI1_at_523_6 M0_aI1_at_524_6 M0_aI1_at_525_6 M0_aI1_at_526_6 M0_aI1_at_527_6 M0_aI1_at_528_6 M0_aI1_at_529_6 M0_aI1_at_530_6 M0_aI1_at_531_6 M0_aI1_af_50_6 M0_aI1_af_51_6 M0_aI1_af_52_6 M0_aI1_af_53_6 M0_aI1_af_54_6 M0_aI1_af_55_6 M0_aI1_af_56_6 M0_aI1_af_57_6 M0_aI1_af_58_6 M0_aI1_af_59_6 M0_aI1_af_510_6 M0_aI1_af_511_6 M0_aI1_af_512_6 M0_aI1_af_513_6 M0_aI1_af_514_6 M0_aI1_af_515_6 M0_aI1_af_516_6 M0_aI1_af_517_6 M0_aI1_af_518_6 M0_aI1_af_519_6 M0_aI1_af_520_6 M0_aI1_af_521_6 M0_aI1_af_522_6 M0_aI1_af_523_6 M0_aI1_af_524_6 M0_aI1_af_525_6 M0_aI1_af_526_6 M0_aI1_af_527_6 M0_aI1_af_528_6 M0_aI1_af_529_6 M0_aI1_af_530_6 M0_aI1_af_531_6 M0_aI1_aa C0_at_50_6 C0_at_51_6 C0_at_52_6 C0_at_53_6 C0_at_54_6 C0_at_55_6 C0_at_56_6 C0_at_57_6 C0_at_58_6 C0_at_59_6 C0_at_510_6 C0_at_511_6 C0_at_512_6 C0_at_513_6 C0_at_514_6 C0_at_515_6 C0_at_516_6 C0_at_517_6 C0_at_518_6 C0_at_519_6 C0_at_520_6 C0_at_521_6 C0_at_522_6 C0_at_523_6 C0_at_524_6 C0_at_525_6 C0_at_526_6 C0_at_527_6 C0_at_528_6 C0_at_529_6 C0_at_530_6 C0_at_531_6 C0_af_50_6 C0_af_51_6 C0_af_52_6 C0_af_53_6 C0_af_54_6 C0_af_55_6 C0_af_56_6 C0_af_57_6 C0_af_58_6 C0_af_59_6 C0_af_510_6 C0_af_511_6 C0_af_512_6 C0_af_513_6 C0_af_514_6 C0_af_515_6 C0_af_516_6 C0_af_517_6 C0_af_518_6 C0_af_519_6 C0_af_520_6 C0_af_521_6 C0_af_522_6 C0_af_523_6 C0_af_524_6 C0_af_525_6 C0_af_526_6 C0_af_527_6 C0_af_528_6 C0_af_529_6 C0_af_530_6 C0_af_531_6 C0_aa Merge_332_7t_4
xIR reset I_at_50_6 I_at_51_6 I_at_52_6 I_at_53_6 I_at_54_6 I_at_55_6 I_at_56_6 I_at_57_6 I_at_58_6 I_at_59_6 I_at_510_6 I_at_511_6 I_at_512_6 I_at_513_6 I_at_514_6 I_at_515_6 I_at_516_6 I_at_517_6 I_at_518_6 I_at_519_6 I_at_520_6 I_at_521_6 I_at_522_6 I_at_523_6 I_at_524_6 I_at_525_6 I_at_526_6 I_at_527_6 I_at_528_6 I_at_529_6 I_at_530_6 I_at_531_6 I_af_50_6 I_af_51_6 I_af_52_6 I_af_53_6 I_af_54_6 I_af_55_6 I_af_56_6 I_af_57_6 I_af_58_6 I_af_59_6 I_af_510_6 I_af_511_6 I_af_512_6 I_af_513_6 I_af_514_6 I_af_515_6 I_af_516_6 I_af_517_6 I_af_518_6 I_af_519_6 I_af_520_6 I_af_521_6 I_af_522_6 I_af_523_6 I_af_524_6 I_af_525_6 I_af_526_6 I_af_527_6 I_af_528_6 I_af_529_6 I_af_530_6 I_af_531_6 I_aa IR_aO0_at_50_6 IR_aO0_at_51_6 IR_aO0_at_52_6 IR_aO0_at_53_6 IR_aO0_at_54_6 IR_aO0_at_55_6 IR_aO0_at_56_6 IR_aO0_at_57_6 IR_aO0_at_58_6 IR_aO0_at_59_6 IR_aO0_at_510_6 IR_aO0_at_511_6 IR_aO0_at_512_6 IR_aO0_at_513_6 IR_aO0_at_514_6 IR_aO0_at_515_6 IR_aO0_at_516_6 IR_aO0_at_517_6 IR_aO0_at_518_6 IR_aO0_at_519_6 IR_aO0_at_520_6 IR_aO0_at_521_6 IR_aO0_at_522_6 IR_aO0_at_523_6 IR_aO0_at_524_6 IR_aO0_at_525_6 IR_aO0_at_526_6 IR_aO0_at_527_6 IR_aO0_at_528_6 IR_aO0_at_529_6 IR_aO0_at_530_6 IR_aO0_at_531_6 IR_aO0_af_50_6 IR_aO0_af_51_6 IR_aO0_af_52_6 IR_aO0_af_53_6 IR_aO0_af_54_6 IR_aO0_af_55_6 IR_aO0_af_56_6 IR_aO0_af_57_6 IR_aO0_af_58_6 IR_aO0_af_59_6 IR_aO0_af_510_6 IR_aO0_af_511_6 IR_aO0_af_512_6 IR_aO0_af_513_6 IR_aO0_af_514_6 IR_aO0_af_515_6 IR_aO0_af_516_6 IR_aO0_af_517_6 IR_aO0_af_518_6 IR_aO0_af_519_6 IR_aO0_af_520_6 IR_aO0_af_521_6 IR_aO0_af_522_6 IR_aO0_af_523_6 IR_aO0_af_524_6 IR_aO0_af_525_6 IR_aO0_af_526_6 IR_aO0_af_527_6 IR_aO0_af_528_6 IR_aO0_af_529_6 IR_aO0_af_530_6 IR_aO0_af_531_6 IR_aO0_aa IR_aO1_at_50_6 IR_aO1_at_51_6 IR_aO1_at_52_6 IR_aO1_at_53_6 IR_aO1_at_54_6 IR_aO1_at_55_6 IR_aO1_at_56_6 IR_aO1_at_57_6 IR_aO1_at_58_6 IR_aO1_at_59_6 IR_aO1_at_510_6 IR_aO1_at_511_6 IR_aO1_at_512_6 IR_aO1_at_513_6 IR_aO1_at_514_6 IR_aO1_at_515_6 IR_aO1_at_516_6 IR_aO1_at_517_6 IR_aO1_at_518_6 IR_aO1_at_519_6 IR_aO1_at_520_6 IR_aO1_at_521_6 IR_aO1_at_522_6 IR_aO1_at_523_6 IR_aO1_at_524_6 IR_aO1_at_525_6 IR_aO1_at_526_6 IR_aO1_at_527_6 IR_aO1_at_528_6 IR_aO1_at_529_6 IR_aO1_at_530_6 IR_aO1_at_531_6 IR_aO1_af_50_6 IR_aO1_af_51_6 IR_aO1_af_52_6 IR_aO1_af_53_6 IR_aO1_af_54_6 IR_aO1_af_55_6 IR_aO1_af_56_6 IR_aO1_af_57_6 IR_aO1_af_58_6 IR_aO1_af_59_6 IR_aO1_af_510_6 IR_aO1_af_511_6 IR_aO1_af_512_6 IR_aO1_af_513_6 IR_aO1_af_514_6 IR_aO1_af_515_6 IR_aO1_af_516_6 IR_aO1_af_517_6 IR_aO1_af_518_6 IR_aO1_af_519_6 IR_aO1_af_520_6 IR_aO1_af_521_6 IR_aO1_af_522_6 IR_aO1_af_523_6 IR_aO1_af_524_6 IR_aO1_af_525_6 IR_aO1_af_526_6 IR_aO1_af_527_6 IR_aO1_af_528_6 IR_aO1_af_529_6 IR_aO1_af_530_6 IR_aO1_af_531_6 IR_aO1_aa InputRouter
xDS0 reset QR_aOD0_at_50_6 QR_aOD0_at_51_6 QR_aOD0_at_52_6 QR_aOD0_at_53_6 QR_aOD0_af_50_6 QR_aOD0_af_51_6 QR_aOD0_af_52_6 QR_aOD0_af_53_6 QR_aOD0_aa M0_aI0_at_50_6 M0_aI0_at_51_6 M0_aI0_at_52_6 M0_aI0_at_53_6 M0_aI0_at_54_6 M0_aI0_at_55_6 M0_aI0_at_56_6 M0_aI0_at_57_6 M0_aI0_at_58_6 M0_aI0_at_59_6 M0_aI0_at_510_6 M0_aI0_at_511_6 M0_aI0_at_512_6 M0_aI0_at_513_6 M0_aI0_at_514_6 M0_aI0_at_515_6 M0_aI0_at_516_6 M0_aI0_at_517_6 M0_aI0_at_518_6 M0_aI0_at_519_6 M0_aI0_at_520_6 M0_aI0_at_521_6 M0_aI0_at_522_6 M0_aI0_at_523_6 M0_aI0_at_524_6 M0_aI0_at_525_6 M0_aI0_at_526_6 M0_aI0_at_527_6 M0_aI0_at_528_6 M0_aI0_at_529_6 M0_aI0_at_530_6 M0_aI0_at_531_6 M0_aI0_af_50_6 M0_aI0_af_51_6 M0_aI0_af_52_6 M0_aI0_af_53_6 M0_aI0_af_54_6 M0_aI0_af_55_6 M0_aI0_af_56_6 M0_aI0_af_57_6 M0_aI0_af_58_6 M0_aI0_af_59_6 M0_aI0_af_510_6 M0_aI0_af_511_6 M0_aI0_af_512_6 M0_aI0_af_513_6 M0_aI0_af_514_6 M0_aI0_af_515_6 M0_aI0_af_516_6 M0_aI0_af_517_6 M0_aI0_af_518_6 M0_aI0_af_519_6 M0_aI0_af_520_6 M0_aI0_af_521_6 M0_aI0_af_522_6 M0_aI0_af_523_6 M0_aI0_af_524_6 M0_aI0_af_525_6 M0_aI0_af_526_6 M0_aI0_af_527_6 M0_aI0_af_528_6 M0_aI0_af_529_6 M0_aI0_af_530_6 M0_aI0_af_531_6 M0_aI0_aa Deserializer
xM2 M2_aI0_at_50_6 M2_aI0_at_51_6 M2_aI0_at_52_6 M2_aI0_at_53_6 M2_aI0_at_54_6 M2_aI0_at_55_6 M2_aI0_at_56_6 M2_aI0_at_57_6 M2_aI0_at_58_6 M2_aI0_at_59_6 M2_aI0_at_510_6 M2_aI0_at_511_6 M2_aI0_at_512_6 M2_aI0_at_513_6 M2_aI0_at_514_6 M2_aI0_at_515_6 M2_aI0_at_516_6 M2_aI0_at_517_6 M2_aI0_at_518_6 M2_aI0_at_519_6 M2_aI0_at_520_6 M2_aI0_at_521_6 M2_aI0_at_522_6 M2_aI0_at_523_6 M2_aI0_at_524_6 M2_aI0_at_525_6 M2_aI0_at_526_6 M2_aI0_at_527_6 M2_aI0_at_528_6 M2_aI0_at_529_6 M2_aI0_at_530_6 M2_aI0_at_531_6 M2_aI0_af_50_6 M2_aI0_af_51_6 M2_aI0_af_52_6 M2_aI0_af_53_6 M2_aI0_af_54_6 M2_aI0_af_55_6 M2_aI0_af_56_6 M2_aI0_af_57_6 M2_aI0_af_58_6 M2_aI0_af_59_6 M2_aI0_af_510_6 M2_aI0_af_511_6 M2_aI0_af_512_6 M2_aI0_af_513_6 M2_aI0_af_514_6 M2_aI0_af_515_6 M2_aI0_af_516_6 M2_aI0_af_517_6 M2_aI0_af_518_6 M2_aI0_af_519_6 M2_aI0_af_520_6 M2_aI0_af_521_6 M2_aI0_af_522_6 M2_aI0_af_523_6 M2_aI0_af_524_6 M2_aI0_af_525_6 M2_aI0_af_526_6 M2_aI0_af_527_6 M2_aI0_af_528_6 M2_aI0_af_529_6 M2_aI0_af_530_6 M2_aI0_af_531_6 M2_aI0_aa M2_aI1_at_50_6 M2_aI1_at_51_6 M2_aI1_at_52_6 M2_aI1_at_53_6 M2_aI1_at_54_6 M2_aI1_at_55_6 M2_aI1_at_56_6 M2_aI1_at_57_6 M2_aI1_at_58_6 M2_aI1_at_59_6 M2_aI1_at_510_6 M2_aI1_at_511_6 M2_aI1_at_512_6 M2_aI1_at_513_6 M2_aI1_at_514_6 M2_aI1_at_515_6 M2_aI1_at_516_6 M2_aI1_at_517_6 M2_aI1_at_518_6 M2_aI1_at_519_6 M2_aI1_at_520_6 M2_aI1_at_521_6 M2_aI1_at_522_6 M2_aI1_at_523_6 M2_aI1_at_524_6 M2_aI1_at_525_6 M2_aI1_at_526_6 M2_aI1_at_527_6 M2_aI1_at_528_6 M2_aI1_at_529_6 M2_aI1_at_530_6 M2_aI1_at_531_6 M2_aI1_af_50_6 M2_aI1_af_51_6 M2_aI1_af_52_6 M2_aI1_af_53_6 M2_aI1_af_54_6 M2_aI1_af_55_6 M2_aI1_af_56_6 M2_aI1_af_57_6 M2_aI1_af_58_6 M2_aI1_af_59_6 M2_aI1_af_510_6 M2_aI1_af_511_6 M2_aI1_af_512_6 M2_aI1_af_513_6 M2_aI1_af_514_6 M2_aI1_af_515_6 M2_aI1_af_516_6 M2_aI1_af_517_6 M2_aI1_af_518_6 M2_aI1_af_519_6 M2_aI1_af_520_6 M2_aI1_af_521_6 M2_aI1_af_522_6 M2_aI1_af_523_6 M2_aI1_af_524_6 M2_aI1_af_525_6 M2_aI1_af_526_6 M2_aI1_af_527_6 M2_aI1_af_528_6 M2_aI1_af_529_6 M2_aI1_af_530_6 M2_aI1_af_531_6 M2_aI1_aa C2_at_50_6 C2_at_51_6 C2_at_52_6 C2_at_53_6 C2_at_54_6 C2_at_55_6 C2_at_56_6 C2_at_57_6 C2_at_58_6 C2_at_59_6 C2_at_510_6 C2_at_511_6 C2_at_512_6 C2_at_513_6 C2_at_514_6 C2_at_515_6 C2_at_516_6 C2_at_517_6 C2_at_518_6 C2_at_519_6 C2_at_520_6 C2_at_521_6 C2_at_522_6 C2_at_523_6 C2_at_524_6 C2_at_525_6 C2_at_526_6 C2_at_527_6 C2_at_528_6 C2_at_529_6 C2_at_530_6 C2_at_531_6 C2_af_50_6 C2_af_51_6 C2_af_52_6 C2_af_53_6 C2_af_54_6 C2_af_55_6 C2_af_56_6 C2_af_57_6 C2_af_58_6 C2_af_59_6 C2_af_510_6 C2_af_511_6 C2_af_512_6 C2_af_513_6 C2_af_514_6 C2_af_515_6 C2_af_516_6 C2_af_517_6 C2_af_518_6 C2_af_519_6 C2_af_520_6 C2_af_521_6 C2_af_522_6 C2_af_523_6 C2_af_524_6 C2_af_525_6 C2_af_526_6 C2_af_527_6 C2_af_528_6 C2_af_529_6 C2_af_530_6 C2_af_531_6 C2_aa Merge_332_7t_4
xCT0 reset QR_aOC0_at_50_6 QR_aOC0_at_51_6 QR_aOC0_at_52_6 QR_aOC0_at_53_6 QR_aOC0_af_50_6 QR_aOC0_af_51_6 QR_aOC0_af_52_6 QR_aOC0_af_53_6 QR_aOC0_aa QR_aCnt0_areq QR_aCnt0_at_50_6 QR_aCnt0_at_51_6 QR_aCnt0_at_52_6 QR_aCnt0_at_53_6 QR_aCnt0_at_54_6 QR_aCnt0_at_55_6 QR_aCnt0_at_56_6 QR_aCnt0_at_57_6 QR_aCnt0_af_50_6 QR_aCnt0_af_51_6 QR_aCnt0_af_52_6 QR_aCnt0_af_53_6 QR_aCnt0_af_54_6 QR_aCnt0_af_55_6 QR_aCnt0_af_56_6 QR_aCnt0_af_57_6 Counter
.ends
*---- end of process: MltcUnit<> -----
*
*---- act defproc: Router<> -----
* raw ports:  reset C0i.t[0] C0i.t[1] C0i.t[2] C0i.t[3] C0i.t[4] C0i.t[5] C0i.t[6] C0i.t[7] C0i.t[8] C0i.t[9] C0i.t[10] C0i.t[11] C0i.t[12] C0i.t[13] C0i.t[14] C0i.t[15] C0i.t[16] C0i.t[17] C0i.t[18] C0i.t[19] C0i.t[20] C0i.t[21] C0i.t[22] C0i.t[23] C0i.t[24] C0i.t[25] C0i.t[26] C0i.t[27] C0i.t[28] C0i.t[29] C0i.t[30] C0i.t[31] C0i.f[0] C0i.f[1] C0i.f[2] C0i.f[3] C0i.f[4] C0i.f[5] C0i.f[6] C0i.f[7] C0i.f[8] C0i.f[9] C0i.f[10] C0i.f[11] C0i.f[12] C0i.f[13] C0i.f[14] C0i.f[15] C0i.f[16] C0i.f[17] C0i.f[18] C0i.f[19] C0i.f[20] C0i.f[21] C0i.f[22] C0i.f[23] C0i.f[24] C0i.f[25] C0i.f[26] C0i.f[27] C0i.f[28] C0i.f[29] C0i.f[30] C0i.f[31] C0i.a C1i.t[0] C1i.t[1] C1i.t[2] C1i.t[3] C1i.t[4] C1i.t[5] C1i.t[6] C1i.t[7] C1i.t[8] C1i.t[9] C1i.t[10] C1i.t[11] C1i.t[12] C1i.t[13] C1i.t[14] C1i.t[15] C1i.t[16] C1i.t[17] C1i.t[18] C1i.t[19] C1i.t[20] C1i.t[21] C1i.t[22] C1i.t[23] C1i.t[24] C1i.t[25] C1i.t[26] C1i.t[27] C1i.t[28] C1i.t[29] C1i.t[30] C1i.t[31] C1i.f[0] C1i.f[1] C1i.f[2] C1i.f[3] C1i.f[4] C1i.f[5] C1i.f[6] C1i.f[7] C1i.f[8] C1i.f[9] C1i.f[10] C1i.f[11] C1i.f[12] C1i.f[13] C1i.f[14] C1i.f[15] C1i.f[16] C1i.f[17] C1i.f[18] C1i.f[19] C1i.f[20] C1i.f[21] C1i.f[22] C1i.f[23] C1i.f[24] C1i.f[25] C1i.f[26] C1i.f[27] C1i.f[28] C1i.f[29] C1i.f[30] C1i.f[31] C1i.a C2i.t[0] C2i.t[1] C2i.t[2] C2i.t[3] C2i.t[4] C2i.t[5] C2i.t[6] C2i.t[7] C2i.t[8] C2i.t[9] C2i.t[10] C2i.t[11] C2i.t[12] C2i.t[13] C2i.t[14] C2i.t[15] C2i.t[16] C2i.t[17] C2i.t[18] C2i.t[19] C2i.t[20] C2i.t[21] C2i.t[22] C2i.t[23] C2i.t[24] C2i.t[25] C2i.t[26] C2i.t[27] C2i.t[28] C2i.t[29] C2i.t[30] C2i.t[31] C2i.f[0] C2i.f[1] C2i.f[2] C2i.f[3] C2i.f[4] C2i.f[5] C2i.f[6] C2i.f[7] C2i.f[8] C2i.f[9] C2i.f[10] C2i.f[11] C2i.f[12] C2i.f[13] C2i.f[14] C2i.f[15] C2i.f[16] C2i.f[17] C2i.f[18] C2i.f[19] C2i.f[20] C2i.f[21] C2i.f[22] C2i.f[23] C2i.f[24] C2i.f[25] C2i.f[26] C2i.f[27] C2i.f[28] C2i.f[29] C2i.f[30] C2i.f[31] C2i.a C3i.t[0] C3i.t[1] C3i.t[2] C3i.t[3] C3i.t[4] C3i.t[5] C3i.t[6] C3i.t[7] C3i.t[8] C3i.t[9] C3i.t[10] C3i.t[11] C3i.t[12] C3i.t[13] C3i.t[14] C3i.t[15] C3i.t[16] C3i.t[17] C3i.t[18] C3i.t[19] C3i.t[20] C3i.t[21] C3i.t[22] C3i.t[23] C3i.t[24] C3i.t[25] C3i.t[26] C3i.t[27] C3i.t[28] C3i.t[29] C3i.t[30] C3i.t[31] C3i.f[0] C3i.f[1] C3i.f[2] C3i.f[3] C3i.f[4] C3i.f[5] C3i.f[6] C3i.f[7] C3i.f[8] C3i.f[9] C3i.f[10] C3i.f[11] C3i.f[12] C3i.f[13] C3i.f[14] C3i.f[15] C3i.f[16] C3i.f[17] C3i.f[18] C3i.f[19] C3i.f[20] C3i.f[21] C3i.f[22] C3i.f[23] C3i.f[24] C3i.f[25] C3i.f[26] C3i.f[27] C3i.f[28] C3i.f[29] C3i.f[30] C3i.f[31] C3i.a Pi.t[0] Pi.t[1] Pi.t[2] Pi.t[3] Pi.t[4] Pi.t[5] Pi.t[6] Pi.t[7] Pi.t[8] Pi.t[9] Pi.t[10] Pi.t[11] Pi.t[12] Pi.t[13] Pi.t[14] Pi.t[15] Pi.t[16] Pi.t[17] Pi.t[18] Pi.t[19] Pi.t[20] Pi.t[21] Pi.t[22] Pi.t[23] Pi.t[24] Pi.t[25] Pi.t[26] Pi.t[27] Pi.t[28] Pi.t[29] Pi.t[30] Pi.t[31] Pi.f[0] Pi.f[1] Pi.f[2] Pi.f[3] Pi.f[4] Pi.f[5] Pi.f[6] Pi.f[7] Pi.f[8] Pi.f[9] Pi.f[10] Pi.f[11] Pi.f[12] Pi.f[13] Pi.f[14] Pi.f[15] Pi.f[16] Pi.f[17] Pi.f[18] Pi.f[19] Pi.f[20] Pi.f[21] Pi.f[22] Pi.f[23] Pi.f[24] Pi.f[25] Pi.f[26] Pi.f[27] Pi.f[28] Pi.f[29] Pi.f[30] Pi.f[31] Pi.a C0o.t[0] C0o.t[1] C0o.t[2] C0o.t[3] C0o.t[4] C0o.t[5] C0o.t[6] C0o.t[7] C0o.t[8] C0o.t[9] C0o.t[10] C0o.t[11] C0o.t[12] C0o.t[13] C0o.t[14] C0o.t[15] C0o.t[16] C0o.t[17] C0o.t[18] C0o.t[19] C0o.t[20] C0o.t[21] C0o.t[22] C0o.t[23] C0o.t[24] C0o.t[25] C0o.t[26] C0o.t[27] C0o.t[28] C0o.t[29] C0o.t[30] C0o.t[31] C0o.f[0] C0o.f[1] C0o.f[2] C0o.f[3] C0o.f[4] C0o.f[5] C0o.f[6] C0o.f[7] C0o.f[8] C0o.f[9] C0o.f[10] C0o.f[11] C0o.f[12] C0o.f[13] C0o.f[14] C0o.f[15] C0o.f[16] C0o.f[17] C0o.f[18] C0o.f[19] C0o.f[20] C0o.f[21] C0o.f[22] C0o.f[23] C0o.f[24] C0o.f[25] C0o.f[26] C0o.f[27] C0o.f[28] C0o.f[29] C0o.f[30] C0o.f[31] C0o.a C1o.t[0] C1o.t[1] C1o.t[2] C1o.t[3] C1o.t[4] C1o.t[5] C1o.t[6] C1o.t[7] C1o.t[8] C1o.t[9] C1o.t[10] C1o.t[11] C1o.t[12] C1o.t[13] C1o.t[14] C1o.t[15] C1o.t[16] C1o.t[17] C1o.t[18] C1o.t[19] C1o.t[20] C1o.t[21] C1o.t[22] C1o.t[23] C1o.t[24] C1o.t[25] C1o.t[26] C1o.t[27] C1o.t[28] C1o.t[29] C1o.t[30] C1o.t[31] C1o.f[0] C1o.f[1] C1o.f[2] C1o.f[3] C1o.f[4] C1o.f[5] C1o.f[6] C1o.f[7] C1o.f[8] C1o.f[9] C1o.f[10] C1o.f[11] C1o.f[12] C1o.f[13] C1o.f[14] C1o.f[15] C1o.f[16] C1o.f[17] C1o.f[18] C1o.f[19] C1o.f[20] C1o.f[21] C1o.f[22] C1o.f[23] C1o.f[24] C1o.f[25] C1o.f[26] C1o.f[27] C1o.f[28] C1o.f[29] C1o.f[30] C1o.f[31] C1o.a C2o.t[0] C2o.t[1] C2o.t[2] C2o.t[3] C2o.t[4] C2o.t[5] C2o.t[6] C2o.t[7] C2o.t[8] C2o.t[9] C2o.t[10] C2o.t[11] C2o.t[12] C2o.t[13] C2o.t[14] C2o.t[15] C2o.t[16] C2o.t[17] C2o.t[18] C2o.t[19] C2o.t[20] C2o.t[21] C2o.t[22] C2o.t[23] C2o.t[24] C2o.t[25] C2o.t[26] C2o.t[27] C2o.t[28] C2o.t[29] C2o.t[30] C2o.t[31] C2o.f[0] C2o.f[1] C2o.f[2] C2o.f[3] C2o.f[4] C2o.f[5] C2o.f[6] C2o.f[7] C2o.f[8] C2o.f[9] C2o.f[10] C2o.f[11] C2o.f[12] C2o.f[13] C2o.f[14] C2o.f[15] C2o.f[16] C2o.f[17] C2o.f[18] C2o.f[19] C2o.f[20] C2o.f[21] C2o.f[22] C2o.f[23] C2o.f[24] C2o.f[25] C2o.f[26] C2o.f[27] C2o.f[28] C2o.f[29] C2o.f[30] C2o.f[31] C2o.a C3o.t[0] C3o.t[1] C3o.t[2] C3o.t[3] C3o.t[4] C3o.t[5] C3o.t[6] C3o.t[7] C3o.t[8] C3o.t[9] C3o.t[10] C3o.t[11] C3o.t[12] C3o.t[13] C3o.t[14] C3o.t[15] C3o.t[16] C3o.t[17] C3o.t[18] C3o.t[19] C3o.t[20] C3o.t[21] C3o.t[22] C3o.t[23] C3o.t[24] C3o.t[25] C3o.t[26] C3o.t[27] C3o.t[28] C3o.t[29] C3o.t[30] C3o.t[31] C3o.f[0] C3o.f[1] C3o.f[2] C3o.f[3] C3o.f[4] C3o.f[5] C3o.f[6] C3o.f[7] C3o.f[8] C3o.f[9] C3o.f[10] C3o.f[11] C3o.f[12] C3o.f[13] C3o.f[14] C3o.f[15] C3o.f[16] C3o.f[17] C3o.f[18] C3o.f[19] C3o.f[20] C3o.f[21] C3o.f[22] C3o.f[23] C3o.f[24] C3o.f[25] C3o.f[26] C3o.f[27] C3o.f[28] C3o.f[29] C3o.f[30] C3o.f[31] C3o.a Po.t[0] Po.t[1] Po.t[2] Po.t[3] Po.t[4] Po.t[5] Po.t[6] Po.t[7] Po.t[8] Po.t[9] Po.t[10] Po.t[11] Po.t[12] Po.t[13] Po.t[14] Po.t[15] Po.t[16] Po.t[17] Po.t[18] Po.t[19] Po.t[20] Po.t[21] Po.t[22] Po.t[23] Po.t[24] Po.t[25] Po.t[26] Po.t[27] Po.t[28] Po.t[29] Po.t[30] Po.t[31] Po.f[0] Po.f[1] Po.f[2] Po.f[3] Po.f[4] Po.f[5] Po.f[6] Po.f[7] Po.f[8] Po.f[9] Po.f[10] Po.f[11] Po.f[12] Po.f[13] Po.f[14] Po.f[15] Po.f[16] Po.f[17] Po.f[18] Po.f[19] Po.f[20] Po.f[21] Po.f[22] Po.f[23] Po.f[24] Po.f[25] Po.f[26] Po.f[27] Po.f[28] Po.f[29] Po.f[30] Po.f[31] Po.a
*
.subckt Router reset C0i_at_50_6 C0i_at_51_6 C0i_at_52_6 C0i_at_53_6 C0i_at_54_6 C0i_at_55_6 C0i_at_56_6 C0i_at_57_6 C0i_at_58_6 C0i_at_59_6 C0i_at_510_6 C0i_at_511_6 C0i_at_512_6 C0i_at_513_6 C0i_at_514_6 C0i_at_515_6 C0i_at_516_6 C0i_at_517_6 C0i_at_518_6 C0i_at_519_6 C0i_at_520_6 C0i_at_521_6 C0i_at_522_6 C0i_at_523_6 C0i_at_524_6 C0i_at_525_6 C0i_at_526_6 C0i_at_527_6 C0i_at_528_6 C0i_at_529_6 C0i_at_530_6 C0i_at_531_6 C0i_af_50_6 C0i_af_51_6 C0i_af_52_6 C0i_af_53_6 C0i_af_54_6 C0i_af_55_6 C0i_af_56_6 C0i_af_57_6 C0i_af_58_6 C0i_af_59_6 C0i_af_510_6 C0i_af_511_6 C0i_af_512_6 C0i_af_513_6 C0i_af_514_6 C0i_af_515_6 C0i_af_516_6 C0i_af_517_6 C0i_af_518_6 C0i_af_519_6 C0i_af_520_6 C0i_af_521_6 C0i_af_522_6 C0i_af_523_6 C0i_af_524_6 C0i_af_525_6 C0i_af_526_6 C0i_af_527_6 C0i_af_528_6 C0i_af_529_6 C0i_af_530_6 C0i_af_531_6 C0i_aa C1i_at_50_6 C1i_at_51_6 C1i_at_52_6 C1i_at_53_6 C1i_at_54_6 C1i_at_55_6 C1i_at_56_6 C1i_at_57_6 C1i_at_58_6 C1i_at_59_6 C1i_at_510_6 C1i_at_511_6 C1i_at_512_6 C1i_at_513_6 C1i_at_514_6 C1i_at_515_6 C1i_at_516_6 C1i_at_517_6 C1i_at_518_6 C1i_at_519_6 C1i_at_520_6 C1i_at_521_6 C1i_at_522_6 C1i_at_523_6 C1i_at_524_6 C1i_at_525_6 C1i_at_526_6 C1i_at_527_6 C1i_at_528_6 C1i_at_529_6 C1i_at_530_6 C1i_at_531_6 C1i_af_50_6 C1i_af_51_6 C1i_af_52_6 C1i_af_53_6 C1i_af_54_6 C1i_af_55_6 C1i_af_56_6 C1i_af_57_6 C1i_af_58_6 C1i_af_59_6 C1i_af_510_6 C1i_af_511_6 C1i_af_512_6 C1i_af_513_6 C1i_af_514_6 C1i_af_515_6 C1i_af_516_6 C1i_af_517_6 C1i_af_518_6 C1i_af_519_6 C1i_af_520_6 C1i_af_521_6 C1i_af_522_6 C1i_af_523_6 C1i_af_524_6 C1i_af_525_6 C1i_af_526_6 C1i_af_527_6 C1i_af_528_6 C1i_af_529_6 C1i_af_530_6 C1i_af_531_6 C1i_aa C2i_at_50_6 C2i_at_51_6 C2i_at_52_6 C2i_at_53_6 C2i_at_54_6 C2i_at_55_6 C2i_at_56_6 C2i_at_57_6 C2i_at_58_6 C2i_at_59_6 C2i_at_510_6 C2i_at_511_6 C2i_at_512_6 C2i_at_513_6 C2i_at_514_6 C2i_at_515_6 C2i_at_516_6 C2i_at_517_6 C2i_at_518_6 C2i_at_519_6 C2i_at_520_6 C2i_at_521_6 C2i_at_522_6 C2i_at_523_6 C2i_at_524_6 C2i_at_525_6 C2i_at_526_6 C2i_at_527_6 C2i_at_528_6 C2i_at_529_6 C2i_at_530_6 C2i_at_531_6 C2i_af_50_6 C2i_af_51_6 C2i_af_52_6 C2i_af_53_6 C2i_af_54_6 C2i_af_55_6 C2i_af_56_6 C2i_af_57_6 C2i_af_58_6 C2i_af_59_6 C2i_af_510_6 C2i_af_511_6 C2i_af_512_6 C2i_af_513_6 C2i_af_514_6 C2i_af_515_6 C2i_af_516_6 C2i_af_517_6 C2i_af_518_6 C2i_af_519_6 C2i_af_520_6 C2i_af_521_6 C2i_af_522_6 C2i_af_523_6 C2i_af_524_6 C2i_af_525_6 C2i_af_526_6 C2i_af_527_6 C2i_af_528_6 C2i_af_529_6 C2i_af_530_6 C2i_af_531_6 C2i_aa C3i_at_50_6 C3i_at_51_6 C3i_at_52_6 C3i_at_53_6 C3i_at_54_6 C3i_at_55_6 C3i_at_56_6 C3i_at_57_6 C3i_at_58_6 C3i_at_59_6 C3i_at_510_6 C3i_at_511_6 C3i_at_512_6 C3i_at_513_6 C3i_at_514_6 C3i_at_515_6 C3i_at_516_6 C3i_at_517_6 C3i_at_518_6 C3i_at_519_6 C3i_at_520_6 C3i_at_521_6 C3i_at_522_6 C3i_at_523_6 C3i_at_524_6 C3i_at_525_6 C3i_at_526_6 C3i_at_527_6 C3i_at_528_6 C3i_at_529_6 C3i_at_530_6 C3i_at_531_6 C3i_af_50_6 C3i_af_51_6 C3i_af_52_6 C3i_af_53_6 C3i_af_54_6 C3i_af_55_6 C3i_af_56_6 C3i_af_57_6 C3i_af_58_6 C3i_af_59_6 C3i_af_510_6 C3i_af_511_6 C3i_af_512_6 C3i_af_513_6 C3i_af_514_6 C3i_af_515_6 C3i_af_516_6 C3i_af_517_6 C3i_af_518_6 C3i_af_519_6 C3i_af_520_6 C3i_af_521_6 C3i_af_522_6 C3i_af_523_6 C3i_af_524_6 C3i_af_525_6 C3i_af_526_6 C3i_af_527_6 C3i_af_528_6 C3i_af_529_6 C3i_af_530_6 C3i_af_531_6 C3i_aa Pi_at_50_6 Pi_at_51_6 Pi_at_52_6 Pi_at_53_6 Pi_at_54_6 Pi_at_55_6 Pi_at_56_6 Pi_at_57_6 Pi_at_58_6 Pi_at_59_6 Pi_at_510_6 Pi_at_511_6 Pi_at_512_6 Pi_at_513_6 Pi_at_514_6 Pi_at_515_6 Pi_at_516_6 Pi_at_517_6 Pi_at_518_6 Pi_at_519_6 Pi_at_520_6 Pi_at_521_6 Pi_at_522_6 Pi_at_523_6 Pi_at_524_6 Pi_at_525_6 Pi_at_526_6 Pi_at_527_6 Pi_at_528_6 Pi_at_529_6 Pi_at_530_6 Pi_at_531_6 Pi_af_50_6 Pi_af_51_6 Pi_af_52_6 Pi_af_53_6 Pi_af_54_6 Pi_af_55_6 Pi_af_56_6 Pi_af_57_6 Pi_af_58_6 Pi_af_59_6 Pi_af_510_6 Pi_af_511_6 Pi_af_512_6 Pi_af_513_6 Pi_af_514_6 Pi_af_515_6 Pi_af_516_6 Pi_af_517_6 Pi_af_518_6 Pi_af_519_6 Pi_af_520_6 Pi_af_521_6 Pi_af_522_6 Pi_af_523_6 Pi_af_524_6 Pi_af_525_6 Pi_af_526_6 Pi_af_527_6 Pi_af_528_6 Pi_af_529_6 Pi_af_530_6 Pi_af_531_6 Pi_aa C0o_at_50_6 C0o_at_51_6 C0o_at_52_6 C0o_at_53_6 C0o_at_54_6 C0o_at_55_6 C0o_at_56_6 C0o_at_57_6 C0o_at_58_6 C0o_at_59_6 C0o_at_510_6 C0o_at_511_6 C0o_at_512_6 C0o_at_513_6 C0o_at_514_6 C0o_at_515_6 C0o_at_516_6 C0o_at_517_6 C0o_at_518_6 C0o_at_519_6 C0o_at_520_6 C0o_at_521_6 C0o_at_522_6 C0o_at_523_6 C0o_at_524_6 C0o_at_525_6 C0o_at_526_6 C0o_at_527_6 C0o_at_528_6 C0o_at_529_6 C0o_at_530_6 C0o_at_531_6 C0o_af_50_6 C0o_af_51_6 C0o_af_52_6 C0o_af_53_6 C0o_af_54_6 C0o_af_55_6 C0o_af_56_6 C0o_af_57_6 C0o_af_58_6 C0o_af_59_6 C0o_af_510_6 C0o_af_511_6 C0o_af_512_6 C0o_af_513_6 C0o_af_514_6 C0o_af_515_6 C0o_af_516_6 C0o_af_517_6 C0o_af_518_6 C0o_af_519_6 C0o_af_520_6 C0o_af_521_6 C0o_af_522_6 C0o_af_523_6 C0o_af_524_6 C0o_af_525_6 C0o_af_526_6 C0o_af_527_6 C0o_af_528_6 C0o_af_529_6 C0o_af_530_6 C0o_af_531_6 C0o_aa C1o_at_50_6 C1o_at_51_6 C1o_at_52_6 C1o_at_53_6 C1o_at_54_6 C1o_at_55_6 C1o_at_56_6 C1o_at_57_6 C1o_at_58_6 C1o_at_59_6 C1o_at_510_6 C1o_at_511_6 C1o_at_512_6 C1o_at_513_6 C1o_at_514_6 C1o_at_515_6 C1o_at_516_6 C1o_at_517_6 C1o_at_518_6 C1o_at_519_6 C1o_at_520_6 C1o_at_521_6 C1o_at_522_6 C1o_at_523_6 C1o_at_524_6 C1o_at_525_6 C1o_at_526_6 C1o_at_527_6 C1o_at_528_6 C1o_at_529_6 C1o_at_530_6 C1o_at_531_6 C1o_af_50_6 C1o_af_51_6 C1o_af_52_6 C1o_af_53_6 C1o_af_54_6 C1o_af_55_6 C1o_af_56_6 C1o_af_57_6 C1o_af_58_6 C1o_af_59_6 C1o_af_510_6 C1o_af_511_6 C1o_af_512_6 C1o_af_513_6 C1o_af_514_6 C1o_af_515_6 C1o_af_516_6 C1o_af_517_6 C1o_af_518_6 C1o_af_519_6 C1o_af_520_6 C1o_af_521_6 C1o_af_522_6 C1o_af_523_6 C1o_af_524_6 C1o_af_525_6 C1o_af_526_6 C1o_af_527_6 C1o_af_528_6 C1o_af_529_6 C1o_af_530_6 C1o_af_531_6 C1o_aa C2o_at_50_6 C2o_at_51_6 C2o_at_52_6 C2o_at_53_6 C2o_at_54_6 C2o_at_55_6 C2o_at_56_6 C2o_at_57_6 C2o_at_58_6 C2o_at_59_6 C2o_at_510_6 C2o_at_511_6 C2o_at_512_6 C2o_at_513_6 C2o_at_514_6 C2o_at_515_6 C2o_at_516_6 C2o_at_517_6 C2o_at_518_6 C2o_at_519_6 C2o_at_520_6 C2o_at_521_6 C2o_at_522_6 C2o_at_523_6 C2o_at_524_6 C2o_at_525_6 C2o_at_526_6 C2o_at_527_6 C2o_at_528_6 C2o_at_529_6 C2o_at_530_6 C2o_at_531_6 C2o_af_50_6 C2o_af_51_6 C2o_af_52_6 C2o_af_53_6 C2o_af_54_6 C2o_af_55_6 C2o_af_56_6 C2o_af_57_6 C2o_af_58_6 C2o_af_59_6 C2o_af_510_6 C2o_af_511_6 C2o_af_512_6 C2o_af_513_6 C2o_af_514_6 C2o_af_515_6 C2o_af_516_6 C2o_af_517_6 C2o_af_518_6 C2o_af_519_6 C2o_af_520_6 C2o_af_521_6 C2o_af_522_6 C2o_af_523_6 C2o_af_524_6 C2o_af_525_6 C2o_af_526_6 C2o_af_527_6 C2o_af_528_6 C2o_af_529_6 C2o_af_530_6 C2o_af_531_6 C2o_aa C3o_at_50_6 C3o_at_51_6 C3o_at_52_6 C3o_at_53_6 C3o_at_54_6 C3o_at_55_6 C3o_at_56_6 C3o_at_57_6 C3o_at_58_6 C3o_at_59_6 C3o_at_510_6 C3o_at_511_6 C3o_at_512_6 C3o_at_513_6 C3o_at_514_6 C3o_at_515_6 C3o_at_516_6 C3o_at_517_6 C3o_at_518_6 C3o_at_519_6 C3o_at_520_6 C3o_at_521_6 C3o_at_522_6 C3o_at_523_6 C3o_at_524_6 C3o_at_525_6 C3o_at_526_6 C3o_at_527_6 C3o_at_528_6 C3o_at_529_6 C3o_at_530_6 C3o_at_531_6 C3o_af_50_6 C3o_af_51_6 C3o_af_52_6 C3o_af_53_6 C3o_af_54_6 C3o_af_55_6 C3o_af_56_6 C3o_af_57_6 C3o_af_58_6 C3o_af_59_6 C3o_af_510_6 C3o_af_511_6 C3o_af_512_6 C3o_af_513_6 C3o_af_514_6 C3o_af_515_6 C3o_af_516_6 C3o_af_517_6 C3o_af_518_6 C3o_af_519_6 C3o_af_520_6 C3o_af_521_6 C3o_af_522_6 C3o_af_523_6 C3o_af_524_6 C3o_af_525_6 C3o_af_526_6 C3o_af_527_6 C3o_af_528_6 C3o_af_529_6 C3o_af_530_6 C3o_af_531_6 C3o_aa Po_at_50_6 Po_at_51_6 Po_at_52_6 Po_at_53_6 Po_at_54_6 Po_at_55_6 Po_at_56_6 Po_at_57_6 Po_at_58_6 Po_at_59_6 Po_at_510_6 Po_at_511_6 Po_at_512_6 Po_at_513_6 Po_at_514_6 Po_at_515_6 Po_at_516_6 Po_at_517_6 Po_at_518_6 Po_at_519_6 Po_at_520_6 Po_at_521_6 Po_at_522_6 Po_at_523_6 Po_at_524_6 Po_at_525_6 Po_at_526_6 Po_at_527_6 Po_at_528_6 Po_at_529_6 Po_at_530_6 Po_at_531_6 Po_af_50_6 Po_af_51_6 Po_af_52_6 Po_af_53_6 Po_af_54_6 Po_af_55_6 Po_af_56_6 Po_af_57_6 Po_af_58_6 Po_af_59_6 Po_af_510_6 Po_af_511_6 Po_af_512_6 Po_af_513_6 Po_af_514_6 Po_af_515_6 Po_af_516_6 Po_af_517_6 Po_af_518_6 Po_af_519_6 Po_af_520_6 Po_af_521_6 Po_af_522_6 Po_af_523_6 Po_af_524_6 Po_af_525_6 Po_af_526_6 Po_af_527_6 Po_af_528_6 Po_af_529_6 Po_af_530_6 Po_af_531_6 Po_aa
*.PININFO reset:I C0i_at_50_6:I C0i_at_51_6:I C0i_at_52_6:I C0i_at_53_6:I C0i_at_54_6:I C0i_at_55_6:I C0i_at_56_6:I C0i_at_57_6:I C0i_at_58_6:I C0i_at_59_6:I C0i_at_510_6:I C0i_at_511_6:I C0i_at_512_6:I C0i_at_513_6:I C0i_at_514_6:I C0i_at_515_6:I C0i_at_516_6:I C0i_at_517_6:I C0i_at_518_6:I C0i_at_519_6:I C0i_at_520_6:I C0i_at_521_6:I C0i_at_522_6:I C0i_at_523_6:I C0i_at_524_6:I C0i_at_525_6:I C0i_at_526_6:I C0i_at_527_6:I C0i_at_528_6:I C0i_at_529_6:I C0i_at_530_6:I C0i_at_531_6:I C0i_af_50_6:I C0i_af_51_6:I C0i_af_52_6:I C0i_af_53_6:I C0i_af_54_6:I C0i_af_55_6:I C0i_af_56_6:I C0i_af_57_6:I C0i_af_58_6:I C0i_af_59_6:I C0i_af_510_6:I C0i_af_511_6:I C0i_af_512_6:I C0i_af_513_6:I C0i_af_514_6:I C0i_af_515_6:I C0i_af_516_6:I C0i_af_517_6:I C0i_af_518_6:I C0i_af_519_6:I C0i_af_520_6:I C0i_af_521_6:I C0i_af_522_6:I C0i_af_523_6:I C0i_af_524_6:I C0i_af_525_6:I C0i_af_526_6:I C0i_af_527_6:I C0i_af_528_6:I C0i_af_529_6:I C0i_af_530_6:I C0i_af_531_6:I C0i_aa:O C1i_at_50_6:I C1i_at_51_6:I C1i_at_52_6:I C1i_at_53_6:I C1i_at_54_6:I C1i_at_55_6:I C1i_at_56_6:I C1i_at_57_6:I C1i_at_58_6:I C1i_at_59_6:I C1i_at_510_6:I C1i_at_511_6:I C1i_at_512_6:I C1i_at_513_6:I C1i_at_514_6:I C1i_at_515_6:I C1i_at_516_6:I C1i_at_517_6:I C1i_at_518_6:I C1i_at_519_6:I C1i_at_520_6:I C1i_at_521_6:I C1i_at_522_6:I C1i_at_523_6:I C1i_at_524_6:I C1i_at_525_6:I C1i_at_526_6:I C1i_at_527_6:I C1i_at_528_6:I C1i_at_529_6:I C1i_at_530_6:I C1i_at_531_6:I C1i_af_50_6:I C1i_af_51_6:I C1i_af_52_6:I C1i_af_53_6:I C1i_af_54_6:I C1i_af_55_6:I C1i_af_56_6:I C1i_af_57_6:I C1i_af_58_6:I C1i_af_59_6:I C1i_af_510_6:I C1i_af_511_6:I C1i_af_512_6:I C1i_af_513_6:I C1i_af_514_6:I C1i_af_515_6:I C1i_af_516_6:I C1i_af_517_6:I C1i_af_518_6:I C1i_af_519_6:I C1i_af_520_6:I C1i_af_521_6:I C1i_af_522_6:I C1i_af_523_6:I C1i_af_524_6:I C1i_af_525_6:I C1i_af_526_6:I C1i_af_527_6:I C1i_af_528_6:I C1i_af_529_6:I C1i_af_530_6:I C1i_af_531_6:I C1i_aa:O C2i_at_50_6:I C2i_at_51_6:I C2i_at_52_6:I C2i_at_53_6:I C2i_at_54_6:I C2i_at_55_6:I C2i_at_56_6:I C2i_at_57_6:I C2i_at_58_6:I C2i_at_59_6:I C2i_at_510_6:I C2i_at_511_6:I C2i_at_512_6:I C2i_at_513_6:I C2i_at_514_6:I C2i_at_515_6:I C2i_at_516_6:I C2i_at_517_6:I C2i_at_518_6:I C2i_at_519_6:I C2i_at_520_6:I C2i_at_521_6:I C2i_at_522_6:I C2i_at_523_6:I C2i_at_524_6:I C2i_at_525_6:I C2i_at_526_6:I C2i_at_527_6:I C2i_at_528_6:I C2i_at_529_6:I C2i_at_530_6:I C2i_at_531_6:I C2i_af_50_6:I C2i_af_51_6:I C2i_af_52_6:I C2i_af_53_6:I C2i_af_54_6:I C2i_af_55_6:I C2i_af_56_6:I C2i_af_57_6:I C2i_af_58_6:I C2i_af_59_6:I C2i_af_510_6:I C2i_af_511_6:I C2i_af_512_6:I C2i_af_513_6:I C2i_af_514_6:I C2i_af_515_6:I C2i_af_516_6:I C2i_af_517_6:I C2i_af_518_6:I C2i_af_519_6:I C2i_af_520_6:I C2i_af_521_6:I C2i_af_522_6:I C2i_af_523_6:I C2i_af_524_6:I C2i_af_525_6:I C2i_af_526_6:I C2i_af_527_6:I C2i_af_528_6:I C2i_af_529_6:I C2i_af_530_6:I C2i_af_531_6:I C2i_aa:O C3i_at_50_6:I C3i_at_51_6:I C3i_at_52_6:I C3i_at_53_6:I C3i_at_54_6:I C3i_at_55_6:I C3i_at_56_6:I C3i_at_57_6:I C3i_at_58_6:I C3i_at_59_6:I C3i_at_510_6:I C3i_at_511_6:I C3i_at_512_6:I C3i_at_513_6:I C3i_at_514_6:I C3i_at_515_6:I C3i_at_516_6:I C3i_at_517_6:I C3i_at_518_6:I C3i_at_519_6:I C3i_at_520_6:I C3i_at_521_6:I C3i_at_522_6:I C3i_at_523_6:I C3i_at_524_6:I C3i_at_525_6:I C3i_at_526_6:I C3i_at_527_6:I C3i_at_528_6:I C3i_at_529_6:I C3i_at_530_6:I C3i_at_531_6:I C3i_af_50_6:I C3i_af_51_6:I C3i_af_52_6:I C3i_af_53_6:I C3i_af_54_6:I C3i_af_55_6:I C3i_af_56_6:I C3i_af_57_6:I C3i_af_58_6:I C3i_af_59_6:I C3i_af_510_6:I C3i_af_511_6:I C3i_af_512_6:I C3i_af_513_6:I C3i_af_514_6:I C3i_af_515_6:I C3i_af_516_6:I C3i_af_517_6:I C3i_af_518_6:I C3i_af_519_6:I C3i_af_520_6:I C3i_af_521_6:I C3i_af_522_6:I C3i_af_523_6:I C3i_af_524_6:I C3i_af_525_6:I C3i_af_526_6:I C3i_af_527_6:I C3i_af_528_6:I C3i_af_529_6:I C3i_af_530_6:I C3i_af_531_6:I C3i_aa:O Pi_at_50_6:I Pi_at_51_6:I Pi_at_52_6:I Pi_at_53_6:I Pi_at_54_6:I Pi_at_55_6:I Pi_at_56_6:I Pi_at_57_6:I Pi_at_58_6:I Pi_at_59_6:I Pi_at_510_6:I Pi_at_511_6:I Pi_at_512_6:I Pi_at_513_6:I Pi_at_514_6:I Pi_at_515_6:I Pi_at_516_6:I Pi_at_517_6:I Pi_at_518_6:I Pi_at_519_6:I Pi_at_520_6:I Pi_at_521_6:I Pi_at_522_6:I Pi_at_523_6:I Pi_at_524_6:I Pi_at_525_6:I Pi_at_526_6:I Pi_at_527_6:I Pi_at_528_6:I Pi_at_529_6:I Pi_at_530_6:I Pi_at_531_6:I Pi_af_50_6:I Pi_af_51_6:I Pi_af_52_6:I Pi_af_53_6:I Pi_af_54_6:I Pi_af_55_6:I Pi_af_56_6:I Pi_af_57_6:I Pi_af_58_6:I Pi_af_59_6:I Pi_af_510_6:I Pi_af_511_6:I Pi_af_512_6:I Pi_af_513_6:I Pi_af_514_6:I Pi_af_515_6:I Pi_af_516_6:I Pi_af_517_6:I Pi_af_518_6:I Pi_af_519_6:I Pi_af_520_6:I Pi_af_521_6:I Pi_af_522_6:I Pi_af_523_6:I Pi_af_524_6:I Pi_af_525_6:I Pi_af_526_6:I Pi_af_527_6:I Pi_af_528_6:I Pi_af_529_6:I Pi_af_530_6:I Pi_af_531_6:I Pi_aa:O C0o_at_50_6:O C0o_at_51_6:O C0o_at_52_6:O C0o_at_53_6:O C0o_at_54_6:O C0o_at_55_6:O C0o_at_56_6:O C0o_at_57_6:O C0o_at_58_6:O C0o_at_59_6:O C0o_at_510_6:O C0o_at_511_6:O C0o_at_512_6:O C0o_at_513_6:O C0o_at_514_6:O C0o_at_515_6:O C0o_at_516_6:O C0o_at_517_6:O C0o_at_518_6:O C0o_at_519_6:O C0o_at_520_6:O C0o_at_521_6:O C0o_at_522_6:O C0o_at_523_6:O C0o_at_524_6:O C0o_at_525_6:O C0o_at_526_6:O C0o_at_527_6:O C0o_at_528_6:O C0o_at_529_6:O C0o_at_530_6:O C0o_at_531_6:O C0o_af_50_6:O C0o_af_51_6:O C0o_af_52_6:O C0o_af_53_6:O C0o_af_54_6:O C0o_af_55_6:O C0o_af_56_6:O C0o_af_57_6:O C0o_af_58_6:O C0o_af_59_6:O C0o_af_510_6:O C0o_af_511_6:O C0o_af_512_6:O C0o_af_513_6:O C0o_af_514_6:O C0o_af_515_6:O C0o_af_516_6:O C0o_af_517_6:O C0o_af_518_6:O C0o_af_519_6:O C0o_af_520_6:O C0o_af_521_6:O C0o_af_522_6:O C0o_af_523_6:O C0o_af_524_6:O C0o_af_525_6:O C0o_af_526_6:O C0o_af_527_6:O C0o_af_528_6:O C0o_af_529_6:O C0o_af_530_6:O C0o_af_531_6:O C0o_aa:I C1o_at_50_6:O C1o_at_51_6:O C1o_at_52_6:O C1o_at_53_6:O C1o_at_54_6:O C1o_at_55_6:O C1o_at_56_6:O C1o_at_57_6:O C1o_at_58_6:O C1o_at_59_6:O C1o_at_510_6:O C1o_at_511_6:O C1o_at_512_6:O C1o_at_513_6:O C1o_at_514_6:O C1o_at_515_6:O C1o_at_516_6:O C1o_at_517_6:O C1o_at_518_6:O C1o_at_519_6:O C1o_at_520_6:O C1o_at_521_6:O C1o_at_522_6:O C1o_at_523_6:O C1o_at_524_6:O C1o_at_525_6:O C1o_at_526_6:O C1o_at_527_6:O C1o_at_528_6:O C1o_at_529_6:O C1o_at_530_6:O C1o_at_531_6:O C1o_af_50_6:O C1o_af_51_6:O C1o_af_52_6:O C1o_af_53_6:O C1o_af_54_6:O C1o_af_55_6:O C1o_af_56_6:O C1o_af_57_6:O C1o_af_58_6:O C1o_af_59_6:O C1o_af_510_6:O C1o_af_511_6:O C1o_af_512_6:O C1o_af_513_6:O C1o_af_514_6:O C1o_af_515_6:O C1o_af_516_6:O C1o_af_517_6:O C1o_af_518_6:O C1o_af_519_6:O C1o_af_520_6:O C1o_af_521_6:O C1o_af_522_6:O C1o_af_523_6:O C1o_af_524_6:O C1o_af_525_6:O C1o_af_526_6:O C1o_af_527_6:O C1o_af_528_6:O C1o_af_529_6:O C1o_af_530_6:O C1o_af_531_6:O C1o_aa:I C2o_at_50_6:O C2o_at_51_6:O C2o_at_52_6:O C2o_at_53_6:O C2o_at_54_6:O C2o_at_55_6:O C2o_at_56_6:O C2o_at_57_6:O C2o_at_58_6:O C2o_at_59_6:O C2o_at_510_6:O C2o_at_511_6:O C2o_at_512_6:O C2o_at_513_6:O C2o_at_514_6:O C2o_at_515_6:O C2o_at_516_6:O C2o_at_517_6:O C2o_at_518_6:O C2o_at_519_6:O C2o_at_520_6:O C2o_at_521_6:O C2o_at_522_6:O C2o_at_523_6:O C2o_at_524_6:O C2o_at_525_6:O C2o_at_526_6:O C2o_at_527_6:O C2o_at_528_6:O C2o_at_529_6:O C2o_at_530_6:O C2o_at_531_6:O C2o_af_50_6:O C2o_af_51_6:O C2o_af_52_6:O C2o_af_53_6:O C2o_af_54_6:O C2o_af_55_6:O C2o_af_56_6:O C2o_af_57_6:O C2o_af_58_6:O C2o_af_59_6:O C2o_af_510_6:O C2o_af_511_6:O C2o_af_512_6:O C2o_af_513_6:O C2o_af_514_6:O C2o_af_515_6:O C2o_af_516_6:O C2o_af_517_6:O C2o_af_518_6:O C2o_af_519_6:O C2o_af_520_6:O C2o_af_521_6:O C2o_af_522_6:O C2o_af_523_6:O C2o_af_524_6:O C2o_af_525_6:O C2o_af_526_6:O C2o_af_527_6:O C2o_af_528_6:O C2o_af_529_6:O C2o_af_530_6:O C2o_af_531_6:O C2o_aa:I C3o_at_50_6:O C3o_at_51_6:O C3o_at_52_6:O C3o_at_53_6:O C3o_at_54_6:O C3o_at_55_6:O C3o_at_56_6:O C3o_at_57_6:O C3o_at_58_6:O C3o_at_59_6:O C3o_at_510_6:O C3o_at_511_6:O C3o_at_512_6:O C3o_at_513_6:O C3o_at_514_6:O C3o_at_515_6:O C3o_at_516_6:O C3o_at_517_6:O C3o_at_518_6:O C3o_at_519_6:O C3o_at_520_6:O C3o_at_521_6:O C3o_at_522_6:O C3o_at_523_6:O C3o_at_524_6:O C3o_at_525_6:O C3o_at_526_6:O C3o_at_527_6:O C3o_at_528_6:O C3o_at_529_6:O C3o_at_530_6:O C3o_at_531_6:O C3o_af_50_6:O C3o_af_51_6:O C3o_af_52_6:O C3o_af_53_6:O C3o_af_54_6:O C3o_af_55_6:O C3o_af_56_6:O C3o_af_57_6:O C3o_af_58_6:O C3o_af_59_6:O C3o_af_510_6:O C3o_af_511_6:O C3o_af_512_6:O C3o_af_513_6:O C3o_af_514_6:O C3o_af_515_6:O C3o_af_516_6:O C3o_af_517_6:O C3o_af_518_6:O C3o_af_519_6:O C3o_af_520_6:O C3o_af_521_6:O C3o_af_522_6:O C3o_af_523_6:O C3o_af_524_6:O C3o_af_525_6:O C3o_af_526_6:O C3o_af_527_6:O C3o_af_528_6:O C3o_af_529_6:O C3o_af_530_6:O C3o_af_531_6:O C3o_aa:I Po_at_50_6:O Po_at_51_6:O Po_at_52_6:O Po_at_53_6:O Po_at_54_6:O Po_at_55_6:O Po_at_56_6:O Po_at_57_6:O Po_at_58_6:O Po_at_59_6:O Po_at_510_6:O Po_at_511_6:O Po_at_512_6:O Po_at_513_6:O Po_at_514_6:O Po_at_515_6:O Po_at_516_6:O Po_at_517_6:O Po_at_518_6:O Po_at_519_6:O Po_at_520_6:O Po_at_521_6:O Po_at_522_6:O Po_at_523_6:O Po_at_524_6:O Po_at_525_6:O Po_at_526_6:O Po_at_527_6:O Po_at_528_6:O Po_at_529_6:O Po_at_530_6:O Po_at_531_6:O Po_af_50_6:O Po_af_51_6:O Po_af_52_6:O Po_af_53_6:O Po_af_54_6:O Po_af_55_6:O Po_af_56_6:O Po_af_57_6:O Po_af_58_6:O Po_af_59_6:O Po_af_510_6:O Po_af_511_6:O Po_af_512_6:O Po_af_513_6:O Po_af_514_6:O Po_af_515_6:O Po_af_516_6:O Po_af_517_6:O Po_af_518_6:O Po_af_519_6:O Po_af_520_6:O Po_af_521_6:O Po_af_522_6:O Po_af_523_6:O Po_af_524_6:O Po_af_525_6:O Po_af_526_6:O Po_af_527_6:O Po_af_528_6:O Po_af_529_6:O Po_af_530_6:O Po_af_531_6:O Po_aa:I
*.POWER VDD Vdd
*.POWER GND GND
*.POWER NSUB GND
*.POWER PSUB Vdd
*
* --- node flags ---
*
* ARM_aM_at_50_6 (combinational)
* ARM_aM_af_50_6 (combinational)
* ARM_aM_at_51_6 (combinational)
* ARM_aM_af_51_6 (combinational)
* ARM_aM_at_52_6 (combinational)
* ARM_aM_af_52_6 (combinational)
* ARM_aM_at_53_6 (combinational)
* ARM_aM_af_53_6 (combinational)
* ARM_aM_at_54_6 (combinational)
* ARM_aM_af_54_6 (combinational)
* ARM_aM_at_55_6 (combinational)
* ARM_aM_af_55_6 (combinational)
* ARM_aM_at_56_6 (combinational)
* ARM_aM_af_56_6 (combinational)
* ARM_aM_at_57_6 (combinational)
* ARM_aM_af_57_6 (combinational)
* ARM_aM_at_58_6 (combinational)
* ARM_aM_af_58_6 (combinational)
* ARM_aM_at_59_6 (combinational)
* ARM_aM_af_59_6 (combinational)
* ARM_aM_at_510_6 (combinational)
* ARM_aM_af_510_6 (combinational)
* ARM_aM_at_511_6 (combinational)
* ARM_aM_af_511_6 (combinational)
* ARM_aM_at_512_6 (combinational)
* ARM_aM_af_512_6 (combinational)
* ARM_aM_at_513_6 (combinational)
* ARM_aM_af_513_6 (combinational)
* ARM_aM_at_514_6 (combinational)
* ARM_aM_af_514_6 (combinational)
* ARM_aM_at_515_6 (combinational)
* ARM_aM_af_515_6 (combinational)
* ARM_aM_at_516_6 (combinational)
* ARM_aM_af_516_6 (combinational)
* ARM_aM_at_517_6 (combinational)
* ARM_aM_af_517_6 (combinational)
* ARM_aM_at_518_6 (combinational)
* ARM_aM_af_518_6 (combinational)
* ARM_aM_at_519_6 (combinational)
* ARM_aM_af_519_6 (combinational)
* ARM_aM_at_520_6 (combinational)
* ARM_aM_af_520_6 (combinational)
* ARM_aM_at_521_6 (combinational)
* ARM_aM_af_521_6 (combinational)
* ARM_aM_at_522_6 (combinational)
* ARM_aM_af_522_6 (combinational)
* ARM_aM_at_523_6 (combinational)
* ARM_aM_af_523_6 (combinational)
* ARM_aM_at_524_6 (combinational)
* ARM_aM_af_524_6 (combinational)
* ARM_aM_at_525_6 (combinational)
* ARM_aM_af_525_6 (combinational)
* ARM_aM_at_526_6 (combinational)
* ARM_aM_af_526_6 (combinational)
* ARM_aM_at_527_6 (combinational)
* ARM_aM_af_527_6 (combinational)
* ARM_aM_at_528_6 (combinational)
* ARM_aM_af_528_6 (combinational)
* ARM_aM_at_529_6 (combinational)
* ARM_aM_af_529_6 (combinational)
* ARM_aM_at_530_6 (combinational)
* ARM_aM_af_530_6 (combinational)
* ARM_aM_at_531_6 (combinational)
* ARM_aM_af_531_6 (combinational)
* ARP_aP_at_50_6 (combinational)
* ARP_aP_af_50_6 (combinational)
* ARP_aP_at_51_6 (combinational)
* ARP_aP_af_51_6 (combinational)
* ARP_aP_at_52_6 (combinational)
* ARP_aP_af_52_6 (combinational)
* ARP_aP_at_53_6 (combinational)
* ARP_aP_af_53_6 (combinational)
* ARP_aP_at_54_6 (combinational)
* ARP_aP_af_54_6 (combinational)
* ARP_aP_at_55_6 (combinational)
* ARP_aP_af_55_6 (combinational)
* ARP_aP_at_56_6 (combinational)
* ARP_aP_af_56_6 (combinational)
* ARP_aP_at_57_6 (combinational)
* ARP_aP_af_57_6 (combinational)
* ARP_aP_at_58_6 (combinational)
* ARP_aP_af_58_6 (combinational)
* ARP_aP_at_59_6 (combinational)
* ARP_aP_af_59_6 (combinational)
* ARP_aP_at_510_6 (combinational)
* ARP_aP_af_510_6 (combinational)
* ARP_aP_at_511_6 (combinational)
* ARP_aP_af_511_6 (combinational)
* ARP_aP_at_512_6 (combinational)
* ARP_aP_af_512_6 (combinational)
* ARP_aP_at_513_6 (combinational)
* ARP_aP_af_513_6 (combinational)
* ARP_aP_at_514_6 (combinational)
* ARP_aP_af_514_6 (combinational)
* ARP_aP_at_515_6 (combinational)
* ARP_aP_af_515_6 (combinational)
* ARP_aP_at_516_6 (combinational)
* ARP_aP_af_516_6 (combinational)
* ARP_aP_at_517_6 (combinational)
* ARP_aP_af_517_6 (combinational)
* ARP_aP_at_518_6 (combinational)
* ARP_aP_af_518_6 (combinational)
* ARP_aP_at_519_6 (combinational)
* ARP_aP_af_519_6 (combinational)
* ARP_aP_at_520_6 (combinational)
* ARP_aP_af_520_6 (combinational)
* ARP_aP_at_521_6 (combinational)
* ARP_aP_af_521_6 (combinational)
* ARP_aP_at_522_6 (combinational)
* ARP_aP_af_522_6 (combinational)
* ARP_aP_at_523_6 (combinational)
* ARP_aP_af_523_6 (combinational)
* ARP_aP_at_524_6 (combinational)
* ARP_aP_af_524_6 (combinational)
* ARP_aP_at_525_6 (combinational)
* ARP_aP_af_525_6 (combinational)
* ARP_aP_at_526_6 (combinational)
* ARP_aP_af_526_6 (combinational)
* ARP_aP_at_527_6 (combinational)
* ARP_aP_af_527_6 (combinational)
* ARP_aP_at_528_6 (combinational)
* ARP_aP_af_528_6 (combinational)
* ARP_aP_at_529_6 (combinational)
* ARP_aP_af_529_6 (combinational)
* ARP_aP_at_530_6 (combinational)
* ARP_aP_af_530_6 (combinational)
* ARP_aP_at_531_6 (combinational)
* ARP_aP_af_531_6 (combinational)
* ARP_aM_at_50_6 (combinational)
* ARP_aM_af_50_6 (combinational)
* ARP_aM_at_51_6 (combinational)
* ARP_aM_af_51_6 (combinational)
* ARP_aM_at_52_6 (combinational)
* ARP_aM_af_52_6 (combinational)
* ARP_aM_at_53_6 (combinational)
* ARP_aM_af_53_6 (combinational)
* ARP_aM_at_54_6 (combinational)
* ARP_aM_af_54_6 (combinational)
* ARP_aM_at_55_6 (combinational)
* ARP_aM_af_55_6 (combinational)
* ARP_aM_at_56_6 (combinational)
* ARP_aM_af_56_6 (combinational)
* ARP_aM_at_57_6 (combinational)
* ARP_aM_af_57_6 (combinational)
* ARP_aM_at_58_6 (combinational)
* ARP_aM_af_58_6 (combinational)
* ARP_aM_at_59_6 (combinational)
* ARP_aM_af_59_6 (combinational)
* ARP_aM_at_510_6 (combinational)
* ARP_aM_af_510_6 (combinational)
* ARP_aM_at_511_6 (combinational)
* ARP_aM_af_511_6 (combinational)
* ARP_aM_at_512_6 (combinational)
* ARP_aM_af_512_6 (combinational)
* ARP_aM_at_513_6 (combinational)
* ARP_aM_af_513_6 (combinational)
* ARP_aM_at_514_6 (combinational)
* ARP_aM_af_514_6 (combinational)
* ARP_aM_at_515_6 (combinational)
* ARP_aM_af_515_6 (combinational)
* ARP_aM_at_516_6 (combinational)
* ARP_aM_af_516_6 (combinational)
* ARP_aM_at_517_6 (combinational)
* ARP_aM_af_517_6 (combinational)
* ARP_aM_at_518_6 (combinational)
* ARP_aM_af_518_6 (combinational)
* ARP_aM_at_519_6 (combinational)
* ARP_aM_af_519_6 (combinational)
* ARP_aM_at_520_6 (combinational)
* ARP_aM_af_520_6 (combinational)
* ARP_aM_at_521_6 (combinational)
* ARP_aM_af_521_6 (combinational)
* ARP_aM_at_522_6 (combinational)
* ARP_aM_af_522_6 (combinational)
* ARP_aM_at_523_6 (combinational)
* ARP_aM_af_523_6 (combinational)
* ARP_aM_at_524_6 (combinational)
* ARP_aM_af_524_6 (combinational)
* ARP_aM_at_525_6 (combinational)
* ARP_aM_af_525_6 (combinational)
* ARP_aM_at_526_6 (combinational)
* ARP_aM_af_526_6 (combinational)
* ARP_aM_at_527_6 (combinational)
* ARP_aM_af_527_6 (combinational)
* ARP_aM_at_528_6 (combinational)
* ARP_aM_af_528_6 (combinational)
* ARP_aM_at_529_6 (combinational)
* ARP_aM_af_529_6 (combinational)
* ARP_aM_at_530_6 (combinational)
* ARP_aM_af_530_6 (combinational)
* ARP_aM_at_531_6 (combinational)
* ARP_aM_af_531_6 (combinational)
*
* --- end node flags ---
*
M0_ GND Vdd ARM_aM_at_50_6 GND nmos W=0.0975U L=0.065U
M1_ GND Vdd ARM_aM_af_50_6 GND nmos W=0.0975U L=0.065U
M2_ GND Vdd ARM_aM_at_51_6 GND nmos W=0.0975U L=0.065U
M3_ GND Vdd ARM_aM_af_51_6 GND nmos W=0.0975U L=0.065U
M4_ GND Vdd ARM_aM_at_52_6 GND nmos W=0.0975U L=0.065U
M5_ GND Vdd ARM_aM_af_52_6 GND nmos W=0.0975U L=0.065U
M6_ GND Vdd ARM_aM_at_53_6 GND nmos W=0.0975U L=0.065U
M7_ GND Vdd ARM_aM_af_53_6 GND nmos W=0.0975U L=0.065U
M8_ GND Vdd ARM_aM_at_54_6 GND nmos W=0.0975U L=0.065U
M9_ GND Vdd ARM_aM_af_54_6 GND nmos W=0.0975U L=0.065U
M10_ GND Vdd ARM_aM_at_55_6 GND nmos W=0.0975U L=0.065U
M11_ GND Vdd ARM_aM_af_55_6 GND nmos W=0.0975U L=0.065U
M12_ GND Vdd ARM_aM_at_56_6 GND nmos W=0.0975U L=0.065U
M13_ GND Vdd ARM_aM_af_56_6 GND nmos W=0.0975U L=0.065U
M14_ GND Vdd ARM_aM_at_57_6 GND nmos W=0.0975U L=0.065U
M15_ GND Vdd ARM_aM_af_57_6 GND nmos W=0.0975U L=0.065U
M16_ GND Vdd ARM_aM_at_58_6 GND nmos W=0.0975U L=0.065U
M17_ GND Vdd ARM_aM_af_58_6 GND nmos W=0.0975U L=0.065U
M18_ GND Vdd ARM_aM_at_59_6 GND nmos W=0.0975U L=0.065U
M19_ GND Vdd ARM_aM_af_59_6 GND nmos W=0.0975U L=0.065U
M20_ GND Vdd ARM_aM_at_510_6 GND nmos W=0.0975U L=0.065U
M21_ GND Vdd ARM_aM_af_510_6 GND nmos W=0.0975U L=0.065U
M22_ GND Vdd ARM_aM_at_511_6 GND nmos W=0.0975U L=0.065U
M23_ GND Vdd ARM_aM_af_511_6 GND nmos W=0.0975U L=0.065U
M24_ GND Vdd ARM_aM_at_512_6 GND nmos W=0.0975U L=0.065U
M25_ GND Vdd ARM_aM_af_512_6 GND nmos W=0.0975U L=0.065U
M26_ GND Vdd ARM_aM_at_513_6 GND nmos W=0.0975U L=0.065U
M27_ GND Vdd ARM_aM_af_513_6 GND nmos W=0.0975U L=0.065U
M28_ GND Vdd ARM_aM_at_514_6 GND nmos W=0.0975U L=0.065U
M29_ GND Vdd ARM_aM_af_514_6 GND nmos W=0.0975U L=0.065U
M30_ GND Vdd ARM_aM_at_515_6 GND nmos W=0.0975U L=0.065U
M31_ GND Vdd ARM_aM_af_515_6 GND nmos W=0.0975U L=0.065U
M32_ GND Vdd ARM_aM_at_516_6 GND nmos W=0.0975U L=0.065U
M33_ GND Vdd ARM_aM_af_516_6 GND nmos W=0.0975U L=0.065U
M34_ GND Vdd ARM_aM_at_517_6 GND nmos W=0.0975U L=0.065U
M35_ GND Vdd ARM_aM_af_517_6 GND nmos W=0.0975U L=0.065U
M36_ GND Vdd ARM_aM_at_518_6 GND nmos W=0.0975U L=0.065U
M37_ GND Vdd ARM_aM_af_518_6 GND nmos W=0.0975U L=0.065U
M38_ GND Vdd ARM_aM_at_519_6 GND nmos W=0.0975U L=0.065U
M39_ GND Vdd ARM_aM_af_519_6 GND nmos W=0.0975U L=0.065U
M40_ GND Vdd ARM_aM_at_520_6 GND nmos W=0.0975U L=0.065U
M41_ GND Vdd ARM_aM_af_520_6 GND nmos W=0.0975U L=0.065U
M42_ GND Vdd ARM_aM_at_521_6 GND nmos W=0.0975U L=0.065U
M43_ GND Vdd ARM_aM_af_521_6 GND nmos W=0.0975U L=0.065U
M44_ GND Vdd ARM_aM_at_522_6 GND nmos W=0.0975U L=0.065U
M45_ GND Vdd ARM_aM_af_522_6 GND nmos W=0.0975U L=0.065U
M46_ GND Vdd ARM_aM_at_523_6 GND nmos W=0.0975U L=0.065U
M47_ GND Vdd ARM_aM_af_523_6 GND nmos W=0.0975U L=0.065U
M48_ GND Vdd ARM_aM_at_524_6 GND nmos W=0.0975U L=0.065U
M49_ GND Vdd ARM_aM_af_524_6 GND nmos W=0.0975U L=0.065U
M50_ GND Vdd ARM_aM_at_525_6 GND nmos W=0.0975U L=0.065U
M51_ GND Vdd ARM_aM_af_525_6 GND nmos W=0.0975U L=0.065U
M52_ GND Vdd ARM_aM_at_526_6 GND nmos W=0.0975U L=0.065U
M53_ GND Vdd ARM_aM_af_526_6 GND nmos W=0.0975U L=0.065U
M54_ GND Vdd ARM_aM_at_527_6 GND nmos W=0.0975U L=0.065U
M55_ GND Vdd ARM_aM_af_527_6 GND nmos W=0.0975U L=0.065U
M56_ GND Vdd ARM_aM_at_528_6 GND nmos W=0.0975U L=0.065U
M57_ GND Vdd ARM_aM_af_528_6 GND nmos W=0.0975U L=0.065U
M58_ GND Vdd ARM_aM_at_529_6 GND nmos W=0.0975U L=0.065U
M59_ GND Vdd ARM_aM_af_529_6 GND nmos W=0.0975U L=0.065U
M60_ GND Vdd ARM_aM_at_530_6 GND nmos W=0.0975U L=0.065U
M61_ GND Vdd ARM_aM_af_530_6 GND nmos W=0.0975U L=0.065U
M62_ GND Vdd ARM_aM_at_531_6 GND nmos W=0.0975U L=0.065U
M63_ GND Vdd ARM_aM_af_531_6 GND nmos W=0.0975U L=0.065U
M64_ GND Vdd ARP_aP_at_50_6 GND nmos W=0.0975U L=0.065U
M65_ GND Vdd ARP_aP_af_50_6 GND nmos W=0.0975U L=0.065U
M66_ GND Vdd ARP_aP_at_51_6 GND nmos W=0.0975U L=0.065U
M67_ GND Vdd ARP_aP_af_51_6 GND nmos W=0.0975U L=0.065U
M68_ GND Vdd ARP_aP_at_52_6 GND nmos W=0.0975U L=0.065U
M69_ GND Vdd ARP_aP_af_52_6 GND nmos W=0.0975U L=0.065U
M70_ GND Vdd ARP_aP_at_53_6 GND nmos W=0.0975U L=0.065U
M71_ GND Vdd ARP_aP_af_53_6 GND nmos W=0.0975U L=0.065U
M72_ GND Vdd ARP_aP_at_54_6 GND nmos W=0.0975U L=0.065U
M73_ GND Vdd ARP_aP_af_54_6 GND nmos W=0.0975U L=0.065U
M74_ GND Vdd ARP_aP_at_55_6 GND nmos W=0.0975U L=0.065U
M75_ GND Vdd ARP_aP_af_55_6 GND nmos W=0.0975U L=0.065U
M76_ GND Vdd ARP_aP_at_56_6 GND nmos W=0.0975U L=0.065U
M77_ GND Vdd ARP_aP_af_56_6 GND nmos W=0.0975U L=0.065U
M78_ GND Vdd ARP_aP_at_57_6 GND nmos W=0.0975U L=0.065U
M79_ GND Vdd ARP_aP_af_57_6 GND nmos W=0.0975U L=0.065U
M80_ GND Vdd ARP_aP_at_58_6 GND nmos W=0.0975U L=0.065U
M81_ GND Vdd ARP_aP_af_58_6 GND nmos W=0.0975U L=0.065U
M82_ GND Vdd ARP_aP_at_59_6 GND nmos W=0.0975U L=0.065U
M83_ GND Vdd ARP_aP_af_59_6 GND nmos W=0.0975U L=0.065U
M84_ GND Vdd ARP_aP_at_510_6 GND nmos W=0.0975U L=0.065U
M85_ GND Vdd ARP_aP_af_510_6 GND nmos W=0.0975U L=0.065U
M86_ GND Vdd ARP_aP_at_511_6 GND nmos W=0.0975U L=0.065U
M87_ GND Vdd ARP_aP_af_511_6 GND nmos W=0.0975U L=0.065U
M88_ GND Vdd ARP_aP_at_512_6 GND nmos W=0.0975U L=0.065U
M89_ GND Vdd ARP_aP_af_512_6 GND nmos W=0.0975U L=0.065U
M90_ GND Vdd ARP_aP_at_513_6 GND nmos W=0.0975U L=0.065U
M91_ GND Vdd ARP_aP_af_513_6 GND nmos W=0.0975U L=0.065U
M92_ GND Vdd ARP_aP_at_514_6 GND nmos W=0.0975U L=0.065U
M93_ GND Vdd ARP_aP_af_514_6 GND nmos W=0.0975U L=0.065U
M94_ GND Vdd ARP_aP_at_515_6 GND nmos W=0.0975U L=0.065U
M95_ GND Vdd ARP_aP_af_515_6 GND nmos W=0.0975U L=0.065U
M96_ GND Vdd ARP_aP_at_516_6 GND nmos W=0.0975U L=0.065U
M97_ GND Vdd ARP_aP_af_516_6 GND nmos W=0.0975U L=0.065U
M98_ GND Vdd ARP_aP_at_517_6 GND nmos W=0.0975U L=0.065U
M99_ GND Vdd ARP_aP_af_517_6 GND nmos W=0.0975U L=0.065U
M100_ GND Vdd ARP_aP_at_518_6 GND nmos W=0.0975U L=0.065U
M101_ GND Vdd ARP_aP_af_518_6 GND nmos W=0.0975U L=0.065U
M102_ GND Vdd ARP_aP_at_519_6 GND nmos W=0.0975U L=0.065U
M103_ GND Vdd ARP_aP_af_519_6 GND nmos W=0.0975U L=0.065U
M104_ GND Vdd ARP_aP_at_520_6 GND nmos W=0.0975U L=0.065U
M105_ GND Vdd ARP_aP_af_520_6 GND nmos W=0.0975U L=0.065U
M106_ GND Vdd ARP_aP_at_521_6 GND nmos W=0.0975U L=0.065U
M107_ GND Vdd ARP_aP_af_521_6 GND nmos W=0.0975U L=0.065U
M108_ GND Vdd ARP_aP_at_522_6 GND nmos W=0.0975U L=0.065U
M109_ GND Vdd ARP_aP_af_522_6 GND nmos W=0.0975U L=0.065U
M110_ GND Vdd ARP_aP_at_523_6 GND nmos W=0.0975U L=0.065U
M111_ GND Vdd ARP_aP_af_523_6 GND nmos W=0.0975U L=0.065U
M112_ GND Vdd ARP_aP_at_524_6 GND nmos W=0.0975U L=0.065U
M113_ GND Vdd ARP_aP_af_524_6 GND nmos W=0.0975U L=0.065U
M114_ GND Vdd ARP_aP_at_525_6 GND nmos W=0.0975U L=0.065U
M115_ GND Vdd ARP_aP_af_525_6 GND nmos W=0.0975U L=0.065U
M116_ GND Vdd ARP_aP_at_526_6 GND nmos W=0.0975U L=0.065U
M117_ GND Vdd ARP_aP_af_526_6 GND nmos W=0.0975U L=0.065U
M118_ GND Vdd ARP_aP_at_527_6 GND nmos W=0.0975U L=0.065U
M119_ GND Vdd ARP_aP_af_527_6 GND nmos W=0.0975U L=0.065U
M120_ GND Vdd ARP_aP_at_528_6 GND nmos W=0.0975U L=0.065U
M121_ GND Vdd ARP_aP_af_528_6 GND nmos W=0.0975U L=0.065U
M122_ GND Vdd ARP_aP_at_529_6 GND nmos W=0.0975U L=0.065U
M123_ GND Vdd ARP_aP_af_529_6 GND nmos W=0.0975U L=0.065U
M124_ GND Vdd ARP_aP_at_530_6 GND nmos W=0.0975U L=0.065U
M125_ GND Vdd ARP_aP_af_530_6 GND nmos W=0.0975U L=0.065U
M126_ GND Vdd ARP_aP_at_531_6 GND nmos W=0.0975U L=0.065U
M127_ GND Vdd ARP_aP_af_531_6 GND nmos W=0.0975U L=0.065U
M128_ GND Vdd ARP_aM_at_50_6 GND nmos W=0.0975U L=0.065U
M129_ GND Vdd ARP_aM_af_50_6 GND nmos W=0.0975U L=0.065U
M130_ GND Vdd ARP_aM_at_51_6 GND nmos W=0.0975U L=0.065U
M131_ GND Vdd ARP_aM_af_51_6 GND nmos W=0.0975U L=0.065U
M132_ GND Vdd ARP_aM_at_52_6 GND nmos W=0.0975U L=0.065U
M133_ GND Vdd ARP_aM_af_52_6 GND nmos W=0.0975U L=0.065U
M134_ GND Vdd ARP_aM_at_53_6 GND nmos W=0.0975U L=0.065U
M135_ GND Vdd ARP_aM_af_53_6 GND nmos W=0.0975U L=0.065U
M136_ GND Vdd ARP_aM_at_54_6 GND nmos W=0.0975U L=0.065U
M137_ GND Vdd ARP_aM_af_54_6 GND nmos W=0.0975U L=0.065U
M138_ GND Vdd ARP_aM_at_55_6 GND nmos W=0.0975U L=0.065U
M139_ GND Vdd ARP_aM_af_55_6 GND nmos W=0.0975U L=0.065U
M140_ GND Vdd ARP_aM_at_56_6 GND nmos W=0.0975U L=0.065U
M141_ GND Vdd ARP_aM_af_56_6 GND nmos W=0.0975U L=0.065U
M142_ GND Vdd ARP_aM_at_57_6 GND nmos W=0.0975U L=0.065U
M143_ GND Vdd ARP_aM_af_57_6 GND nmos W=0.0975U L=0.065U
M144_ GND Vdd ARP_aM_at_58_6 GND nmos W=0.0975U L=0.065U
M145_ GND Vdd ARP_aM_af_58_6 GND nmos W=0.0975U L=0.065U
M146_ GND Vdd ARP_aM_at_59_6 GND nmos W=0.0975U L=0.065U
M147_ GND Vdd ARP_aM_af_59_6 GND nmos W=0.0975U L=0.065U
M148_ GND Vdd ARP_aM_at_510_6 GND nmos W=0.0975U L=0.065U
M149_ GND Vdd ARP_aM_af_510_6 GND nmos W=0.0975U L=0.065U
M150_ GND Vdd ARP_aM_at_511_6 GND nmos W=0.0975U L=0.065U
M151_ GND Vdd ARP_aM_af_511_6 GND nmos W=0.0975U L=0.065U
M152_ GND Vdd ARP_aM_at_512_6 GND nmos W=0.0975U L=0.065U
M153_ GND Vdd ARP_aM_af_512_6 GND nmos W=0.0975U L=0.065U
M154_ GND Vdd ARP_aM_at_513_6 GND nmos W=0.0975U L=0.065U
M155_ GND Vdd ARP_aM_af_513_6 GND nmos W=0.0975U L=0.065U
M156_ GND Vdd ARP_aM_at_514_6 GND nmos W=0.0975U L=0.065U
M157_ GND Vdd ARP_aM_af_514_6 GND nmos W=0.0975U L=0.065U
M158_ GND Vdd ARP_aM_at_515_6 GND nmos W=0.0975U L=0.065U
M159_ GND Vdd ARP_aM_af_515_6 GND nmos W=0.0975U L=0.065U
M160_ GND Vdd ARP_aM_at_516_6 GND nmos W=0.0975U L=0.065U
M161_ GND Vdd ARP_aM_af_516_6 GND nmos W=0.0975U L=0.065U
M162_ GND Vdd ARP_aM_at_517_6 GND nmos W=0.0975U L=0.065U
M163_ GND Vdd ARP_aM_af_517_6 GND nmos W=0.0975U L=0.065U
M164_ GND Vdd ARP_aM_at_518_6 GND nmos W=0.0975U L=0.065U
M165_ GND Vdd ARP_aM_af_518_6 GND nmos W=0.0975U L=0.065U
M166_ GND Vdd ARP_aM_at_519_6 GND nmos W=0.0975U L=0.065U
M167_ GND Vdd ARP_aM_af_519_6 GND nmos W=0.0975U L=0.065U
M168_ GND Vdd ARP_aM_at_520_6 GND nmos W=0.0975U L=0.065U
M169_ GND Vdd ARP_aM_af_520_6 GND nmos W=0.0975U L=0.065U
M170_ GND Vdd ARP_aM_at_521_6 GND nmos W=0.0975U L=0.065U
M171_ GND Vdd ARP_aM_af_521_6 GND nmos W=0.0975U L=0.065U
M172_ GND Vdd ARP_aM_at_522_6 GND nmos W=0.0975U L=0.065U
M173_ GND Vdd ARP_aM_af_522_6 GND nmos W=0.0975U L=0.065U
M174_ GND Vdd ARP_aM_at_523_6 GND nmos W=0.0975U L=0.065U
M175_ GND Vdd ARP_aM_af_523_6 GND nmos W=0.0975U L=0.065U
M176_ GND Vdd ARP_aM_at_524_6 GND nmos W=0.0975U L=0.065U
M177_ GND Vdd ARP_aM_af_524_6 GND nmos W=0.0975U L=0.065U
M178_ GND Vdd ARP_aM_at_525_6 GND nmos W=0.0975U L=0.065U
M179_ GND Vdd ARP_aM_af_525_6 GND nmos W=0.0975U L=0.065U
M180_ GND Vdd ARP_aM_at_526_6 GND nmos W=0.0975U L=0.065U
M181_ GND Vdd ARP_aM_af_526_6 GND nmos W=0.0975U L=0.065U
M182_ GND Vdd ARP_aM_at_527_6 GND nmos W=0.0975U L=0.065U
M183_ GND Vdd ARP_aM_af_527_6 GND nmos W=0.0975U L=0.065U
M184_ GND Vdd ARP_aM_at_528_6 GND nmos W=0.0975U L=0.065U
M185_ GND Vdd ARP_aM_af_528_6 GND nmos W=0.0975U L=0.065U
M186_ GND Vdd ARP_aM_at_529_6 GND nmos W=0.0975U L=0.065U
M187_ GND Vdd ARP_aM_af_529_6 GND nmos W=0.0975U L=0.065U
M188_ GND Vdd ARP_aM_at_530_6 GND nmos W=0.0975U L=0.065U
M189_ GND Vdd ARP_aM_af_530_6 GND nmos W=0.0975U L=0.065U
M190_ GND Vdd ARP_aM_at_531_6 GND nmos W=0.0975U L=0.065U
M191_ GND Vdd ARP_aM_af_531_6 GND nmos W=0.0975U L=0.065U
xCRT3 reset C3i_at_50_6 C3i_at_51_6 C3i_at_52_6 C3i_at_53_6 C3i_at_54_6 C3i_at_55_6 C3i_at_56_6 C3i_at_57_6 C3i_at_58_6 C3i_at_59_6 C3i_at_510_6 C3i_at_511_6 C3i_at_512_6 C3i_at_513_6 C3i_at_514_6 C3i_at_515_6 C3i_at_516_6 C3i_at_517_6 C3i_at_518_6 C3i_at_519_6 C3i_at_520_6 C3i_at_521_6 C3i_at_522_6 C3i_at_523_6 C3i_at_524_6 C3i_at_525_6 C3i_at_526_6 C3i_at_527_6 C3i_at_528_6 C3i_at_529_6 C3i_at_530_6 C3i_at_531_6 C3i_af_50_6 C3i_af_51_6 C3i_af_52_6 C3i_af_53_6 C3i_af_54_6 C3i_af_55_6 C3i_af_56_6 C3i_af_57_6 C3i_af_58_6 C3i_af_59_6 C3i_af_510_6 C3i_af_511_6 C3i_af_512_6 C3i_af_513_6 C3i_af_514_6 C3i_af_515_6 C3i_af_516_6 C3i_af_517_6 C3i_af_518_6 C3i_af_519_6 C3i_af_520_6 C3i_af_521_6 C3i_af_522_6 C3i_af_523_6 C3i_af_524_6 C3i_af_525_6 C3i_af_526_6 C3i_af_527_6 C3i_af_528_6 C3i_af_529_6 C3i_af_530_6 C3i_af_531_6 C3i_aa ARM_aC3_at_50_6 ARM_aC3_at_51_6 ARM_aC3_at_52_6 ARM_aC3_at_53_6 ARM_aC3_at_54_6 ARM_aC3_at_55_6 ARM_aC3_at_56_6 ARM_aC3_at_57_6 ARM_aC3_at_58_6 ARM_aC3_at_59_6 ARM_aC3_at_510_6 ARM_aC3_at_511_6 ARM_aC3_at_512_6 ARM_aC3_at_513_6 ARM_aC3_at_514_6 ARM_aC3_at_515_6 ARM_aC3_at_516_6 ARM_aC3_at_517_6 ARM_aC3_at_518_6 ARM_aC3_at_519_6 ARM_aC3_at_520_6 ARM_aC3_at_521_6 ARM_aC3_at_522_6 ARM_aC3_at_523_6 ARM_aC3_at_524_6 ARM_aC3_at_525_6 ARM_aC3_at_526_6 ARM_aC3_at_527_6 ARM_aC3_at_528_6 ARM_aC3_at_529_6 ARM_aC3_at_530_6 ARM_aC3_at_531_6 ARM_aC3_af_50_6 ARM_aC3_af_51_6 ARM_aC3_af_52_6 ARM_aC3_af_53_6 ARM_aC3_af_54_6 ARM_aC3_af_55_6 ARM_aC3_af_56_6 ARM_aC3_af_57_6 ARM_aC3_af_58_6 ARM_aC3_af_59_6 ARM_aC3_af_510_6 ARM_aC3_af_511_6 ARM_aC3_af_512_6 ARM_aC3_af_513_6 ARM_aC3_af_514_6 ARM_aC3_af_515_6 ARM_aC3_af_516_6 ARM_aC3_af_517_6 ARM_aC3_af_518_6 ARM_aC3_af_519_6 ARM_aC3_af_520_6 ARM_aC3_af_521_6 ARM_aC3_af_522_6 ARM_aC3_af_523_6 ARM_aC3_af_524_6 ARM_aC3_af_525_6 ARM_aC3_af_526_6 ARM_aC3_af_527_6 ARM_aC3_af_528_6 ARM_aC3_af_529_6 ARM_aC3_af_530_6 ARM_aC3_af_531_6 ARM_aC3_aa ARP_aC3_at_50_6 ARP_aC3_at_51_6 ARP_aC3_at_52_6 ARP_aC3_at_53_6 ARP_aC3_at_54_6 ARP_aC3_at_55_6 ARP_aC3_at_56_6 ARP_aC3_at_57_6 ARP_aC3_at_58_6 ARP_aC3_at_59_6 ARP_aC3_at_510_6 ARP_aC3_at_511_6 ARP_aC3_at_512_6 ARP_aC3_at_513_6 ARP_aC3_at_514_6 ARP_aC3_at_515_6 ARP_aC3_at_516_6 ARP_aC3_at_517_6 ARP_aC3_at_518_6 ARP_aC3_at_519_6 ARP_aC3_at_520_6 ARP_aC3_at_521_6 ARP_aC3_at_522_6 ARP_aC3_at_523_6 ARP_aC3_at_524_6 ARP_aC3_at_525_6 ARP_aC3_at_526_6 ARP_aC3_at_527_6 ARP_aC3_at_528_6 ARP_aC3_at_529_6 ARP_aC3_at_530_6 ARP_aC3_at_531_6 ARP_aC3_af_50_6 ARP_aC3_af_51_6 ARP_aC3_af_52_6 ARP_aC3_af_53_6 ARP_aC3_af_54_6 ARP_aC3_af_55_6 ARP_aC3_af_56_6 ARP_aC3_af_57_6 ARP_aC3_af_58_6 ARP_aC3_af_59_6 ARP_aC3_af_510_6 ARP_aC3_af_511_6 ARP_aC3_af_512_6 ARP_aC3_af_513_6 ARP_aC3_af_514_6 ARP_aC3_af_515_6 ARP_aC3_af_516_6 ARP_aC3_af_517_6 ARP_aC3_af_518_6 ARP_aC3_af_519_6 ARP_aC3_af_520_6 ARP_aC3_af_521_6 ARP_aC3_af_522_6 ARP_aC3_af_523_6 ARP_aC3_af_524_6 ARP_aC3_af_525_6 ARP_aC3_af_526_6 ARP_aC3_af_527_6 ARP_aC3_af_528_6 ARP_aC3_af_529_6 ARP_aC3_af_530_6 ARP_aC3_af_531_6 ARP_aC3_aa ARC0_aC3_at_50_6 ARC0_aC3_at_51_6 ARC0_aC3_at_52_6 ARC0_aC3_at_53_6 ARC0_aC3_at_54_6 ARC0_aC3_at_55_6 ARC0_aC3_at_56_6 ARC0_aC3_at_57_6 ARC0_aC3_at_58_6 ARC0_aC3_at_59_6 ARC0_aC3_at_510_6 ARC0_aC3_at_511_6 ARC0_aC3_at_512_6 ARC0_aC3_at_513_6 ARC0_aC3_at_514_6 ARC0_aC3_at_515_6 ARC0_aC3_at_516_6 ARC0_aC3_at_517_6 ARC0_aC3_at_518_6 ARC0_aC3_at_519_6 ARC0_aC3_at_520_6 ARC0_aC3_at_521_6 ARC0_aC3_at_522_6 ARC0_aC3_at_523_6 ARC0_aC3_at_524_6 ARC0_aC3_at_525_6 ARC0_aC3_at_526_6 ARC0_aC3_at_527_6 ARC0_aC3_at_528_6 ARC0_aC3_at_529_6 ARC0_aC3_at_530_6 ARC0_aC3_at_531_6 ARC0_aC3_af_50_6 ARC0_aC3_af_51_6 ARC0_aC3_af_52_6 ARC0_aC3_af_53_6 ARC0_aC3_af_54_6 ARC0_aC3_af_55_6 ARC0_aC3_af_56_6 ARC0_aC3_af_57_6 ARC0_aC3_af_58_6 ARC0_aC3_af_59_6 ARC0_aC3_af_510_6 ARC0_aC3_af_511_6 ARC0_aC3_af_512_6 ARC0_aC3_af_513_6 ARC0_aC3_af_514_6 ARC0_aC3_af_515_6 ARC0_aC3_af_516_6 ARC0_aC3_af_517_6 ARC0_aC3_af_518_6 ARC0_aC3_af_519_6 ARC0_aC3_af_520_6 ARC0_aC3_af_521_6 ARC0_aC3_af_522_6 ARC0_aC3_af_523_6 ARC0_aC3_af_524_6 ARC0_aC3_af_525_6 ARC0_aC3_af_526_6 ARC0_aC3_af_527_6 ARC0_aC3_af_528_6 ARC0_aC3_af_529_6 ARC0_aC3_af_530_6 ARC0_aC3_af_531_6 ARC0_aC3_aa ARC1_aC3_at_50_6 ARC1_aC3_at_51_6 ARC1_aC3_at_52_6 ARC1_aC3_at_53_6 ARC1_aC3_at_54_6 ARC1_aC3_at_55_6 ARC1_aC3_at_56_6 ARC1_aC3_at_57_6 ARC1_aC3_at_58_6 ARC1_aC3_at_59_6 ARC1_aC3_at_510_6 ARC1_aC3_at_511_6 ARC1_aC3_at_512_6 ARC1_aC3_at_513_6 ARC1_aC3_at_514_6 ARC1_aC3_at_515_6 ARC1_aC3_at_516_6 ARC1_aC3_at_517_6 ARC1_aC3_at_518_6 ARC1_aC3_at_519_6 ARC1_aC3_at_520_6 ARC1_aC3_at_521_6 ARC1_aC3_at_522_6 ARC1_aC3_at_523_6 ARC1_aC3_at_524_6 ARC1_aC3_at_525_6 ARC1_aC3_at_526_6 ARC1_aC3_at_527_6 ARC1_aC3_at_528_6 ARC1_aC3_at_529_6 ARC1_aC3_at_530_6 ARC1_aC3_at_531_6 ARC1_aC3_af_50_6 ARC1_aC3_af_51_6 ARC1_aC3_af_52_6 ARC1_aC3_af_53_6 ARC1_aC3_af_54_6 ARC1_aC3_af_55_6 ARC1_aC3_af_56_6 ARC1_aC3_af_57_6 ARC1_aC3_af_58_6 ARC1_aC3_af_59_6 ARC1_aC3_af_510_6 ARC1_aC3_af_511_6 ARC1_aC3_af_512_6 ARC1_aC3_af_513_6 ARC1_aC3_af_514_6 ARC1_aC3_af_515_6 ARC1_aC3_af_516_6 ARC1_aC3_af_517_6 ARC1_aC3_af_518_6 ARC1_aC3_af_519_6 ARC1_aC3_af_520_6 ARC1_aC3_af_521_6 ARC1_aC3_af_522_6 ARC1_aC3_af_523_6 ARC1_aC3_af_524_6 ARC1_aC3_af_525_6 ARC1_aC3_af_526_6 ARC1_aC3_af_527_6 ARC1_aC3_af_528_6 ARC1_aC3_af_529_6 ARC1_aC3_af_530_6 ARC1_aC3_af_531_6 ARC1_aC3_aa ARC2_aC3_at_50_6 ARC2_aC3_at_51_6 ARC2_aC3_at_52_6 ARC2_aC3_at_53_6 ARC2_aC3_at_54_6 ARC2_aC3_at_55_6 ARC2_aC3_at_56_6 ARC2_aC3_at_57_6 ARC2_aC3_at_58_6 ARC2_aC3_at_59_6 ARC2_aC3_at_510_6 ARC2_aC3_at_511_6 ARC2_aC3_at_512_6 ARC2_aC3_at_513_6 ARC2_aC3_at_514_6 ARC2_aC3_at_515_6 ARC2_aC3_at_516_6 ARC2_aC3_at_517_6 ARC2_aC3_at_518_6 ARC2_aC3_at_519_6 ARC2_aC3_at_520_6 ARC2_aC3_at_521_6 ARC2_aC3_at_522_6 ARC2_aC3_at_523_6 ARC2_aC3_at_524_6 ARC2_aC3_at_525_6 ARC2_aC3_at_526_6 ARC2_aC3_at_527_6 ARC2_aC3_at_528_6 ARC2_aC3_at_529_6 ARC2_aC3_at_530_6 ARC2_aC3_at_531_6 ARC2_aC3_af_50_6 ARC2_aC3_af_51_6 ARC2_aC3_af_52_6 ARC2_aC3_af_53_6 ARC2_aC3_af_54_6 ARC2_aC3_af_55_6 ARC2_aC3_af_56_6 ARC2_aC3_af_57_6 ARC2_aC3_af_58_6 ARC2_aC3_af_59_6 ARC2_aC3_af_510_6 ARC2_aC3_af_511_6 ARC2_aC3_af_512_6 ARC2_aC3_af_513_6 ARC2_aC3_af_514_6 ARC2_aC3_af_515_6 ARC2_aC3_af_516_6 ARC2_aC3_af_517_6 ARC2_aC3_af_518_6 ARC2_aC3_af_519_6 ARC2_aC3_af_520_6 ARC2_aC3_af_521_6 ARC2_aC3_af_522_6 ARC2_aC3_af_523_6 ARC2_aC3_af_524_6 ARC2_aC3_af_525_6 ARC2_aC3_af_526_6 ARC2_aC3_af_527_6 ARC2_aC3_af_528_6 ARC2_aC3_af_529_6 ARC2_aC3_af_530_6 ARC2_aC3_af_531_6 ARC2_aC3_aa ARC3_aC3_at_50_6 ARC3_aC3_at_51_6 ARC3_aC3_at_52_6 ARC3_aC3_at_53_6 ARC3_aC3_at_54_6 ARC3_aC3_at_55_6 ARC3_aC3_at_56_6 ARC3_aC3_at_57_6 ARC3_aC3_at_58_6 ARC3_aC3_at_59_6 ARC3_aC3_at_510_6 ARC3_aC3_at_511_6 ARC3_aC3_at_512_6 ARC3_aC3_at_513_6 ARC3_aC3_at_514_6 ARC3_aC3_at_515_6 ARC3_aC3_at_516_6 ARC3_aC3_at_517_6 ARC3_aC3_at_518_6 ARC3_aC3_at_519_6 ARC3_aC3_at_520_6 ARC3_aC3_at_521_6 ARC3_aC3_at_522_6 ARC3_aC3_at_523_6 ARC3_aC3_at_524_6 ARC3_aC3_at_525_6 ARC3_aC3_at_526_6 ARC3_aC3_at_527_6 ARC3_aC3_at_528_6 ARC3_aC3_at_529_6 ARC3_aC3_at_530_6 ARC3_aC3_at_531_6 ARC3_aC3_af_50_6 ARC3_aC3_af_51_6 ARC3_aC3_af_52_6 ARC3_aC3_af_53_6 ARC3_aC3_af_54_6 ARC3_aC3_af_55_6 ARC3_aC3_af_56_6 ARC3_aC3_af_57_6 ARC3_aC3_af_58_6 ARC3_aC3_af_59_6 ARC3_aC3_af_510_6 ARC3_aC3_af_511_6 ARC3_aC3_af_512_6 ARC3_aC3_af_513_6 ARC3_aC3_af_514_6 ARC3_aC3_af_515_6 ARC3_aC3_af_516_6 ARC3_aC3_af_517_6 ARC3_aC3_af_518_6 ARC3_aC3_af_519_6 ARC3_aC3_af_520_6 ARC3_aC3_af_521_6 ARC3_aC3_af_522_6 ARC3_aC3_af_523_6 ARC3_aC3_af_524_6 ARC3_aC3_af_525_6 ARC3_aC3_af_526_6 ARC3_aC3_af_527_6 ARC3_aC3_af_528_6 ARC3_aC3_af_529_6 ARC3_aC3_af_530_6 ARC3_aC3_af_531_6 ARC3_aC3_aa ChildRouter
xARP reset ARP_aC0_at_50_6 ARP_aC0_at_51_6 ARP_aC0_at_52_6 ARP_aC0_at_53_6 ARP_aC0_at_54_6 ARP_aC0_at_55_6 ARP_aC0_at_56_6 ARP_aC0_at_57_6 ARP_aC0_at_58_6 ARP_aC0_at_59_6 ARP_aC0_at_510_6 ARP_aC0_at_511_6 ARP_aC0_at_512_6 ARP_aC0_at_513_6 ARP_aC0_at_514_6 ARP_aC0_at_515_6 ARP_aC0_at_516_6 ARP_aC0_at_517_6 ARP_aC0_at_518_6 ARP_aC0_at_519_6 ARP_aC0_at_520_6 ARP_aC0_at_521_6 ARP_aC0_at_522_6 ARP_aC0_at_523_6 ARP_aC0_at_524_6 ARP_aC0_at_525_6 ARP_aC0_at_526_6 ARP_aC0_at_527_6 ARP_aC0_at_528_6 ARP_aC0_at_529_6 ARP_aC0_at_530_6 ARP_aC0_at_531_6 ARP_aC0_af_50_6 ARP_aC0_af_51_6 ARP_aC0_af_52_6 ARP_aC0_af_53_6 ARP_aC0_af_54_6 ARP_aC0_af_55_6 ARP_aC0_af_56_6 ARP_aC0_af_57_6 ARP_aC0_af_58_6 ARP_aC0_af_59_6 ARP_aC0_af_510_6 ARP_aC0_af_511_6 ARP_aC0_af_512_6 ARP_aC0_af_513_6 ARP_aC0_af_514_6 ARP_aC0_af_515_6 ARP_aC0_af_516_6 ARP_aC0_af_517_6 ARP_aC0_af_518_6 ARP_aC0_af_519_6 ARP_aC0_af_520_6 ARP_aC0_af_521_6 ARP_aC0_af_522_6 ARP_aC0_af_523_6 ARP_aC0_af_524_6 ARP_aC0_af_525_6 ARP_aC0_af_526_6 ARP_aC0_af_527_6 ARP_aC0_af_528_6 ARP_aC0_af_529_6 ARP_aC0_af_530_6 ARP_aC0_af_531_6 ARP_aC0_aa ARP_aC1_at_50_6 ARP_aC1_at_51_6 ARP_aC1_at_52_6 ARP_aC1_at_53_6 ARP_aC1_at_54_6 ARP_aC1_at_55_6 ARP_aC1_at_56_6 ARP_aC1_at_57_6 ARP_aC1_at_58_6 ARP_aC1_at_59_6 ARP_aC1_at_510_6 ARP_aC1_at_511_6 ARP_aC1_at_512_6 ARP_aC1_at_513_6 ARP_aC1_at_514_6 ARP_aC1_at_515_6 ARP_aC1_at_516_6 ARP_aC1_at_517_6 ARP_aC1_at_518_6 ARP_aC1_at_519_6 ARP_aC1_at_520_6 ARP_aC1_at_521_6 ARP_aC1_at_522_6 ARP_aC1_at_523_6 ARP_aC1_at_524_6 ARP_aC1_at_525_6 ARP_aC1_at_526_6 ARP_aC1_at_527_6 ARP_aC1_at_528_6 ARP_aC1_at_529_6 ARP_aC1_at_530_6 ARP_aC1_at_531_6 ARP_aC1_af_50_6 ARP_aC1_af_51_6 ARP_aC1_af_52_6 ARP_aC1_af_53_6 ARP_aC1_af_54_6 ARP_aC1_af_55_6 ARP_aC1_af_56_6 ARP_aC1_af_57_6 ARP_aC1_af_58_6 ARP_aC1_af_59_6 ARP_aC1_af_510_6 ARP_aC1_af_511_6 ARP_aC1_af_512_6 ARP_aC1_af_513_6 ARP_aC1_af_514_6 ARP_aC1_af_515_6 ARP_aC1_af_516_6 ARP_aC1_af_517_6 ARP_aC1_af_518_6 ARP_aC1_af_519_6 ARP_aC1_af_520_6 ARP_aC1_af_521_6 ARP_aC1_af_522_6 ARP_aC1_af_523_6 ARP_aC1_af_524_6 ARP_aC1_af_525_6 ARP_aC1_af_526_6 ARP_aC1_af_527_6 ARP_aC1_af_528_6 ARP_aC1_af_529_6 ARP_aC1_af_530_6 ARP_aC1_af_531_6 ARP_aC1_aa ARP_aC2_at_50_6 ARP_aC2_at_51_6 ARP_aC2_at_52_6 ARP_aC2_at_53_6 ARP_aC2_at_54_6 ARP_aC2_at_55_6 ARP_aC2_at_56_6 ARP_aC2_at_57_6 ARP_aC2_at_58_6 ARP_aC2_at_59_6 ARP_aC2_at_510_6 ARP_aC2_at_511_6 ARP_aC2_at_512_6 ARP_aC2_at_513_6 ARP_aC2_at_514_6 ARP_aC2_at_515_6 ARP_aC2_at_516_6 ARP_aC2_at_517_6 ARP_aC2_at_518_6 ARP_aC2_at_519_6 ARP_aC2_at_520_6 ARP_aC2_at_521_6 ARP_aC2_at_522_6 ARP_aC2_at_523_6 ARP_aC2_at_524_6 ARP_aC2_at_525_6 ARP_aC2_at_526_6 ARP_aC2_at_527_6 ARP_aC2_at_528_6 ARP_aC2_at_529_6 ARP_aC2_at_530_6 ARP_aC2_at_531_6 ARP_aC2_af_50_6 ARP_aC2_af_51_6 ARP_aC2_af_52_6 ARP_aC2_af_53_6 ARP_aC2_af_54_6 ARP_aC2_af_55_6 ARP_aC2_af_56_6 ARP_aC2_af_57_6 ARP_aC2_af_58_6 ARP_aC2_af_59_6 ARP_aC2_af_510_6 ARP_aC2_af_511_6 ARP_aC2_af_512_6 ARP_aC2_af_513_6 ARP_aC2_af_514_6 ARP_aC2_af_515_6 ARP_aC2_af_516_6 ARP_aC2_af_517_6 ARP_aC2_af_518_6 ARP_aC2_af_519_6 ARP_aC2_af_520_6 ARP_aC2_af_521_6 ARP_aC2_af_522_6 ARP_aC2_af_523_6 ARP_aC2_af_524_6 ARP_aC2_af_525_6 ARP_aC2_af_526_6 ARP_aC2_af_527_6 ARP_aC2_af_528_6 ARP_aC2_af_529_6 ARP_aC2_af_530_6 ARP_aC2_af_531_6 ARP_aC2_aa ARP_aC3_at_50_6 ARP_aC3_at_51_6 ARP_aC3_at_52_6 ARP_aC3_at_53_6 ARP_aC3_at_54_6 ARP_aC3_at_55_6 ARP_aC3_at_56_6 ARP_aC3_at_57_6 ARP_aC3_at_58_6 ARP_aC3_at_59_6 ARP_aC3_at_510_6 ARP_aC3_at_511_6 ARP_aC3_at_512_6 ARP_aC3_at_513_6 ARP_aC3_at_514_6 ARP_aC3_at_515_6 ARP_aC3_at_516_6 ARP_aC3_at_517_6 ARP_aC3_at_518_6 ARP_aC3_at_519_6 ARP_aC3_at_520_6 ARP_aC3_at_521_6 ARP_aC3_at_522_6 ARP_aC3_at_523_6 ARP_aC3_at_524_6 ARP_aC3_at_525_6 ARP_aC3_at_526_6 ARP_aC3_at_527_6 ARP_aC3_at_528_6 ARP_aC3_at_529_6 ARP_aC3_at_530_6 ARP_aC3_at_531_6 ARP_aC3_af_50_6 ARP_aC3_af_51_6 ARP_aC3_af_52_6 ARP_aC3_af_53_6 ARP_aC3_af_54_6 ARP_aC3_af_55_6 ARP_aC3_af_56_6 ARP_aC3_af_57_6 ARP_aC3_af_58_6 ARP_aC3_af_59_6 ARP_aC3_af_510_6 ARP_aC3_af_511_6 ARP_aC3_af_512_6 ARP_aC3_af_513_6 ARP_aC3_af_514_6 ARP_aC3_af_515_6 ARP_aC3_af_516_6 ARP_aC3_af_517_6 ARP_aC3_af_518_6 ARP_aC3_af_519_6 ARP_aC3_af_520_6 ARP_aC3_af_521_6 ARP_aC3_af_522_6 ARP_aC3_af_523_6 ARP_aC3_af_524_6 ARP_aC3_af_525_6 ARP_aC3_af_526_6 ARP_aC3_af_527_6 ARP_aC3_af_528_6 ARP_aC3_af_529_6 ARP_aC3_af_530_6 ARP_aC3_af_531_6 ARP_aC3_aa ARP_aP_at_50_6 ARP_aP_at_51_6 ARP_aP_at_52_6 ARP_aP_at_53_6 ARP_aP_at_54_6 ARP_aP_at_55_6 ARP_aP_at_56_6 ARP_aP_at_57_6 ARP_aP_at_58_6 ARP_aP_at_59_6 ARP_aP_at_510_6 ARP_aP_at_511_6 ARP_aP_at_512_6 ARP_aP_at_513_6 ARP_aP_at_514_6 ARP_aP_at_515_6 ARP_aP_at_516_6 ARP_aP_at_517_6 ARP_aP_at_518_6 ARP_aP_at_519_6 ARP_aP_at_520_6 ARP_aP_at_521_6 ARP_aP_at_522_6 ARP_aP_at_523_6 ARP_aP_at_524_6 ARP_aP_at_525_6 ARP_aP_at_526_6 ARP_aP_at_527_6 ARP_aP_at_528_6 ARP_aP_at_529_6 ARP_aP_at_530_6 ARP_aP_at_531_6 ARP_aP_af_50_6 ARP_aP_af_51_6 ARP_aP_af_52_6 ARP_aP_af_53_6 ARP_aP_af_54_6 ARP_aP_af_55_6 ARP_aP_af_56_6 ARP_aP_af_57_6 ARP_aP_af_58_6 ARP_aP_af_59_6 ARP_aP_af_510_6 ARP_aP_af_511_6 ARP_aP_af_512_6 ARP_aP_af_513_6 ARP_aP_af_514_6 ARP_aP_af_515_6 ARP_aP_af_516_6 ARP_aP_af_517_6 ARP_aP_af_518_6 ARP_aP_af_519_6 ARP_aP_af_520_6 ARP_aP_af_521_6 ARP_aP_af_522_6 ARP_aP_af_523_6 ARP_aP_af_524_6 ARP_aP_af_525_6 ARP_aP_af_526_6 ARP_aP_af_527_6 ARP_aP_af_528_6 ARP_aP_af_529_6 ARP_aP_af_530_6 ARP_aP_af_531_6 ARP_aP_aa ARP_aM_at_50_6 ARP_aM_at_51_6 ARP_aM_at_52_6 ARP_aM_at_53_6 ARP_aM_at_54_6 ARP_aM_at_55_6 ARP_aM_at_56_6 ARP_aM_at_57_6 ARP_aM_at_58_6 ARP_aM_at_59_6 ARP_aM_at_510_6 ARP_aM_at_511_6 ARP_aM_at_512_6 ARP_aM_at_513_6 ARP_aM_at_514_6 ARP_aM_at_515_6 ARP_aM_at_516_6 ARP_aM_at_517_6 ARP_aM_at_518_6 ARP_aM_at_519_6 ARP_aM_at_520_6 ARP_aM_at_521_6 ARP_aM_at_522_6 ARP_aM_at_523_6 ARP_aM_at_524_6 ARP_aM_at_525_6 ARP_aM_at_526_6 ARP_aM_at_527_6 ARP_aM_at_528_6 ARP_aM_at_529_6 ARP_aM_at_530_6 ARP_aM_at_531_6 ARP_aM_af_50_6 ARP_aM_af_51_6 ARP_aM_af_52_6 ARP_aM_af_53_6 ARP_aM_af_54_6 ARP_aM_af_55_6 ARP_aM_af_56_6 ARP_aM_af_57_6 ARP_aM_af_58_6 ARP_aM_af_59_6 ARP_aM_af_510_6 ARP_aM_af_511_6 ARP_aM_af_512_6 ARP_aM_af_513_6 ARP_aM_af_514_6 ARP_aM_af_515_6 ARP_aM_af_516_6 ARP_aM_af_517_6 ARP_aM_af_518_6 ARP_aM_af_519_6 ARP_aM_af_520_6 ARP_aM_af_521_6 ARP_aM_af_522_6 ARP_aM_af_523_6 ARP_aM_af_524_6 ARP_aM_af_525_6 ARP_aM_af_526_6 ARP_aM_af_527_6 ARP_aM_af_528_6 ARP_aM_af_529_6 ARP_aM_af_530_6 ARP_aM_af_531_6 ARP_aM_aa Po_at_50_6 Po_at_51_6 Po_at_52_6 Po_at_53_6 Po_at_54_6 Po_at_55_6 Po_at_56_6 Po_at_57_6 Po_at_58_6 Po_at_59_6 Po_at_510_6 Po_at_511_6 Po_at_512_6 Po_at_513_6 Po_at_514_6 Po_at_515_6 Po_at_516_6 Po_at_517_6 Po_at_518_6 Po_at_519_6 Po_at_520_6 Po_at_521_6 Po_at_522_6 Po_at_523_6 Po_at_524_6 Po_at_525_6 Po_at_526_6 Po_at_527_6 Po_at_528_6 Po_at_529_6 Po_at_530_6 Po_at_531_6 Po_af_50_6 Po_af_51_6 Po_af_52_6 Po_af_53_6 Po_af_54_6 Po_af_55_6 Po_af_56_6 Po_af_57_6 Po_af_58_6 Po_af_59_6 Po_af_510_6 Po_af_511_6 Po_af_512_6 Po_af_513_6 Po_af_514_6 Po_af_515_6 Po_af_516_6 Po_af_517_6 Po_af_518_6 Po_af_519_6 Po_af_520_6 Po_af_521_6 Po_af_522_6 Po_af_523_6 Po_af_524_6 Po_af_525_6 Po_af_526_6 Po_af_527_6 Po_af_528_6 Po_af_529_6 Po_af_530_6 Po_af_531_6 Po_aa Arb
xCRT1 reset C1i_at_50_6 C1i_at_51_6 C1i_at_52_6 C1i_at_53_6 C1i_at_54_6 C1i_at_55_6 C1i_at_56_6 C1i_at_57_6 C1i_at_58_6 C1i_at_59_6 C1i_at_510_6 C1i_at_511_6 C1i_at_512_6 C1i_at_513_6 C1i_at_514_6 C1i_at_515_6 C1i_at_516_6 C1i_at_517_6 C1i_at_518_6 C1i_at_519_6 C1i_at_520_6 C1i_at_521_6 C1i_at_522_6 C1i_at_523_6 C1i_at_524_6 C1i_at_525_6 C1i_at_526_6 C1i_at_527_6 C1i_at_528_6 C1i_at_529_6 C1i_at_530_6 C1i_at_531_6 C1i_af_50_6 C1i_af_51_6 C1i_af_52_6 C1i_af_53_6 C1i_af_54_6 C1i_af_55_6 C1i_af_56_6 C1i_af_57_6 C1i_af_58_6 C1i_af_59_6 C1i_af_510_6 C1i_af_511_6 C1i_af_512_6 C1i_af_513_6 C1i_af_514_6 C1i_af_515_6 C1i_af_516_6 C1i_af_517_6 C1i_af_518_6 C1i_af_519_6 C1i_af_520_6 C1i_af_521_6 C1i_af_522_6 C1i_af_523_6 C1i_af_524_6 C1i_af_525_6 C1i_af_526_6 C1i_af_527_6 C1i_af_528_6 C1i_af_529_6 C1i_af_530_6 C1i_af_531_6 C1i_aa ARM_aC1_at_50_6 ARM_aC1_at_51_6 ARM_aC1_at_52_6 ARM_aC1_at_53_6 ARM_aC1_at_54_6 ARM_aC1_at_55_6 ARM_aC1_at_56_6 ARM_aC1_at_57_6 ARM_aC1_at_58_6 ARM_aC1_at_59_6 ARM_aC1_at_510_6 ARM_aC1_at_511_6 ARM_aC1_at_512_6 ARM_aC1_at_513_6 ARM_aC1_at_514_6 ARM_aC1_at_515_6 ARM_aC1_at_516_6 ARM_aC1_at_517_6 ARM_aC1_at_518_6 ARM_aC1_at_519_6 ARM_aC1_at_520_6 ARM_aC1_at_521_6 ARM_aC1_at_522_6 ARM_aC1_at_523_6 ARM_aC1_at_524_6 ARM_aC1_at_525_6 ARM_aC1_at_526_6 ARM_aC1_at_527_6 ARM_aC1_at_528_6 ARM_aC1_at_529_6 ARM_aC1_at_530_6 ARM_aC1_at_531_6 ARM_aC1_af_50_6 ARM_aC1_af_51_6 ARM_aC1_af_52_6 ARM_aC1_af_53_6 ARM_aC1_af_54_6 ARM_aC1_af_55_6 ARM_aC1_af_56_6 ARM_aC1_af_57_6 ARM_aC1_af_58_6 ARM_aC1_af_59_6 ARM_aC1_af_510_6 ARM_aC1_af_511_6 ARM_aC1_af_512_6 ARM_aC1_af_513_6 ARM_aC1_af_514_6 ARM_aC1_af_515_6 ARM_aC1_af_516_6 ARM_aC1_af_517_6 ARM_aC1_af_518_6 ARM_aC1_af_519_6 ARM_aC1_af_520_6 ARM_aC1_af_521_6 ARM_aC1_af_522_6 ARM_aC1_af_523_6 ARM_aC1_af_524_6 ARM_aC1_af_525_6 ARM_aC1_af_526_6 ARM_aC1_af_527_6 ARM_aC1_af_528_6 ARM_aC1_af_529_6 ARM_aC1_af_530_6 ARM_aC1_af_531_6 ARM_aC1_aa ARP_aC1_at_50_6 ARP_aC1_at_51_6 ARP_aC1_at_52_6 ARP_aC1_at_53_6 ARP_aC1_at_54_6 ARP_aC1_at_55_6 ARP_aC1_at_56_6 ARP_aC1_at_57_6 ARP_aC1_at_58_6 ARP_aC1_at_59_6 ARP_aC1_at_510_6 ARP_aC1_at_511_6 ARP_aC1_at_512_6 ARP_aC1_at_513_6 ARP_aC1_at_514_6 ARP_aC1_at_515_6 ARP_aC1_at_516_6 ARP_aC1_at_517_6 ARP_aC1_at_518_6 ARP_aC1_at_519_6 ARP_aC1_at_520_6 ARP_aC1_at_521_6 ARP_aC1_at_522_6 ARP_aC1_at_523_6 ARP_aC1_at_524_6 ARP_aC1_at_525_6 ARP_aC1_at_526_6 ARP_aC1_at_527_6 ARP_aC1_at_528_6 ARP_aC1_at_529_6 ARP_aC1_at_530_6 ARP_aC1_at_531_6 ARP_aC1_af_50_6 ARP_aC1_af_51_6 ARP_aC1_af_52_6 ARP_aC1_af_53_6 ARP_aC1_af_54_6 ARP_aC1_af_55_6 ARP_aC1_af_56_6 ARP_aC1_af_57_6 ARP_aC1_af_58_6 ARP_aC1_af_59_6 ARP_aC1_af_510_6 ARP_aC1_af_511_6 ARP_aC1_af_512_6 ARP_aC1_af_513_6 ARP_aC1_af_514_6 ARP_aC1_af_515_6 ARP_aC1_af_516_6 ARP_aC1_af_517_6 ARP_aC1_af_518_6 ARP_aC1_af_519_6 ARP_aC1_af_520_6 ARP_aC1_af_521_6 ARP_aC1_af_522_6 ARP_aC1_af_523_6 ARP_aC1_af_524_6 ARP_aC1_af_525_6 ARP_aC1_af_526_6 ARP_aC1_af_527_6 ARP_aC1_af_528_6 ARP_aC1_af_529_6 ARP_aC1_af_530_6 ARP_aC1_af_531_6 ARP_aC1_aa ARC0_aC1_at_50_6 ARC0_aC1_at_51_6 ARC0_aC1_at_52_6 ARC0_aC1_at_53_6 ARC0_aC1_at_54_6 ARC0_aC1_at_55_6 ARC0_aC1_at_56_6 ARC0_aC1_at_57_6 ARC0_aC1_at_58_6 ARC0_aC1_at_59_6 ARC0_aC1_at_510_6 ARC0_aC1_at_511_6 ARC0_aC1_at_512_6 ARC0_aC1_at_513_6 ARC0_aC1_at_514_6 ARC0_aC1_at_515_6 ARC0_aC1_at_516_6 ARC0_aC1_at_517_6 ARC0_aC1_at_518_6 ARC0_aC1_at_519_6 ARC0_aC1_at_520_6 ARC0_aC1_at_521_6 ARC0_aC1_at_522_6 ARC0_aC1_at_523_6 ARC0_aC1_at_524_6 ARC0_aC1_at_525_6 ARC0_aC1_at_526_6 ARC0_aC1_at_527_6 ARC0_aC1_at_528_6 ARC0_aC1_at_529_6 ARC0_aC1_at_530_6 ARC0_aC1_at_531_6 ARC0_aC1_af_50_6 ARC0_aC1_af_51_6 ARC0_aC1_af_52_6 ARC0_aC1_af_53_6 ARC0_aC1_af_54_6 ARC0_aC1_af_55_6 ARC0_aC1_af_56_6 ARC0_aC1_af_57_6 ARC0_aC1_af_58_6 ARC0_aC1_af_59_6 ARC0_aC1_af_510_6 ARC0_aC1_af_511_6 ARC0_aC1_af_512_6 ARC0_aC1_af_513_6 ARC0_aC1_af_514_6 ARC0_aC1_af_515_6 ARC0_aC1_af_516_6 ARC0_aC1_af_517_6 ARC0_aC1_af_518_6 ARC0_aC1_af_519_6 ARC0_aC1_af_520_6 ARC0_aC1_af_521_6 ARC0_aC1_af_522_6 ARC0_aC1_af_523_6 ARC0_aC1_af_524_6 ARC0_aC1_af_525_6 ARC0_aC1_af_526_6 ARC0_aC1_af_527_6 ARC0_aC1_af_528_6 ARC0_aC1_af_529_6 ARC0_aC1_af_530_6 ARC0_aC1_af_531_6 ARC0_aC1_aa ARC1_aC1_at_50_6 ARC1_aC1_at_51_6 ARC1_aC1_at_52_6 ARC1_aC1_at_53_6 ARC1_aC1_at_54_6 ARC1_aC1_at_55_6 ARC1_aC1_at_56_6 ARC1_aC1_at_57_6 ARC1_aC1_at_58_6 ARC1_aC1_at_59_6 ARC1_aC1_at_510_6 ARC1_aC1_at_511_6 ARC1_aC1_at_512_6 ARC1_aC1_at_513_6 ARC1_aC1_at_514_6 ARC1_aC1_at_515_6 ARC1_aC1_at_516_6 ARC1_aC1_at_517_6 ARC1_aC1_at_518_6 ARC1_aC1_at_519_6 ARC1_aC1_at_520_6 ARC1_aC1_at_521_6 ARC1_aC1_at_522_6 ARC1_aC1_at_523_6 ARC1_aC1_at_524_6 ARC1_aC1_at_525_6 ARC1_aC1_at_526_6 ARC1_aC1_at_527_6 ARC1_aC1_at_528_6 ARC1_aC1_at_529_6 ARC1_aC1_at_530_6 ARC1_aC1_at_531_6 ARC1_aC1_af_50_6 ARC1_aC1_af_51_6 ARC1_aC1_af_52_6 ARC1_aC1_af_53_6 ARC1_aC1_af_54_6 ARC1_aC1_af_55_6 ARC1_aC1_af_56_6 ARC1_aC1_af_57_6 ARC1_aC1_af_58_6 ARC1_aC1_af_59_6 ARC1_aC1_af_510_6 ARC1_aC1_af_511_6 ARC1_aC1_af_512_6 ARC1_aC1_af_513_6 ARC1_aC1_af_514_6 ARC1_aC1_af_515_6 ARC1_aC1_af_516_6 ARC1_aC1_af_517_6 ARC1_aC1_af_518_6 ARC1_aC1_af_519_6 ARC1_aC1_af_520_6 ARC1_aC1_af_521_6 ARC1_aC1_af_522_6 ARC1_aC1_af_523_6 ARC1_aC1_af_524_6 ARC1_aC1_af_525_6 ARC1_aC1_af_526_6 ARC1_aC1_af_527_6 ARC1_aC1_af_528_6 ARC1_aC1_af_529_6 ARC1_aC1_af_530_6 ARC1_aC1_af_531_6 ARC1_aC1_aa ARC2_aC1_at_50_6 ARC2_aC1_at_51_6 ARC2_aC1_at_52_6 ARC2_aC1_at_53_6 ARC2_aC1_at_54_6 ARC2_aC1_at_55_6 ARC2_aC1_at_56_6 ARC2_aC1_at_57_6 ARC2_aC1_at_58_6 ARC2_aC1_at_59_6 ARC2_aC1_at_510_6 ARC2_aC1_at_511_6 ARC2_aC1_at_512_6 ARC2_aC1_at_513_6 ARC2_aC1_at_514_6 ARC2_aC1_at_515_6 ARC2_aC1_at_516_6 ARC2_aC1_at_517_6 ARC2_aC1_at_518_6 ARC2_aC1_at_519_6 ARC2_aC1_at_520_6 ARC2_aC1_at_521_6 ARC2_aC1_at_522_6 ARC2_aC1_at_523_6 ARC2_aC1_at_524_6 ARC2_aC1_at_525_6 ARC2_aC1_at_526_6 ARC2_aC1_at_527_6 ARC2_aC1_at_528_6 ARC2_aC1_at_529_6 ARC2_aC1_at_530_6 ARC2_aC1_at_531_6 ARC2_aC1_af_50_6 ARC2_aC1_af_51_6 ARC2_aC1_af_52_6 ARC2_aC1_af_53_6 ARC2_aC1_af_54_6 ARC2_aC1_af_55_6 ARC2_aC1_af_56_6 ARC2_aC1_af_57_6 ARC2_aC1_af_58_6 ARC2_aC1_af_59_6 ARC2_aC1_af_510_6 ARC2_aC1_af_511_6 ARC2_aC1_af_512_6 ARC2_aC1_af_513_6 ARC2_aC1_af_514_6 ARC2_aC1_af_515_6 ARC2_aC1_af_516_6 ARC2_aC1_af_517_6 ARC2_aC1_af_518_6 ARC2_aC1_af_519_6 ARC2_aC1_af_520_6 ARC2_aC1_af_521_6 ARC2_aC1_af_522_6 ARC2_aC1_af_523_6 ARC2_aC1_af_524_6 ARC2_aC1_af_525_6 ARC2_aC1_af_526_6 ARC2_aC1_af_527_6 ARC2_aC1_af_528_6 ARC2_aC1_af_529_6 ARC2_aC1_af_530_6 ARC2_aC1_af_531_6 ARC2_aC1_aa ARC3_aC1_at_50_6 ARC3_aC1_at_51_6 ARC3_aC1_at_52_6 ARC3_aC1_at_53_6 ARC3_aC1_at_54_6 ARC3_aC1_at_55_6 ARC3_aC1_at_56_6 ARC3_aC1_at_57_6 ARC3_aC1_at_58_6 ARC3_aC1_at_59_6 ARC3_aC1_at_510_6 ARC3_aC1_at_511_6 ARC3_aC1_at_512_6 ARC3_aC1_at_513_6 ARC3_aC1_at_514_6 ARC3_aC1_at_515_6 ARC3_aC1_at_516_6 ARC3_aC1_at_517_6 ARC3_aC1_at_518_6 ARC3_aC1_at_519_6 ARC3_aC1_at_520_6 ARC3_aC1_at_521_6 ARC3_aC1_at_522_6 ARC3_aC1_at_523_6 ARC3_aC1_at_524_6 ARC3_aC1_at_525_6 ARC3_aC1_at_526_6 ARC3_aC1_at_527_6 ARC3_aC1_at_528_6 ARC3_aC1_at_529_6 ARC3_aC1_at_530_6 ARC3_aC1_at_531_6 ARC3_aC1_af_50_6 ARC3_aC1_af_51_6 ARC3_aC1_af_52_6 ARC3_aC1_af_53_6 ARC3_aC1_af_54_6 ARC3_aC1_af_55_6 ARC3_aC1_af_56_6 ARC3_aC1_af_57_6 ARC3_aC1_af_58_6 ARC3_aC1_af_59_6 ARC3_aC1_af_510_6 ARC3_aC1_af_511_6 ARC3_aC1_af_512_6 ARC3_aC1_af_513_6 ARC3_aC1_af_514_6 ARC3_aC1_af_515_6 ARC3_aC1_af_516_6 ARC3_aC1_af_517_6 ARC3_aC1_af_518_6 ARC3_aC1_af_519_6 ARC3_aC1_af_520_6 ARC3_aC1_af_521_6 ARC3_aC1_af_522_6 ARC3_aC1_af_523_6 ARC3_aC1_af_524_6 ARC3_aC1_af_525_6 ARC3_aC1_af_526_6 ARC3_aC1_af_527_6 ARC3_aC1_af_528_6 ARC3_aC1_af_529_6 ARC3_aC1_af_530_6 ARC3_aC1_af_531_6 ARC3_aC1_aa ChildRouter
xARC0 reset ARC0_aC0_at_50_6 ARC0_aC0_at_51_6 ARC0_aC0_at_52_6 ARC0_aC0_at_53_6 ARC0_aC0_at_54_6 ARC0_aC0_at_55_6 ARC0_aC0_at_56_6 ARC0_aC0_at_57_6 ARC0_aC0_at_58_6 ARC0_aC0_at_59_6 ARC0_aC0_at_510_6 ARC0_aC0_at_511_6 ARC0_aC0_at_512_6 ARC0_aC0_at_513_6 ARC0_aC0_at_514_6 ARC0_aC0_at_515_6 ARC0_aC0_at_516_6 ARC0_aC0_at_517_6 ARC0_aC0_at_518_6 ARC0_aC0_at_519_6 ARC0_aC0_at_520_6 ARC0_aC0_at_521_6 ARC0_aC0_at_522_6 ARC0_aC0_at_523_6 ARC0_aC0_at_524_6 ARC0_aC0_at_525_6 ARC0_aC0_at_526_6 ARC0_aC0_at_527_6 ARC0_aC0_at_528_6 ARC0_aC0_at_529_6 ARC0_aC0_at_530_6 ARC0_aC0_at_531_6 ARC0_aC0_af_50_6 ARC0_aC0_af_51_6 ARC0_aC0_af_52_6 ARC0_aC0_af_53_6 ARC0_aC0_af_54_6 ARC0_aC0_af_55_6 ARC0_aC0_af_56_6 ARC0_aC0_af_57_6 ARC0_aC0_af_58_6 ARC0_aC0_af_59_6 ARC0_aC0_af_510_6 ARC0_aC0_af_511_6 ARC0_aC0_af_512_6 ARC0_aC0_af_513_6 ARC0_aC0_af_514_6 ARC0_aC0_af_515_6 ARC0_aC0_af_516_6 ARC0_aC0_af_517_6 ARC0_aC0_af_518_6 ARC0_aC0_af_519_6 ARC0_aC0_af_520_6 ARC0_aC0_af_521_6 ARC0_aC0_af_522_6 ARC0_aC0_af_523_6 ARC0_aC0_af_524_6 ARC0_aC0_af_525_6 ARC0_aC0_af_526_6 ARC0_aC0_af_527_6 ARC0_aC0_af_528_6 ARC0_aC0_af_529_6 ARC0_aC0_af_530_6 ARC0_aC0_af_531_6 ARC0_aC0_aa ARC0_aC1_at_50_6 ARC0_aC1_at_51_6 ARC0_aC1_at_52_6 ARC0_aC1_at_53_6 ARC0_aC1_at_54_6 ARC0_aC1_at_55_6 ARC0_aC1_at_56_6 ARC0_aC1_at_57_6 ARC0_aC1_at_58_6 ARC0_aC1_at_59_6 ARC0_aC1_at_510_6 ARC0_aC1_at_511_6 ARC0_aC1_at_512_6 ARC0_aC1_at_513_6 ARC0_aC1_at_514_6 ARC0_aC1_at_515_6 ARC0_aC1_at_516_6 ARC0_aC1_at_517_6 ARC0_aC1_at_518_6 ARC0_aC1_at_519_6 ARC0_aC1_at_520_6 ARC0_aC1_at_521_6 ARC0_aC1_at_522_6 ARC0_aC1_at_523_6 ARC0_aC1_at_524_6 ARC0_aC1_at_525_6 ARC0_aC1_at_526_6 ARC0_aC1_at_527_6 ARC0_aC1_at_528_6 ARC0_aC1_at_529_6 ARC0_aC1_at_530_6 ARC0_aC1_at_531_6 ARC0_aC1_af_50_6 ARC0_aC1_af_51_6 ARC0_aC1_af_52_6 ARC0_aC1_af_53_6 ARC0_aC1_af_54_6 ARC0_aC1_af_55_6 ARC0_aC1_af_56_6 ARC0_aC1_af_57_6 ARC0_aC1_af_58_6 ARC0_aC1_af_59_6 ARC0_aC1_af_510_6 ARC0_aC1_af_511_6 ARC0_aC1_af_512_6 ARC0_aC1_af_513_6 ARC0_aC1_af_514_6 ARC0_aC1_af_515_6 ARC0_aC1_af_516_6 ARC0_aC1_af_517_6 ARC0_aC1_af_518_6 ARC0_aC1_af_519_6 ARC0_aC1_af_520_6 ARC0_aC1_af_521_6 ARC0_aC1_af_522_6 ARC0_aC1_af_523_6 ARC0_aC1_af_524_6 ARC0_aC1_af_525_6 ARC0_aC1_af_526_6 ARC0_aC1_af_527_6 ARC0_aC1_af_528_6 ARC0_aC1_af_529_6 ARC0_aC1_af_530_6 ARC0_aC1_af_531_6 ARC0_aC1_aa ARC0_aC2_at_50_6 ARC0_aC2_at_51_6 ARC0_aC2_at_52_6 ARC0_aC2_at_53_6 ARC0_aC2_at_54_6 ARC0_aC2_at_55_6 ARC0_aC2_at_56_6 ARC0_aC2_at_57_6 ARC0_aC2_at_58_6 ARC0_aC2_at_59_6 ARC0_aC2_at_510_6 ARC0_aC2_at_511_6 ARC0_aC2_at_512_6 ARC0_aC2_at_513_6 ARC0_aC2_at_514_6 ARC0_aC2_at_515_6 ARC0_aC2_at_516_6 ARC0_aC2_at_517_6 ARC0_aC2_at_518_6 ARC0_aC2_at_519_6 ARC0_aC2_at_520_6 ARC0_aC2_at_521_6 ARC0_aC2_at_522_6 ARC0_aC2_at_523_6 ARC0_aC2_at_524_6 ARC0_aC2_at_525_6 ARC0_aC2_at_526_6 ARC0_aC2_at_527_6 ARC0_aC2_at_528_6 ARC0_aC2_at_529_6 ARC0_aC2_at_530_6 ARC0_aC2_at_531_6 ARC0_aC2_af_50_6 ARC0_aC2_af_51_6 ARC0_aC2_af_52_6 ARC0_aC2_af_53_6 ARC0_aC2_af_54_6 ARC0_aC2_af_55_6 ARC0_aC2_af_56_6 ARC0_aC2_af_57_6 ARC0_aC2_af_58_6 ARC0_aC2_af_59_6 ARC0_aC2_af_510_6 ARC0_aC2_af_511_6 ARC0_aC2_af_512_6 ARC0_aC2_af_513_6 ARC0_aC2_af_514_6 ARC0_aC2_af_515_6 ARC0_aC2_af_516_6 ARC0_aC2_af_517_6 ARC0_aC2_af_518_6 ARC0_aC2_af_519_6 ARC0_aC2_af_520_6 ARC0_aC2_af_521_6 ARC0_aC2_af_522_6 ARC0_aC2_af_523_6 ARC0_aC2_af_524_6 ARC0_aC2_af_525_6 ARC0_aC2_af_526_6 ARC0_aC2_af_527_6 ARC0_aC2_af_528_6 ARC0_aC2_af_529_6 ARC0_aC2_af_530_6 ARC0_aC2_af_531_6 ARC0_aC2_aa ARC0_aC3_at_50_6 ARC0_aC3_at_51_6 ARC0_aC3_at_52_6 ARC0_aC3_at_53_6 ARC0_aC3_at_54_6 ARC0_aC3_at_55_6 ARC0_aC3_at_56_6 ARC0_aC3_at_57_6 ARC0_aC3_at_58_6 ARC0_aC3_at_59_6 ARC0_aC3_at_510_6 ARC0_aC3_at_511_6 ARC0_aC3_at_512_6 ARC0_aC3_at_513_6 ARC0_aC3_at_514_6 ARC0_aC3_at_515_6 ARC0_aC3_at_516_6 ARC0_aC3_at_517_6 ARC0_aC3_at_518_6 ARC0_aC3_at_519_6 ARC0_aC3_at_520_6 ARC0_aC3_at_521_6 ARC0_aC3_at_522_6 ARC0_aC3_at_523_6 ARC0_aC3_at_524_6 ARC0_aC3_at_525_6 ARC0_aC3_at_526_6 ARC0_aC3_at_527_6 ARC0_aC3_at_528_6 ARC0_aC3_at_529_6 ARC0_aC3_at_530_6 ARC0_aC3_at_531_6 ARC0_aC3_af_50_6 ARC0_aC3_af_51_6 ARC0_aC3_af_52_6 ARC0_aC3_af_53_6 ARC0_aC3_af_54_6 ARC0_aC3_af_55_6 ARC0_aC3_af_56_6 ARC0_aC3_af_57_6 ARC0_aC3_af_58_6 ARC0_aC3_af_59_6 ARC0_aC3_af_510_6 ARC0_aC3_af_511_6 ARC0_aC3_af_512_6 ARC0_aC3_af_513_6 ARC0_aC3_af_514_6 ARC0_aC3_af_515_6 ARC0_aC3_af_516_6 ARC0_aC3_af_517_6 ARC0_aC3_af_518_6 ARC0_aC3_af_519_6 ARC0_aC3_af_520_6 ARC0_aC3_af_521_6 ARC0_aC3_af_522_6 ARC0_aC3_af_523_6 ARC0_aC3_af_524_6 ARC0_aC3_af_525_6 ARC0_aC3_af_526_6 ARC0_aC3_af_527_6 ARC0_aC3_af_528_6 ARC0_aC3_af_529_6 ARC0_aC3_af_530_6 ARC0_aC3_af_531_6 ARC0_aC3_aa PRT_aC0_at_50_6 PRT_aC0_at_51_6 PRT_aC0_at_52_6 PRT_aC0_at_53_6 PRT_aC0_at_54_6 PRT_aC0_at_55_6 PRT_aC0_at_56_6 PRT_aC0_at_57_6 PRT_aC0_at_58_6 PRT_aC0_at_59_6 PRT_aC0_at_510_6 PRT_aC0_at_511_6 PRT_aC0_at_512_6 PRT_aC0_at_513_6 PRT_aC0_at_514_6 PRT_aC0_at_515_6 PRT_aC0_at_516_6 PRT_aC0_at_517_6 PRT_aC0_at_518_6 PRT_aC0_at_519_6 PRT_aC0_at_520_6 PRT_aC0_at_521_6 PRT_aC0_at_522_6 PRT_aC0_at_523_6 PRT_aC0_at_524_6 PRT_aC0_at_525_6 PRT_aC0_at_526_6 PRT_aC0_at_527_6 PRT_aC0_at_528_6 PRT_aC0_at_529_6 PRT_aC0_at_530_6 PRT_aC0_at_531_6 PRT_aC0_af_50_6 PRT_aC0_af_51_6 PRT_aC0_af_52_6 PRT_aC0_af_53_6 PRT_aC0_af_54_6 PRT_aC0_af_55_6 PRT_aC0_af_56_6 PRT_aC0_af_57_6 PRT_aC0_af_58_6 PRT_aC0_af_59_6 PRT_aC0_af_510_6 PRT_aC0_af_511_6 PRT_aC0_af_512_6 PRT_aC0_af_513_6 PRT_aC0_af_514_6 PRT_aC0_af_515_6 PRT_aC0_af_516_6 PRT_aC0_af_517_6 PRT_aC0_af_518_6 PRT_aC0_af_519_6 PRT_aC0_af_520_6 PRT_aC0_af_521_6 PRT_aC0_af_522_6 PRT_aC0_af_523_6 PRT_aC0_af_524_6 PRT_aC0_af_525_6 PRT_aC0_af_526_6 PRT_aC0_af_527_6 PRT_aC0_af_528_6 PRT_aC0_af_529_6 PRT_aC0_af_530_6 PRT_aC0_af_531_6 PRT_aC0_aa MU_aC0_at_50_6 MU_aC0_at_51_6 MU_aC0_at_52_6 MU_aC0_at_53_6 MU_aC0_at_54_6 MU_aC0_at_55_6 MU_aC0_at_56_6 MU_aC0_at_57_6 MU_aC0_at_58_6 MU_aC0_at_59_6 MU_aC0_at_510_6 MU_aC0_at_511_6 MU_aC0_at_512_6 MU_aC0_at_513_6 MU_aC0_at_514_6 MU_aC0_at_515_6 MU_aC0_at_516_6 MU_aC0_at_517_6 MU_aC0_at_518_6 MU_aC0_at_519_6 MU_aC0_at_520_6 MU_aC0_at_521_6 MU_aC0_at_522_6 MU_aC0_at_523_6 MU_aC0_at_524_6 MU_aC0_at_525_6 MU_aC0_at_526_6 MU_aC0_at_527_6 MU_aC0_at_528_6 MU_aC0_at_529_6 MU_aC0_at_530_6 MU_aC0_at_531_6 MU_aC0_af_50_6 MU_aC0_af_51_6 MU_aC0_af_52_6 MU_aC0_af_53_6 MU_aC0_af_54_6 MU_aC0_af_55_6 MU_aC0_af_56_6 MU_aC0_af_57_6 MU_aC0_af_58_6 MU_aC0_af_59_6 MU_aC0_af_510_6 MU_aC0_af_511_6 MU_aC0_af_512_6 MU_aC0_af_513_6 MU_aC0_af_514_6 MU_aC0_af_515_6 MU_aC0_af_516_6 MU_aC0_af_517_6 MU_aC0_af_518_6 MU_aC0_af_519_6 MU_aC0_af_520_6 MU_aC0_af_521_6 MU_aC0_af_522_6 MU_aC0_af_523_6 MU_aC0_af_524_6 MU_aC0_af_525_6 MU_aC0_af_526_6 MU_aC0_af_527_6 MU_aC0_af_528_6 MU_aC0_af_529_6 MU_aC0_af_530_6 MU_aC0_af_531_6 MU_aC0_aa C0o_at_50_6 C0o_at_51_6 C0o_at_52_6 C0o_at_53_6 C0o_at_54_6 C0o_at_55_6 C0o_at_56_6 C0o_at_57_6 C0o_at_58_6 C0o_at_59_6 C0o_at_510_6 C0o_at_511_6 C0o_at_512_6 C0o_at_513_6 C0o_at_514_6 C0o_at_515_6 C0o_at_516_6 C0o_at_517_6 C0o_at_518_6 C0o_at_519_6 C0o_at_520_6 C0o_at_521_6 C0o_at_522_6 C0o_at_523_6 C0o_at_524_6 C0o_at_525_6 C0o_at_526_6 C0o_at_527_6 C0o_at_528_6 C0o_at_529_6 C0o_at_530_6 C0o_at_531_6 C0o_af_50_6 C0o_af_51_6 C0o_af_52_6 C0o_af_53_6 C0o_af_54_6 C0o_af_55_6 C0o_af_56_6 C0o_af_57_6 C0o_af_58_6 C0o_af_59_6 C0o_af_510_6 C0o_af_511_6 C0o_af_512_6 C0o_af_513_6 C0o_af_514_6 C0o_af_515_6 C0o_af_516_6 C0o_af_517_6 C0o_af_518_6 C0o_af_519_6 C0o_af_520_6 C0o_af_521_6 C0o_af_522_6 C0o_af_523_6 C0o_af_524_6 C0o_af_525_6 C0o_af_526_6 C0o_af_527_6 C0o_af_528_6 C0o_af_529_6 C0o_af_530_6 C0o_af_531_6 C0o_aa Arb
xARC2 reset ARC2_aC0_at_50_6 ARC2_aC0_at_51_6 ARC2_aC0_at_52_6 ARC2_aC0_at_53_6 ARC2_aC0_at_54_6 ARC2_aC0_at_55_6 ARC2_aC0_at_56_6 ARC2_aC0_at_57_6 ARC2_aC0_at_58_6 ARC2_aC0_at_59_6 ARC2_aC0_at_510_6 ARC2_aC0_at_511_6 ARC2_aC0_at_512_6 ARC2_aC0_at_513_6 ARC2_aC0_at_514_6 ARC2_aC0_at_515_6 ARC2_aC0_at_516_6 ARC2_aC0_at_517_6 ARC2_aC0_at_518_6 ARC2_aC0_at_519_6 ARC2_aC0_at_520_6 ARC2_aC0_at_521_6 ARC2_aC0_at_522_6 ARC2_aC0_at_523_6 ARC2_aC0_at_524_6 ARC2_aC0_at_525_6 ARC2_aC0_at_526_6 ARC2_aC0_at_527_6 ARC2_aC0_at_528_6 ARC2_aC0_at_529_6 ARC2_aC0_at_530_6 ARC2_aC0_at_531_6 ARC2_aC0_af_50_6 ARC2_aC0_af_51_6 ARC2_aC0_af_52_6 ARC2_aC0_af_53_6 ARC2_aC0_af_54_6 ARC2_aC0_af_55_6 ARC2_aC0_af_56_6 ARC2_aC0_af_57_6 ARC2_aC0_af_58_6 ARC2_aC0_af_59_6 ARC2_aC0_af_510_6 ARC2_aC0_af_511_6 ARC2_aC0_af_512_6 ARC2_aC0_af_513_6 ARC2_aC0_af_514_6 ARC2_aC0_af_515_6 ARC2_aC0_af_516_6 ARC2_aC0_af_517_6 ARC2_aC0_af_518_6 ARC2_aC0_af_519_6 ARC2_aC0_af_520_6 ARC2_aC0_af_521_6 ARC2_aC0_af_522_6 ARC2_aC0_af_523_6 ARC2_aC0_af_524_6 ARC2_aC0_af_525_6 ARC2_aC0_af_526_6 ARC2_aC0_af_527_6 ARC2_aC0_af_528_6 ARC2_aC0_af_529_6 ARC2_aC0_af_530_6 ARC2_aC0_af_531_6 ARC2_aC0_aa ARC2_aC1_at_50_6 ARC2_aC1_at_51_6 ARC2_aC1_at_52_6 ARC2_aC1_at_53_6 ARC2_aC1_at_54_6 ARC2_aC1_at_55_6 ARC2_aC1_at_56_6 ARC2_aC1_at_57_6 ARC2_aC1_at_58_6 ARC2_aC1_at_59_6 ARC2_aC1_at_510_6 ARC2_aC1_at_511_6 ARC2_aC1_at_512_6 ARC2_aC1_at_513_6 ARC2_aC1_at_514_6 ARC2_aC1_at_515_6 ARC2_aC1_at_516_6 ARC2_aC1_at_517_6 ARC2_aC1_at_518_6 ARC2_aC1_at_519_6 ARC2_aC1_at_520_6 ARC2_aC1_at_521_6 ARC2_aC1_at_522_6 ARC2_aC1_at_523_6 ARC2_aC1_at_524_6 ARC2_aC1_at_525_6 ARC2_aC1_at_526_6 ARC2_aC1_at_527_6 ARC2_aC1_at_528_6 ARC2_aC1_at_529_6 ARC2_aC1_at_530_6 ARC2_aC1_at_531_6 ARC2_aC1_af_50_6 ARC2_aC1_af_51_6 ARC2_aC1_af_52_6 ARC2_aC1_af_53_6 ARC2_aC1_af_54_6 ARC2_aC1_af_55_6 ARC2_aC1_af_56_6 ARC2_aC1_af_57_6 ARC2_aC1_af_58_6 ARC2_aC1_af_59_6 ARC2_aC1_af_510_6 ARC2_aC1_af_511_6 ARC2_aC1_af_512_6 ARC2_aC1_af_513_6 ARC2_aC1_af_514_6 ARC2_aC1_af_515_6 ARC2_aC1_af_516_6 ARC2_aC1_af_517_6 ARC2_aC1_af_518_6 ARC2_aC1_af_519_6 ARC2_aC1_af_520_6 ARC2_aC1_af_521_6 ARC2_aC1_af_522_6 ARC2_aC1_af_523_6 ARC2_aC1_af_524_6 ARC2_aC1_af_525_6 ARC2_aC1_af_526_6 ARC2_aC1_af_527_6 ARC2_aC1_af_528_6 ARC2_aC1_af_529_6 ARC2_aC1_af_530_6 ARC2_aC1_af_531_6 ARC2_aC1_aa ARC2_aC2_at_50_6 ARC2_aC2_at_51_6 ARC2_aC2_at_52_6 ARC2_aC2_at_53_6 ARC2_aC2_at_54_6 ARC2_aC2_at_55_6 ARC2_aC2_at_56_6 ARC2_aC2_at_57_6 ARC2_aC2_at_58_6 ARC2_aC2_at_59_6 ARC2_aC2_at_510_6 ARC2_aC2_at_511_6 ARC2_aC2_at_512_6 ARC2_aC2_at_513_6 ARC2_aC2_at_514_6 ARC2_aC2_at_515_6 ARC2_aC2_at_516_6 ARC2_aC2_at_517_6 ARC2_aC2_at_518_6 ARC2_aC2_at_519_6 ARC2_aC2_at_520_6 ARC2_aC2_at_521_6 ARC2_aC2_at_522_6 ARC2_aC2_at_523_6 ARC2_aC2_at_524_6 ARC2_aC2_at_525_6 ARC2_aC2_at_526_6 ARC2_aC2_at_527_6 ARC2_aC2_at_528_6 ARC2_aC2_at_529_6 ARC2_aC2_at_530_6 ARC2_aC2_at_531_6 ARC2_aC2_af_50_6 ARC2_aC2_af_51_6 ARC2_aC2_af_52_6 ARC2_aC2_af_53_6 ARC2_aC2_af_54_6 ARC2_aC2_af_55_6 ARC2_aC2_af_56_6 ARC2_aC2_af_57_6 ARC2_aC2_af_58_6 ARC2_aC2_af_59_6 ARC2_aC2_af_510_6 ARC2_aC2_af_511_6 ARC2_aC2_af_512_6 ARC2_aC2_af_513_6 ARC2_aC2_af_514_6 ARC2_aC2_af_515_6 ARC2_aC2_af_516_6 ARC2_aC2_af_517_6 ARC2_aC2_af_518_6 ARC2_aC2_af_519_6 ARC2_aC2_af_520_6 ARC2_aC2_af_521_6 ARC2_aC2_af_522_6 ARC2_aC2_af_523_6 ARC2_aC2_af_524_6 ARC2_aC2_af_525_6 ARC2_aC2_af_526_6 ARC2_aC2_af_527_6 ARC2_aC2_af_528_6 ARC2_aC2_af_529_6 ARC2_aC2_af_530_6 ARC2_aC2_af_531_6 ARC2_aC2_aa ARC2_aC3_at_50_6 ARC2_aC3_at_51_6 ARC2_aC3_at_52_6 ARC2_aC3_at_53_6 ARC2_aC3_at_54_6 ARC2_aC3_at_55_6 ARC2_aC3_at_56_6 ARC2_aC3_at_57_6 ARC2_aC3_at_58_6 ARC2_aC3_at_59_6 ARC2_aC3_at_510_6 ARC2_aC3_at_511_6 ARC2_aC3_at_512_6 ARC2_aC3_at_513_6 ARC2_aC3_at_514_6 ARC2_aC3_at_515_6 ARC2_aC3_at_516_6 ARC2_aC3_at_517_6 ARC2_aC3_at_518_6 ARC2_aC3_at_519_6 ARC2_aC3_at_520_6 ARC2_aC3_at_521_6 ARC2_aC3_at_522_6 ARC2_aC3_at_523_6 ARC2_aC3_at_524_6 ARC2_aC3_at_525_6 ARC2_aC3_at_526_6 ARC2_aC3_at_527_6 ARC2_aC3_at_528_6 ARC2_aC3_at_529_6 ARC2_aC3_at_530_6 ARC2_aC3_at_531_6 ARC2_aC3_af_50_6 ARC2_aC3_af_51_6 ARC2_aC3_af_52_6 ARC2_aC3_af_53_6 ARC2_aC3_af_54_6 ARC2_aC3_af_55_6 ARC2_aC3_af_56_6 ARC2_aC3_af_57_6 ARC2_aC3_af_58_6 ARC2_aC3_af_59_6 ARC2_aC3_af_510_6 ARC2_aC3_af_511_6 ARC2_aC3_af_512_6 ARC2_aC3_af_513_6 ARC2_aC3_af_514_6 ARC2_aC3_af_515_6 ARC2_aC3_af_516_6 ARC2_aC3_af_517_6 ARC2_aC3_af_518_6 ARC2_aC3_af_519_6 ARC2_aC3_af_520_6 ARC2_aC3_af_521_6 ARC2_aC3_af_522_6 ARC2_aC3_af_523_6 ARC2_aC3_af_524_6 ARC2_aC3_af_525_6 ARC2_aC3_af_526_6 ARC2_aC3_af_527_6 ARC2_aC3_af_528_6 ARC2_aC3_af_529_6 ARC2_aC3_af_530_6 ARC2_aC3_af_531_6 ARC2_aC3_aa PRT_aC2_at_50_6 PRT_aC2_at_51_6 PRT_aC2_at_52_6 PRT_aC2_at_53_6 PRT_aC2_at_54_6 PRT_aC2_at_55_6 PRT_aC2_at_56_6 PRT_aC2_at_57_6 PRT_aC2_at_58_6 PRT_aC2_at_59_6 PRT_aC2_at_510_6 PRT_aC2_at_511_6 PRT_aC2_at_512_6 PRT_aC2_at_513_6 PRT_aC2_at_514_6 PRT_aC2_at_515_6 PRT_aC2_at_516_6 PRT_aC2_at_517_6 PRT_aC2_at_518_6 PRT_aC2_at_519_6 PRT_aC2_at_520_6 PRT_aC2_at_521_6 PRT_aC2_at_522_6 PRT_aC2_at_523_6 PRT_aC2_at_524_6 PRT_aC2_at_525_6 PRT_aC2_at_526_6 PRT_aC2_at_527_6 PRT_aC2_at_528_6 PRT_aC2_at_529_6 PRT_aC2_at_530_6 PRT_aC2_at_531_6 PRT_aC2_af_50_6 PRT_aC2_af_51_6 PRT_aC2_af_52_6 PRT_aC2_af_53_6 PRT_aC2_af_54_6 PRT_aC2_af_55_6 PRT_aC2_af_56_6 PRT_aC2_af_57_6 PRT_aC2_af_58_6 PRT_aC2_af_59_6 PRT_aC2_af_510_6 PRT_aC2_af_511_6 PRT_aC2_af_512_6 PRT_aC2_af_513_6 PRT_aC2_af_514_6 PRT_aC2_af_515_6 PRT_aC2_af_516_6 PRT_aC2_af_517_6 PRT_aC2_af_518_6 PRT_aC2_af_519_6 PRT_aC2_af_520_6 PRT_aC2_af_521_6 PRT_aC2_af_522_6 PRT_aC2_af_523_6 PRT_aC2_af_524_6 PRT_aC2_af_525_6 PRT_aC2_af_526_6 PRT_aC2_af_527_6 PRT_aC2_af_528_6 PRT_aC2_af_529_6 PRT_aC2_af_530_6 PRT_aC2_af_531_6 PRT_aC2_aa MU_aC2_at_50_6 MU_aC2_at_51_6 MU_aC2_at_52_6 MU_aC2_at_53_6 MU_aC2_at_54_6 MU_aC2_at_55_6 MU_aC2_at_56_6 MU_aC2_at_57_6 MU_aC2_at_58_6 MU_aC2_at_59_6 MU_aC2_at_510_6 MU_aC2_at_511_6 MU_aC2_at_512_6 MU_aC2_at_513_6 MU_aC2_at_514_6 MU_aC2_at_515_6 MU_aC2_at_516_6 MU_aC2_at_517_6 MU_aC2_at_518_6 MU_aC2_at_519_6 MU_aC2_at_520_6 MU_aC2_at_521_6 MU_aC2_at_522_6 MU_aC2_at_523_6 MU_aC2_at_524_6 MU_aC2_at_525_6 MU_aC2_at_526_6 MU_aC2_at_527_6 MU_aC2_at_528_6 MU_aC2_at_529_6 MU_aC2_at_530_6 MU_aC2_at_531_6 MU_aC2_af_50_6 MU_aC2_af_51_6 MU_aC2_af_52_6 MU_aC2_af_53_6 MU_aC2_af_54_6 MU_aC2_af_55_6 MU_aC2_af_56_6 MU_aC2_af_57_6 MU_aC2_af_58_6 MU_aC2_af_59_6 MU_aC2_af_510_6 MU_aC2_af_511_6 MU_aC2_af_512_6 MU_aC2_af_513_6 MU_aC2_af_514_6 MU_aC2_af_515_6 MU_aC2_af_516_6 MU_aC2_af_517_6 MU_aC2_af_518_6 MU_aC2_af_519_6 MU_aC2_af_520_6 MU_aC2_af_521_6 MU_aC2_af_522_6 MU_aC2_af_523_6 MU_aC2_af_524_6 MU_aC2_af_525_6 MU_aC2_af_526_6 MU_aC2_af_527_6 MU_aC2_af_528_6 MU_aC2_af_529_6 MU_aC2_af_530_6 MU_aC2_af_531_6 MU_aC2_aa C2o_at_50_6 C2o_at_51_6 C2o_at_52_6 C2o_at_53_6 C2o_at_54_6 C2o_at_55_6 C2o_at_56_6 C2o_at_57_6 C2o_at_58_6 C2o_at_59_6 C2o_at_510_6 C2o_at_511_6 C2o_at_512_6 C2o_at_513_6 C2o_at_514_6 C2o_at_515_6 C2o_at_516_6 C2o_at_517_6 C2o_at_518_6 C2o_at_519_6 C2o_at_520_6 C2o_at_521_6 C2o_at_522_6 C2o_at_523_6 C2o_at_524_6 C2o_at_525_6 C2o_at_526_6 C2o_at_527_6 C2o_at_528_6 C2o_at_529_6 C2o_at_530_6 C2o_at_531_6 C2o_af_50_6 C2o_af_51_6 C2o_af_52_6 C2o_af_53_6 C2o_af_54_6 C2o_af_55_6 C2o_af_56_6 C2o_af_57_6 C2o_af_58_6 C2o_af_59_6 C2o_af_510_6 C2o_af_511_6 C2o_af_512_6 C2o_af_513_6 C2o_af_514_6 C2o_af_515_6 C2o_af_516_6 C2o_af_517_6 C2o_af_518_6 C2o_af_519_6 C2o_af_520_6 C2o_af_521_6 C2o_af_522_6 C2o_af_523_6 C2o_af_524_6 C2o_af_525_6 C2o_af_526_6 C2o_af_527_6 C2o_af_528_6 C2o_af_529_6 C2o_af_530_6 C2o_af_531_6 C2o_aa Arb
xPRT reset Pi_at_50_6 Pi_at_51_6 Pi_at_52_6 Pi_at_53_6 Pi_at_54_6 Pi_at_55_6 Pi_at_56_6 Pi_at_57_6 Pi_at_58_6 Pi_at_59_6 Pi_at_510_6 Pi_at_511_6 Pi_at_512_6 Pi_at_513_6 Pi_at_514_6 Pi_at_515_6 Pi_at_516_6 Pi_at_517_6 Pi_at_518_6 Pi_at_519_6 Pi_at_520_6 Pi_at_521_6 Pi_at_522_6 Pi_at_523_6 Pi_at_524_6 Pi_at_525_6 Pi_at_526_6 Pi_at_527_6 Pi_at_528_6 Pi_at_529_6 Pi_at_530_6 Pi_at_531_6 Pi_af_50_6 Pi_af_51_6 Pi_af_52_6 Pi_af_53_6 Pi_af_54_6 Pi_af_55_6 Pi_af_56_6 Pi_af_57_6 Pi_af_58_6 Pi_af_59_6 Pi_af_510_6 Pi_af_511_6 Pi_af_512_6 Pi_af_513_6 Pi_af_514_6 Pi_af_515_6 Pi_af_516_6 Pi_af_517_6 Pi_af_518_6 Pi_af_519_6 Pi_af_520_6 Pi_af_521_6 Pi_af_522_6 Pi_af_523_6 Pi_af_524_6 Pi_af_525_6 Pi_af_526_6 Pi_af_527_6 Pi_af_528_6 Pi_af_529_6 Pi_af_530_6 Pi_af_531_6 Pi_aa ARM_aP_at_50_6 ARM_aP_at_51_6 ARM_aP_at_52_6 ARM_aP_at_53_6 ARM_aP_at_54_6 ARM_aP_at_55_6 ARM_aP_at_56_6 ARM_aP_at_57_6 ARM_aP_at_58_6 ARM_aP_at_59_6 ARM_aP_at_510_6 ARM_aP_at_511_6 ARM_aP_at_512_6 ARM_aP_at_513_6 ARM_aP_at_514_6 ARM_aP_at_515_6 ARM_aP_at_516_6 ARM_aP_at_517_6 ARM_aP_at_518_6 ARM_aP_at_519_6 ARM_aP_at_520_6 ARM_aP_at_521_6 ARM_aP_at_522_6 ARM_aP_at_523_6 ARM_aP_at_524_6 ARM_aP_at_525_6 ARM_aP_at_526_6 ARM_aP_at_527_6 ARM_aP_at_528_6 ARM_aP_at_529_6 ARM_aP_at_530_6 ARM_aP_at_531_6 ARM_aP_af_50_6 ARM_aP_af_51_6 ARM_aP_af_52_6 ARM_aP_af_53_6 ARM_aP_af_54_6 ARM_aP_af_55_6 ARM_aP_af_56_6 ARM_aP_af_57_6 ARM_aP_af_58_6 ARM_aP_af_59_6 ARM_aP_af_510_6 ARM_aP_af_511_6 ARM_aP_af_512_6 ARM_aP_af_513_6 ARM_aP_af_514_6 ARM_aP_af_515_6 ARM_aP_af_516_6 ARM_aP_af_517_6 ARM_aP_af_518_6 ARM_aP_af_519_6 ARM_aP_af_520_6 ARM_aP_af_521_6 ARM_aP_af_522_6 ARM_aP_af_523_6 ARM_aP_af_524_6 ARM_aP_af_525_6 ARM_aP_af_526_6 ARM_aP_af_527_6 ARM_aP_af_528_6 ARM_aP_af_529_6 ARM_aP_af_530_6 ARM_aP_af_531_6 ARM_aP_aa PRT_aC0_at_50_6 PRT_aC0_at_51_6 PRT_aC0_at_52_6 PRT_aC0_at_53_6 PRT_aC0_at_54_6 PRT_aC0_at_55_6 PRT_aC0_at_56_6 PRT_aC0_at_57_6 PRT_aC0_at_58_6 PRT_aC0_at_59_6 PRT_aC0_at_510_6 PRT_aC0_at_511_6 PRT_aC0_at_512_6 PRT_aC0_at_513_6 PRT_aC0_at_514_6 PRT_aC0_at_515_6 PRT_aC0_at_516_6 PRT_aC0_at_517_6 PRT_aC0_at_518_6 PRT_aC0_at_519_6 PRT_aC0_at_520_6 PRT_aC0_at_521_6 PRT_aC0_at_522_6 PRT_aC0_at_523_6 PRT_aC0_at_524_6 PRT_aC0_at_525_6 PRT_aC0_at_526_6 PRT_aC0_at_527_6 PRT_aC0_at_528_6 PRT_aC0_at_529_6 PRT_aC0_at_530_6 PRT_aC0_at_531_6 PRT_aC0_af_50_6 PRT_aC0_af_51_6 PRT_aC0_af_52_6 PRT_aC0_af_53_6 PRT_aC0_af_54_6 PRT_aC0_af_55_6 PRT_aC0_af_56_6 PRT_aC0_af_57_6 PRT_aC0_af_58_6 PRT_aC0_af_59_6 PRT_aC0_af_510_6 PRT_aC0_af_511_6 PRT_aC0_af_512_6 PRT_aC0_af_513_6 PRT_aC0_af_514_6 PRT_aC0_af_515_6 PRT_aC0_af_516_6 PRT_aC0_af_517_6 PRT_aC0_af_518_6 PRT_aC0_af_519_6 PRT_aC0_af_520_6 PRT_aC0_af_521_6 PRT_aC0_af_522_6 PRT_aC0_af_523_6 PRT_aC0_af_524_6 PRT_aC0_af_525_6 PRT_aC0_af_526_6 PRT_aC0_af_527_6 PRT_aC0_af_528_6 PRT_aC0_af_529_6 PRT_aC0_af_530_6 PRT_aC0_af_531_6 PRT_aC0_aa PRT_aC1_at_50_6 PRT_aC1_at_51_6 PRT_aC1_at_52_6 PRT_aC1_at_53_6 PRT_aC1_at_54_6 PRT_aC1_at_55_6 PRT_aC1_at_56_6 PRT_aC1_at_57_6 PRT_aC1_at_58_6 PRT_aC1_at_59_6 PRT_aC1_at_510_6 PRT_aC1_at_511_6 PRT_aC1_at_512_6 PRT_aC1_at_513_6 PRT_aC1_at_514_6 PRT_aC1_at_515_6 PRT_aC1_at_516_6 PRT_aC1_at_517_6 PRT_aC1_at_518_6 PRT_aC1_at_519_6 PRT_aC1_at_520_6 PRT_aC1_at_521_6 PRT_aC1_at_522_6 PRT_aC1_at_523_6 PRT_aC1_at_524_6 PRT_aC1_at_525_6 PRT_aC1_at_526_6 PRT_aC1_at_527_6 PRT_aC1_at_528_6 PRT_aC1_at_529_6 PRT_aC1_at_530_6 PRT_aC1_at_531_6 PRT_aC1_af_50_6 PRT_aC1_af_51_6 PRT_aC1_af_52_6 PRT_aC1_af_53_6 PRT_aC1_af_54_6 PRT_aC1_af_55_6 PRT_aC1_af_56_6 PRT_aC1_af_57_6 PRT_aC1_af_58_6 PRT_aC1_af_59_6 PRT_aC1_af_510_6 PRT_aC1_af_511_6 PRT_aC1_af_512_6 PRT_aC1_af_513_6 PRT_aC1_af_514_6 PRT_aC1_af_515_6 PRT_aC1_af_516_6 PRT_aC1_af_517_6 PRT_aC1_af_518_6 PRT_aC1_af_519_6 PRT_aC1_af_520_6 PRT_aC1_af_521_6 PRT_aC1_af_522_6 PRT_aC1_af_523_6 PRT_aC1_af_524_6 PRT_aC1_af_525_6 PRT_aC1_af_526_6 PRT_aC1_af_527_6 PRT_aC1_af_528_6 PRT_aC1_af_529_6 PRT_aC1_af_530_6 PRT_aC1_af_531_6 PRT_aC1_aa PRT_aC2_at_50_6 PRT_aC2_at_51_6 PRT_aC2_at_52_6 PRT_aC2_at_53_6 PRT_aC2_at_54_6 PRT_aC2_at_55_6 PRT_aC2_at_56_6 PRT_aC2_at_57_6 PRT_aC2_at_58_6 PRT_aC2_at_59_6 PRT_aC2_at_510_6 PRT_aC2_at_511_6 PRT_aC2_at_512_6 PRT_aC2_at_513_6 PRT_aC2_at_514_6 PRT_aC2_at_515_6 PRT_aC2_at_516_6 PRT_aC2_at_517_6 PRT_aC2_at_518_6 PRT_aC2_at_519_6 PRT_aC2_at_520_6 PRT_aC2_at_521_6 PRT_aC2_at_522_6 PRT_aC2_at_523_6 PRT_aC2_at_524_6 PRT_aC2_at_525_6 PRT_aC2_at_526_6 PRT_aC2_at_527_6 PRT_aC2_at_528_6 PRT_aC2_at_529_6 PRT_aC2_at_530_6 PRT_aC2_at_531_6 PRT_aC2_af_50_6 PRT_aC2_af_51_6 PRT_aC2_af_52_6 PRT_aC2_af_53_6 PRT_aC2_af_54_6 PRT_aC2_af_55_6 PRT_aC2_af_56_6 PRT_aC2_af_57_6 PRT_aC2_af_58_6 PRT_aC2_af_59_6 PRT_aC2_af_510_6 PRT_aC2_af_511_6 PRT_aC2_af_512_6 PRT_aC2_af_513_6 PRT_aC2_af_514_6 PRT_aC2_af_515_6 PRT_aC2_af_516_6 PRT_aC2_af_517_6 PRT_aC2_af_518_6 PRT_aC2_af_519_6 PRT_aC2_af_520_6 PRT_aC2_af_521_6 PRT_aC2_af_522_6 PRT_aC2_af_523_6 PRT_aC2_af_524_6 PRT_aC2_af_525_6 PRT_aC2_af_526_6 PRT_aC2_af_527_6 PRT_aC2_af_528_6 PRT_aC2_af_529_6 PRT_aC2_af_530_6 PRT_aC2_af_531_6 PRT_aC2_aa PRT_aC3_at_50_6 PRT_aC3_at_51_6 PRT_aC3_at_52_6 PRT_aC3_at_53_6 PRT_aC3_at_54_6 PRT_aC3_at_55_6 PRT_aC3_at_56_6 PRT_aC3_at_57_6 PRT_aC3_at_58_6 PRT_aC3_at_59_6 PRT_aC3_at_510_6 PRT_aC3_at_511_6 PRT_aC3_at_512_6 PRT_aC3_at_513_6 PRT_aC3_at_514_6 PRT_aC3_at_515_6 PRT_aC3_at_516_6 PRT_aC3_at_517_6 PRT_aC3_at_518_6 PRT_aC3_at_519_6 PRT_aC3_at_520_6 PRT_aC3_at_521_6 PRT_aC3_at_522_6 PRT_aC3_at_523_6 PRT_aC3_at_524_6 PRT_aC3_at_525_6 PRT_aC3_at_526_6 PRT_aC3_at_527_6 PRT_aC3_at_528_6 PRT_aC3_at_529_6 PRT_aC3_at_530_6 PRT_aC3_at_531_6 PRT_aC3_af_50_6 PRT_aC3_af_51_6 PRT_aC3_af_52_6 PRT_aC3_af_53_6 PRT_aC3_af_54_6 PRT_aC3_af_55_6 PRT_aC3_af_56_6 PRT_aC3_af_57_6 PRT_aC3_af_58_6 PRT_aC3_af_59_6 PRT_aC3_af_510_6 PRT_aC3_af_511_6 PRT_aC3_af_512_6 PRT_aC3_af_513_6 PRT_aC3_af_514_6 PRT_aC3_af_515_6 PRT_aC3_af_516_6 PRT_aC3_af_517_6 PRT_aC3_af_518_6 PRT_aC3_af_519_6 PRT_aC3_af_520_6 PRT_aC3_af_521_6 PRT_aC3_af_522_6 PRT_aC3_af_523_6 PRT_aC3_af_524_6 PRT_aC3_af_525_6 PRT_aC3_af_526_6 PRT_aC3_af_527_6 PRT_aC3_af_528_6 PRT_aC3_af_529_6 PRT_aC3_af_530_6 PRT_aC3_af_531_6 PRT_aC3_aa ParentRouter
xARM reset ARM_aC0_at_50_6 ARM_aC0_at_51_6 ARM_aC0_at_52_6 ARM_aC0_at_53_6 ARM_aC0_at_54_6 ARM_aC0_at_55_6 ARM_aC0_at_56_6 ARM_aC0_at_57_6 ARM_aC0_at_58_6 ARM_aC0_at_59_6 ARM_aC0_at_510_6 ARM_aC0_at_511_6 ARM_aC0_at_512_6 ARM_aC0_at_513_6 ARM_aC0_at_514_6 ARM_aC0_at_515_6 ARM_aC0_at_516_6 ARM_aC0_at_517_6 ARM_aC0_at_518_6 ARM_aC0_at_519_6 ARM_aC0_at_520_6 ARM_aC0_at_521_6 ARM_aC0_at_522_6 ARM_aC0_at_523_6 ARM_aC0_at_524_6 ARM_aC0_at_525_6 ARM_aC0_at_526_6 ARM_aC0_at_527_6 ARM_aC0_at_528_6 ARM_aC0_at_529_6 ARM_aC0_at_530_6 ARM_aC0_at_531_6 ARM_aC0_af_50_6 ARM_aC0_af_51_6 ARM_aC0_af_52_6 ARM_aC0_af_53_6 ARM_aC0_af_54_6 ARM_aC0_af_55_6 ARM_aC0_af_56_6 ARM_aC0_af_57_6 ARM_aC0_af_58_6 ARM_aC0_af_59_6 ARM_aC0_af_510_6 ARM_aC0_af_511_6 ARM_aC0_af_512_6 ARM_aC0_af_513_6 ARM_aC0_af_514_6 ARM_aC0_af_515_6 ARM_aC0_af_516_6 ARM_aC0_af_517_6 ARM_aC0_af_518_6 ARM_aC0_af_519_6 ARM_aC0_af_520_6 ARM_aC0_af_521_6 ARM_aC0_af_522_6 ARM_aC0_af_523_6 ARM_aC0_af_524_6 ARM_aC0_af_525_6 ARM_aC0_af_526_6 ARM_aC0_af_527_6 ARM_aC0_af_528_6 ARM_aC0_af_529_6 ARM_aC0_af_530_6 ARM_aC0_af_531_6 ARM_aC0_aa ARM_aC1_at_50_6 ARM_aC1_at_51_6 ARM_aC1_at_52_6 ARM_aC1_at_53_6 ARM_aC1_at_54_6 ARM_aC1_at_55_6 ARM_aC1_at_56_6 ARM_aC1_at_57_6 ARM_aC1_at_58_6 ARM_aC1_at_59_6 ARM_aC1_at_510_6 ARM_aC1_at_511_6 ARM_aC1_at_512_6 ARM_aC1_at_513_6 ARM_aC1_at_514_6 ARM_aC1_at_515_6 ARM_aC1_at_516_6 ARM_aC1_at_517_6 ARM_aC1_at_518_6 ARM_aC1_at_519_6 ARM_aC1_at_520_6 ARM_aC1_at_521_6 ARM_aC1_at_522_6 ARM_aC1_at_523_6 ARM_aC1_at_524_6 ARM_aC1_at_525_6 ARM_aC1_at_526_6 ARM_aC1_at_527_6 ARM_aC1_at_528_6 ARM_aC1_at_529_6 ARM_aC1_at_530_6 ARM_aC1_at_531_6 ARM_aC1_af_50_6 ARM_aC1_af_51_6 ARM_aC1_af_52_6 ARM_aC1_af_53_6 ARM_aC1_af_54_6 ARM_aC1_af_55_6 ARM_aC1_af_56_6 ARM_aC1_af_57_6 ARM_aC1_af_58_6 ARM_aC1_af_59_6 ARM_aC1_af_510_6 ARM_aC1_af_511_6 ARM_aC1_af_512_6 ARM_aC1_af_513_6 ARM_aC1_af_514_6 ARM_aC1_af_515_6 ARM_aC1_af_516_6 ARM_aC1_af_517_6 ARM_aC1_af_518_6 ARM_aC1_af_519_6 ARM_aC1_af_520_6 ARM_aC1_af_521_6 ARM_aC1_af_522_6 ARM_aC1_af_523_6 ARM_aC1_af_524_6 ARM_aC1_af_525_6 ARM_aC1_af_526_6 ARM_aC1_af_527_6 ARM_aC1_af_528_6 ARM_aC1_af_529_6 ARM_aC1_af_530_6 ARM_aC1_af_531_6 ARM_aC1_aa ARM_aC2_at_50_6 ARM_aC2_at_51_6 ARM_aC2_at_52_6 ARM_aC2_at_53_6 ARM_aC2_at_54_6 ARM_aC2_at_55_6 ARM_aC2_at_56_6 ARM_aC2_at_57_6 ARM_aC2_at_58_6 ARM_aC2_at_59_6 ARM_aC2_at_510_6 ARM_aC2_at_511_6 ARM_aC2_at_512_6 ARM_aC2_at_513_6 ARM_aC2_at_514_6 ARM_aC2_at_515_6 ARM_aC2_at_516_6 ARM_aC2_at_517_6 ARM_aC2_at_518_6 ARM_aC2_at_519_6 ARM_aC2_at_520_6 ARM_aC2_at_521_6 ARM_aC2_at_522_6 ARM_aC2_at_523_6 ARM_aC2_at_524_6 ARM_aC2_at_525_6 ARM_aC2_at_526_6 ARM_aC2_at_527_6 ARM_aC2_at_528_6 ARM_aC2_at_529_6 ARM_aC2_at_530_6 ARM_aC2_at_531_6 ARM_aC2_af_50_6 ARM_aC2_af_51_6 ARM_aC2_af_52_6 ARM_aC2_af_53_6 ARM_aC2_af_54_6 ARM_aC2_af_55_6 ARM_aC2_af_56_6 ARM_aC2_af_57_6 ARM_aC2_af_58_6 ARM_aC2_af_59_6 ARM_aC2_af_510_6 ARM_aC2_af_511_6 ARM_aC2_af_512_6 ARM_aC2_af_513_6 ARM_aC2_af_514_6 ARM_aC2_af_515_6 ARM_aC2_af_516_6 ARM_aC2_af_517_6 ARM_aC2_af_518_6 ARM_aC2_af_519_6 ARM_aC2_af_520_6 ARM_aC2_af_521_6 ARM_aC2_af_522_6 ARM_aC2_af_523_6 ARM_aC2_af_524_6 ARM_aC2_af_525_6 ARM_aC2_af_526_6 ARM_aC2_af_527_6 ARM_aC2_af_528_6 ARM_aC2_af_529_6 ARM_aC2_af_530_6 ARM_aC2_af_531_6 ARM_aC2_aa ARM_aC3_at_50_6 ARM_aC3_at_51_6 ARM_aC3_at_52_6 ARM_aC3_at_53_6 ARM_aC3_at_54_6 ARM_aC3_at_55_6 ARM_aC3_at_56_6 ARM_aC3_at_57_6 ARM_aC3_at_58_6 ARM_aC3_at_59_6 ARM_aC3_at_510_6 ARM_aC3_at_511_6 ARM_aC3_at_512_6 ARM_aC3_at_513_6 ARM_aC3_at_514_6 ARM_aC3_at_515_6 ARM_aC3_at_516_6 ARM_aC3_at_517_6 ARM_aC3_at_518_6 ARM_aC3_at_519_6 ARM_aC3_at_520_6 ARM_aC3_at_521_6 ARM_aC3_at_522_6 ARM_aC3_at_523_6 ARM_aC3_at_524_6 ARM_aC3_at_525_6 ARM_aC3_at_526_6 ARM_aC3_at_527_6 ARM_aC3_at_528_6 ARM_aC3_at_529_6 ARM_aC3_at_530_6 ARM_aC3_at_531_6 ARM_aC3_af_50_6 ARM_aC3_af_51_6 ARM_aC3_af_52_6 ARM_aC3_af_53_6 ARM_aC3_af_54_6 ARM_aC3_af_55_6 ARM_aC3_af_56_6 ARM_aC3_af_57_6 ARM_aC3_af_58_6 ARM_aC3_af_59_6 ARM_aC3_af_510_6 ARM_aC3_af_511_6 ARM_aC3_af_512_6 ARM_aC3_af_513_6 ARM_aC3_af_514_6 ARM_aC3_af_515_6 ARM_aC3_af_516_6 ARM_aC3_af_517_6 ARM_aC3_af_518_6 ARM_aC3_af_519_6 ARM_aC3_af_520_6 ARM_aC3_af_521_6 ARM_aC3_af_522_6 ARM_aC3_af_523_6 ARM_aC3_af_524_6 ARM_aC3_af_525_6 ARM_aC3_af_526_6 ARM_aC3_af_527_6 ARM_aC3_af_528_6 ARM_aC3_af_529_6 ARM_aC3_af_530_6 ARM_aC3_af_531_6 ARM_aC3_aa ARM_aP_at_50_6 ARM_aP_at_51_6 ARM_aP_at_52_6 ARM_aP_at_53_6 ARM_aP_at_54_6 ARM_aP_at_55_6 ARM_aP_at_56_6 ARM_aP_at_57_6 ARM_aP_at_58_6 ARM_aP_at_59_6 ARM_aP_at_510_6 ARM_aP_at_511_6 ARM_aP_at_512_6 ARM_aP_at_513_6 ARM_aP_at_514_6 ARM_aP_at_515_6 ARM_aP_at_516_6 ARM_aP_at_517_6 ARM_aP_at_518_6 ARM_aP_at_519_6 ARM_aP_at_520_6 ARM_aP_at_521_6 ARM_aP_at_522_6 ARM_aP_at_523_6 ARM_aP_at_524_6 ARM_aP_at_525_6 ARM_aP_at_526_6 ARM_aP_at_527_6 ARM_aP_at_528_6 ARM_aP_at_529_6 ARM_aP_at_530_6 ARM_aP_at_531_6 ARM_aP_af_50_6 ARM_aP_af_51_6 ARM_aP_af_52_6 ARM_aP_af_53_6 ARM_aP_af_54_6 ARM_aP_af_55_6 ARM_aP_af_56_6 ARM_aP_af_57_6 ARM_aP_af_58_6 ARM_aP_af_59_6 ARM_aP_af_510_6 ARM_aP_af_511_6 ARM_aP_af_512_6 ARM_aP_af_513_6 ARM_aP_af_514_6 ARM_aP_af_515_6 ARM_aP_af_516_6 ARM_aP_af_517_6 ARM_aP_af_518_6 ARM_aP_af_519_6 ARM_aP_af_520_6 ARM_aP_af_521_6 ARM_aP_af_522_6 ARM_aP_af_523_6 ARM_aP_af_524_6 ARM_aP_af_525_6 ARM_aP_af_526_6 ARM_aP_af_527_6 ARM_aP_af_528_6 ARM_aP_af_529_6 ARM_aP_af_530_6 ARM_aP_af_531_6 ARM_aP_aa ARM_aM_at_50_6 ARM_aM_at_51_6 ARM_aM_at_52_6 ARM_aM_at_53_6 ARM_aM_at_54_6 ARM_aM_at_55_6 ARM_aM_at_56_6 ARM_aM_at_57_6 ARM_aM_at_58_6 ARM_aM_at_59_6 ARM_aM_at_510_6 ARM_aM_at_511_6 ARM_aM_at_512_6 ARM_aM_at_513_6 ARM_aM_at_514_6 ARM_aM_at_515_6 ARM_aM_at_516_6 ARM_aM_at_517_6 ARM_aM_at_518_6 ARM_aM_at_519_6 ARM_aM_at_520_6 ARM_aM_at_521_6 ARM_aM_at_522_6 ARM_aM_at_523_6 ARM_aM_at_524_6 ARM_aM_at_525_6 ARM_aM_at_526_6 ARM_aM_at_527_6 ARM_aM_at_528_6 ARM_aM_at_529_6 ARM_aM_at_530_6 ARM_aM_at_531_6 ARM_aM_af_50_6 ARM_aM_af_51_6 ARM_aM_af_52_6 ARM_aM_af_53_6 ARM_aM_af_54_6 ARM_aM_af_55_6 ARM_aM_af_56_6 ARM_aM_af_57_6 ARM_aM_af_58_6 ARM_aM_af_59_6 ARM_aM_af_510_6 ARM_aM_af_511_6 ARM_aM_af_512_6 ARM_aM_af_513_6 ARM_aM_af_514_6 ARM_aM_af_515_6 ARM_aM_af_516_6 ARM_aM_af_517_6 ARM_aM_af_518_6 ARM_aM_af_519_6 ARM_aM_af_520_6 ARM_aM_af_521_6 ARM_aM_af_522_6 ARM_aM_af_523_6 ARM_aM_af_524_6 ARM_aM_af_525_6 ARM_aM_af_526_6 ARM_aM_af_527_6 ARM_aM_af_528_6 ARM_aM_af_529_6 ARM_aM_af_530_6 ARM_aM_af_531_6 ARM_aM_aa MU_aI_at_50_6 MU_aI_at_51_6 MU_aI_at_52_6 MU_aI_at_53_6 MU_aI_at_54_6 MU_aI_at_55_6 MU_aI_at_56_6 MU_aI_at_57_6 MU_aI_at_58_6 MU_aI_at_59_6 MU_aI_at_510_6 MU_aI_at_511_6 MU_aI_at_512_6 MU_aI_at_513_6 MU_aI_at_514_6 MU_aI_at_515_6 MU_aI_at_516_6 MU_aI_at_517_6 MU_aI_at_518_6 MU_aI_at_519_6 MU_aI_at_520_6 MU_aI_at_521_6 MU_aI_at_522_6 MU_aI_at_523_6 MU_aI_at_524_6 MU_aI_at_525_6 MU_aI_at_526_6 MU_aI_at_527_6 MU_aI_at_528_6 MU_aI_at_529_6 MU_aI_at_530_6 MU_aI_at_531_6 MU_aI_af_50_6 MU_aI_af_51_6 MU_aI_af_52_6 MU_aI_af_53_6 MU_aI_af_54_6 MU_aI_af_55_6 MU_aI_af_56_6 MU_aI_af_57_6 MU_aI_af_58_6 MU_aI_af_59_6 MU_aI_af_510_6 MU_aI_af_511_6 MU_aI_af_512_6 MU_aI_af_513_6 MU_aI_af_514_6 MU_aI_af_515_6 MU_aI_af_516_6 MU_aI_af_517_6 MU_aI_af_518_6 MU_aI_af_519_6 MU_aI_af_520_6 MU_aI_af_521_6 MU_aI_af_522_6 MU_aI_af_523_6 MU_aI_af_524_6 MU_aI_af_525_6 MU_aI_af_526_6 MU_aI_af_527_6 MU_aI_af_528_6 MU_aI_af_529_6 MU_aI_af_530_6 MU_aI_af_531_6 MU_aI_aa Arb
xARC3 reset ARC3_aC0_at_50_6 ARC3_aC0_at_51_6 ARC3_aC0_at_52_6 ARC3_aC0_at_53_6 ARC3_aC0_at_54_6 ARC3_aC0_at_55_6 ARC3_aC0_at_56_6 ARC3_aC0_at_57_6 ARC3_aC0_at_58_6 ARC3_aC0_at_59_6 ARC3_aC0_at_510_6 ARC3_aC0_at_511_6 ARC3_aC0_at_512_6 ARC3_aC0_at_513_6 ARC3_aC0_at_514_6 ARC3_aC0_at_515_6 ARC3_aC0_at_516_6 ARC3_aC0_at_517_6 ARC3_aC0_at_518_6 ARC3_aC0_at_519_6 ARC3_aC0_at_520_6 ARC3_aC0_at_521_6 ARC3_aC0_at_522_6 ARC3_aC0_at_523_6 ARC3_aC0_at_524_6 ARC3_aC0_at_525_6 ARC3_aC0_at_526_6 ARC3_aC0_at_527_6 ARC3_aC0_at_528_6 ARC3_aC0_at_529_6 ARC3_aC0_at_530_6 ARC3_aC0_at_531_6 ARC3_aC0_af_50_6 ARC3_aC0_af_51_6 ARC3_aC0_af_52_6 ARC3_aC0_af_53_6 ARC3_aC0_af_54_6 ARC3_aC0_af_55_6 ARC3_aC0_af_56_6 ARC3_aC0_af_57_6 ARC3_aC0_af_58_6 ARC3_aC0_af_59_6 ARC3_aC0_af_510_6 ARC3_aC0_af_511_6 ARC3_aC0_af_512_6 ARC3_aC0_af_513_6 ARC3_aC0_af_514_6 ARC3_aC0_af_515_6 ARC3_aC0_af_516_6 ARC3_aC0_af_517_6 ARC3_aC0_af_518_6 ARC3_aC0_af_519_6 ARC3_aC0_af_520_6 ARC3_aC0_af_521_6 ARC3_aC0_af_522_6 ARC3_aC0_af_523_6 ARC3_aC0_af_524_6 ARC3_aC0_af_525_6 ARC3_aC0_af_526_6 ARC3_aC0_af_527_6 ARC3_aC0_af_528_6 ARC3_aC0_af_529_6 ARC3_aC0_af_530_6 ARC3_aC0_af_531_6 ARC3_aC0_aa ARC3_aC1_at_50_6 ARC3_aC1_at_51_6 ARC3_aC1_at_52_6 ARC3_aC1_at_53_6 ARC3_aC1_at_54_6 ARC3_aC1_at_55_6 ARC3_aC1_at_56_6 ARC3_aC1_at_57_6 ARC3_aC1_at_58_6 ARC3_aC1_at_59_6 ARC3_aC1_at_510_6 ARC3_aC1_at_511_6 ARC3_aC1_at_512_6 ARC3_aC1_at_513_6 ARC3_aC1_at_514_6 ARC3_aC1_at_515_6 ARC3_aC1_at_516_6 ARC3_aC1_at_517_6 ARC3_aC1_at_518_6 ARC3_aC1_at_519_6 ARC3_aC1_at_520_6 ARC3_aC1_at_521_6 ARC3_aC1_at_522_6 ARC3_aC1_at_523_6 ARC3_aC1_at_524_6 ARC3_aC1_at_525_6 ARC3_aC1_at_526_6 ARC3_aC1_at_527_6 ARC3_aC1_at_528_6 ARC3_aC1_at_529_6 ARC3_aC1_at_530_6 ARC3_aC1_at_531_6 ARC3_aC1_af_50_6 ARC3_aC1_af_51_6 ARC3_aC1_af_52_6 ARC3_aC1_af_53_6 ARC3_aC1_af_54_6 ARC3_aC1_af_55_6 ARC3_aC1_af_56_6 ARC3_aC1_af_57_6 ARC3_aC1_af_58_6 ARC3_aC1_af_59_6 ARC3_aC1_af_510_6 ARC3_aC1_af_511_6 ARC3_aC1_af_512_6 ARC3_aC1_af_513_6 ARC3_aC1_af_514_6 ARC3_aC1_af_515_6 ARC3_aC1_af_516_6 ARC3_aC1_af_517_6 ARC3_aC1_af_518_6 ARC3_aC1_af_519_6 ARC3_aC1_af_520_6 ARC3_aC1_af_521_6 ARC3_aC1_af_522_6 ARC3_aC1_af_523_6 ARC3_aC1_af_524_6 ARC3_aC1_af_525_6 ARC3_aC1_af_526_6 ARC3_aC1_af_527_6 ARC3_aC1_af_528_6 ARC3_aC1_af_529_6 ARC3_aC1_af_530_6 ARC3_aC1_af_531_6 ARC3_aC1_aa ARC3_aC2_at_50_6 ARC3_aC2_at_51_6 ARC3_aC2_at_52_6 ARC3_aC2_at_53_6 ARC3_aC2_at_54_6 ARC3_aC2_at_55_6 ARC3_aC2_at_56_6 ARC3_aC2_at_57_6 ARC3_aC2_at_58_6 ARC3_aC2_at_59_6 ARC3_aC2_at_510_6 ARC3_aC2_at_511_6 ARC3_aC2_at_512_6 ARC3_aC2_at_513_6 ARC3_aC2_at_514_6 ARC3_aC2_at_515_6 ARC3_aC2_at_516_6 ARC3_aC2_at_517_6 ARC3_aC2_at_518_6 ARC3_aC2_at_519_6 ARC3_aC2_at_520_6 ARC3_aC2_at_521_6 ARC3_aC2_at_522_6 ARC3_aC2_at_523_6 ARC3_aC2_at_524_6 ARC3_aC2_at_525_6 ARC3_aC2_at_526_6 ARC3_aC2_at_527_6 ARC3_aC2_at_528_6 ARC3_aC2_at_529_6 ARC3_aC2_at_530_6 ARC3_aC2_at_531_6 ARC3_aC2_af_50_6 ARC3_aC2_af_51_6 ARC3_aC2_af_52_6 ARC3_aC2_af_53_6 ARC3_aC2_af_54_6 ARC3_aC2_af_55_6 ARC3_aC2_af_56_6 ARC3_aC2_af_57_6 ARC3_aC2_af_58_6 ARC3_aC2_af_59_6 ARC3_aC2_af_510_6 ARC3_aC2_af_511_6 ARC3_aC2_af_512_6 ARC3_aC2_af_513_6 ARC3_aC2_af_514_6 ARC3_aC2_af_515_6 ARC3_aC2_af_516_6 ARC3_aC2_af_517_6 ARC3_aC2_af_518_6 ARC3_aC2_af_519_6 ARC3_aC2_af_520_6 ARC3_aC2_af_521_6 ARC3_aC2_af_522_6 ARC3_aC2_af_523_6 ARC3_aC2_af_524_6 ARC3_aC2_af_525_6 ARC3_aC2_af_526_6 ARC3_aC2_af_527_6 ARC3_aC2_af_528_6 ARC3_aC2_af_529_6 ARC3_aC2_af_530_6 ARC3_aC2_af_531_6 ARC3_aC2_aa ARC3_aC3_at_50_6 ARC3_aC3_at_51_6 ARC3_aC3_at_52_6 ARC3_aC3_at_53_6 ARC3_aC3_at_54_6 ARC3_aC3_at_55_6 ARC3_aC3_at_56_6 ARC3_aC3_at_57_6 ARC3_aC3_at_58_6 ARC3_aC3_at_59_6 ARC3_aC3_at_510_6 ARC3_aC3_at_511_6 ARC3_aC3_at_512_6 ARC3_aC3_at_513_6 ARC3_aC3_at_514_6 ARC3_aC3_at_515_6 ARC3_aC3_at_516_6 ARC3_aC3_at_517_6 ARC3_aC3_at_518_6 ARC3_aC3_at_519_6 ARC3_aC3_at_520_6 ARC3_aC3_at_521_6 ARC3_aC3_at_522_6 ARC3_aC3_at_523_6 ARC3_aC3_at_524_6 ARC3_aC3_at_525_6 ARC3_aC3_at_526_6 ARC3_aC3_at_527_6 ARC3_aC3_at_528_6 ARC3_aC3_at_529_6 ARC3_aC3_at_530_6 ARC3_aC3_at_531_6 ARC3_aC3_af_50_6 ARC3_aC3_af_51_6 ARC3_aC3_af_52_6 ARC3_aC3_af_53_6 ARC3_aC3_af_54_6 ARC3_aC3_af_55_6 ARC3_aC3_af_56_6 ARC3_aC3_af_57_6 ARC3_aC3_af_58_6 ARC3_aC3_af_59_6 ARC3_aC3_af_510_6 ARC3_aC3_af_511_6 ARC3_aC3_af_512_6 ARC3_aC3_af_513_6 ARC3_aC3_af_514_6 ARC3_aC3_af_515_6 ARC3_aC3_af_516_6 ARC3_aC3_af_517_6 ARC3_aC3_af_518_6 ARC3_aC3_af_519_6 ARC3_aC3_af_520_6 ARC3_aC3_af_521_6 ARC3_aC3_af_522_6 ARC3_aC3_af_523_6 ARC3_aC3_af_524_6 ARC3_aC3_af_525_6 ARC3_aC3_af_526_6 ARC3_aC3_af_527_6 ARC3_aC3_af_528_6 ARC3_aC3_af_529_6 ARC3_aC3_af_530_6 ARC3_aC3_af_531_6 ARC3_aC3_aa PRT_aC3_at_50_6 PRT_aC3_at_51_6 PRT_aC3_at_52_6 PRT_aC3_at_53_6 PRT_aC3_at_54_6 PRT_aC3_at_55_6 PRT_aC3_at_56_6 PRT_aC3_at_57_6 PRT_aC3_at_58_6 PRT_aC3_at_59_6 PRT_aC3_at_510_6 PRT_aC3_at_511_6 PRT_aC3_at_512_6 PRT_aC3_at_513_6 PRT_aC3_at_514_6 PRT_aC3_at_515_6 PRT_aC3_at_516_6 PRT_aC3_at_517_6 PRT_aC3_at_518_6 PRT_aC3_at_519_6 PRT_aC3_at_520_6 PRT_aC3_at_521_6 PRT_aC3_at_522_6 PRT_aC3_at_523_6 PRT_aC3_at_524_6 PRT_aC3_at_525_6 PRT_aC3_at_526_6 PRT_aC3_at_527_6 PRT_aC3_at_528_6 PRT_aC3_at_529_6 PRT_aC3_at_530_6 PRT_aC3_at_531_6 PRT_aC3_af_50_6 PRT_aC3_af_51_6 PRT_aC3_af_52_6 PRT_aC3_af_53_6 PRT_aC3_af_54_6 PRT_aC3_af_55_6 PRT_aC3_af_56_6 PRT_aC3_af_57_6 PRT_aC3_af_58_6 PRT_aC3_af_59_6 PRT_aC3_af_510_6 PRT_aC3_af_511_6 PRT_aC3_af_512_6 PRT_aC3_af_513_6 PRT_aC3_af_514_6 PRT_aC3_af_515_6 PRT_aC3_af_516_6 PRT_aC3_af_517_6 PRT_aC3_af_518_6 PRT_aC3_af_519_6 PRT_aC3_af_520_6 PRT_aC3_af_521_6 PRT_aC3_af_522_6 PRT_aC3_af_523_6 PRT_aC3_af_524_6 PRT_aC3_af_525_6 PRT_aC3_af_526_6 PRT_aC3_af_527_6 PRT_aC3_af_528_6 PRT_aC3_af_529_6 PRT_aC3_af_530_6 PRT_aC3_af_531_6 PRT_aC3_aa MU_aC3_at_50_6 MU_aC3_at_51_6 MU_aC3_at_52_6 MU_aC3_at_53_6 MU_aC3_at_54_6 MU_aC3_at_55_6 MU_aC3_at_56_6 MU_aC3_at_57_6 MU_aC3_at_58_6 MU_aC3_at_59_6 MU_aC3_at_510_6 MU_aC3_at_511_6 MU_aC3_at_512_6 MU_aC3_at_513_6 MU_aC3_at_514_6 MU_aC3_at_515_6 MU_aC3_at_516_6 MU_aC3_at_517_6 MU_aC3_at_518_6 MU_aC3_at_519_6 MU_aC3_at_520_6 MU_aC3_at_521_6 MU_aC3_at_522_6 MU_aC3_at_523_6 MU_aC3_at_524_6 MU_aC3_at_525_6 MU_aC3_at_526_6 MU_aC3_at_527_6 MU_aC3_at_528_6 MU_aC3_at_529_6 MU_aC3_at_530_6 MU_aC3_at_531_6 MU_aC3_af_50_6 MU_aC3_af_51_6 MU_aC3_af_52_6 MU_aC3_af_53_6 MU_aC3_af_54_6 MU_aC3_af_55_6 MU_aC3_af_56_6 MU_aC3_af_57_6 MU_aC3_af_58_6 MU_aC3_af_59_6 MU_aC3_af_510_6 MU_aC3_af_511_6 MU_aC3_af_512_6 MU_aC3_af_513_6 MU_aC3_af_514_6 MU_aC3_af_515_6 MU_aC3_af_516_6 MU_aC3_af_517_6 MU_aC3_af_518_6 MU_aC3_af_519_6 MU_aC3_af_520_6 MU_aC3_af_521_6 MU_aC3_af_522_6 MU_aC3_af_523_6 MU_aC3_af_524_6 MU_aC3_af_525_6 MU_aC3_af_526_6 MU_aC3_af_527_6 MU_aC3_af_528_6 MU_aC3_af_529_6 MU_aC3_af_530_6 MU_aC3_af_531_6 MU_aC3_aa C3o_at_50_6 C3o_at_51_6 C3o_at_52_6 C3o_at_53_6 C3o_at_54_6 C3o_at_55_6 C3o_at_56_6 C3o_at_57_6 C3o_at_58_6 C3o_at_59_6 C3o_at_510_6 C3o_at_511_6 C3o_at_512_6 C3o_at_513_6 C3o_at_514_6 C3o_at_515_6 C3o_at_516_6 C3o_at_517_6 C3o_at_518_6 C3o_at_519_6 C3o_at_520_6 C3o_at_521_6 C3o_at_522_6 C3o_at_523_6 C3o_at_524_6 C3o_at_525_6 C3o_at_526_6 C3o_at_527_6 C3o_at_528_6 C3o_at_529_6 C3o_at_530_6 C3o_at_531_6 C3o_af_50_6 C3o_af_51_6 C3o_af_52_6 C3o_af_53_6 C3o_af_54_6 C3o_af_55_6 C3o_af_56_6 C3o_af_57_6 C3o_af_58_6 C3o_af_59_6 C3o_af_510_6 C3o_af_511_6 C3o_af_512_6 C3o_af_513_6 C3o_af_514_6 C3o_af_515_6 C3o_af_516_6 C3o_af_517_6 C3o_af_518_6 C3o_af_519_6 C3o_af_520_6 C3o_af_521_6 C3o_af_522_6 C3o_af_523_6 C3o_af_524_6 C3o_af_525_6 C3o_af_526_6 C3o_af_527_6 C3o_af_528_6 C3o_af_529_6 C3o_af_530_6 C3o_af_531_6 C3o_aa Arb
xARC1 reset ARC1_aC0_at_50_6 ARC1_aC0_at_51_6 ARC1_aC0_at_52_6 ARC1_aC0_at_53_6 ARC1_aC0_at_54_6 ARC1_aC0_at_55_6 ARC1_aC0_at_56_6 ARC1_aC0_at_57_6 ARC1_aC0_at_58_6 ARC1_aC0_at_59_6 ARC1_aC0_at_510_6 ARC1_aC0_at_511_6 ARC1_aC0_at_512_6 ARC1_aC0_at_513_6 ARC1_aC0_at_514_6 ARC1_aC0_at_515_6 ARC1_aC0_at_516_6 ARC1_aC0_at_517_6 ARC1_aC0_at_518_6 ARC1_aC0_at_519_6 ARC1_aC0_at_520_6 ARC1_aC0_at_521_6 ARC1_aC0_at_522_6 ARC1_aC0_at_523_6 ARC1_aC0_at_524_6 ARC1_aC0_at_525_6 ARC1_aC0_at_526_6 ARC1_aC0_at_527_6 ARC1_aC0_at_528_6 ARC1_aC0_at_529_6 ARC1_aC0_at_530_6 ARC1_aC0_at_531_6 ARC1_aC0_af_50_6 ARC1_aC0_af_51_6 ARC1_aC0_af_52_6 ARC1_aC0_af_53_6 ARC1_aC0_af_54_6 ARC1_aC0_af_55_6 ARC1_aC0_af_56_6 ARC1_aC0_af_57_6 ARC1_aC0_af_58_6 ARC1_aC0_af_59_6 ARC1_aC0_af_510_6 ARC1_aC0_af_511_6 ARC1_aC0_af_512_6 ARC1_aC0_af_513_6 ARC1_aC0_af_514_6 ARC1_aC0_af_515_6 ARC1_aC0_af_516_6 ARC1_aC0_af_517_6 ARC1_aC0_af_518_6 ARC1_aC0_af_519_6 ARC1_aC0_af_520_6 ARC1_aC0_af_521_6 ARC1_aC0_af_522_6 ARC1_aC0_af_523_6 ARC1_aC0_af_524_6 ARC1_aC0_af_525_6 ARC1_aC0_af_526_6 ARC1_aC0_af_527_6 ARC1_aC0_af_528_6 ARC1_aC0_af_529_6 ARC1_aC0_af_530_6 ARC1_aC0_af_531_6 ARC1_aC0_aa ARC1_aC1_at_50_6 ARC1_aC1_at_51_6 ARC1_aC1_at_52_6 ARC1_aC1_at_53_6 ARC1_aC1_at_54_6 ARC1_aC1_at_55_6 ARC1_aC1_at_56_6 ARC1_aC1_at_57_6 ARC1_aC1_at_58_6 ARC1_aC1_at_59_6 ARC1_aC1_at_510_6 ARC1_aC1_at_511_6 ARC1_aC1_at_512_6 ARC1_aC1_at_513_6 ARC1_aC1_at_514_6 ARC1_aC1_at_515_6 ARC1_aC1_at_516_6 ARC1_aC1_at_517_6 ARC1_aC1_at_518_6 ARC1_aC1_at_519_6 ARC1_aC1_at_520_6 ARC1_aC1_at_521_6 ARC1_aC1_at_522_6 ARC1_aC1_at_523_6 ARC1_aC1_at_524_6 ARC1_aC1_at_525_6 ARC1_aC1_at_526_6 ARC1_aC1_at_527_6 ARC1_aC1_at_528_6 ARC1_aC1_at_529_6 ARC1_aC1_at_530_6 ARC1_aC1_at_531_6 ARC1_aC1_af_50_6 ARC1_aC1_af_51_6 ARC1_aC1_af_52_6 ARC1_aC1_af_53_6 ARC1_aC1_af_54_6 ARC1_aC1_af_55_6 ARC1_aC1_af_56_6 ARC1_aC1_af_57_6 ARC1_aC1_af_58_6 ARC1_aC1_af_59_6 ARC1_aC1_af_510_6 ARC1_aC1_af_511_6 ARC1_aC1_af_512_6 ARC1_aC1_af_513_6 ARC1_aC1_af_514_6 ARC1_aC1_af_515_6 ARC1_aC1_af_516_6 ARC1_aC1_af_517_6 ARC1_aC1_af_518_6 ARC1_aC1_af_519_6 ARC1_aC1_af_520_6 ARC1_aC1_af_521_6 ARC1_aC1_af_522_6 ARC1_aC1_af_523_6 ARC1_aC1_af_524_6 ARC1_aC1_af_525_6 ARC1_aC1_af_526_6 ARC1_aC1_af_527_6 ARC1_aC1_af_528_6 ARC1_aC1_af_529_6 ARC1_aC1_af_530_6 ARC1_aC1_af_531_6 ARC1_aC1_aa ARC1_aC2_at_50_6 ARC1_aC2_at_51_6 ARC1_aC2_at_52_6 ARC1_aC2_at_53_6 ARC1_aC2_at_54_6 ARC1_aC2_at_55_6 ARC1_aC2_at_56_6 ARC1_aC2_at_57_6 ARC1_aC2_at_58_6 ARC1_aC2_at_59_6 ARC1_aC2_at_510_6 ARC1_aC2_at_511_6 ARC1_aC2_at_512_6 ARC1_aC2_at_513_6 ARC1_aC2_at_514_6 ARC1_aC2_at_515_6 ARC1_aC2_at_516_6 ARC1_aC2_at_517_6 ARC1_aC2_at_518_6 ARC1_aC2_at_519_6 ARC1_aC2_at_520_6 ARC1_aC2_at_521_6 ARC1_aC2_at_522_6 ARC1_aC2_at_523_6 ARC1_aC2_at_524_6 ARC1_aC2_at_525_6 ARC1_aC2_at_526_6 ARC1_aC2_at_527_6 ARC1_aC2_at_528_6 ARC1_aC2_at_529_6 ARC1_aC2_at_530_6 ARC1_aC2_at_531_6 ARC1_aC2_af_50_6 ARC1_aC2_af_51_6 ARC1_aC2_af_52_6 ARC1_aC2_af_53_6 ARC1_aC2_af_54_6 ARC1_aC2_af_55_6 ARC1_aC2_af_56_6 ARC1_aC2_af_57_6 ARC1_aC2_af_58_6 ARC1_aC2_af_59_6 ARC1_aC2_af_510_6 ARC1_aC2_af_511_6 ARC1_aC2_af_512_6 ARC1_aC2_af_513_6 ARC1_aC2_af_514_6 ARC1_aC2_af_515_6 ARC1_aC2_af_516_6 ARC1_aC2_af_517_6 ARC1_aC2_af_518_6 ARC1_aC2_af_519_6 ARC1_aC2_af_520_6 ARC1_aC2_af_521_6 ARC1_aC2_af_522_6 ARC1_aC2_af_523_6 ARC1_aC2_af_524_6 ARC1_aC2_af_525_6 ARC1_aC2_af_526_6 ARC1_aC2_af_527_6 ARC1_aC2_af_528_6 ARC1_aC2_af_529_6 ARC1_aC2_af_530_6 ARC1_aC2_af_531_6 ARC1_aC2_aa ARC1_aC3_at_50_6 ARC1_aC3_at_51_6 ARC1_aC3_at_52_6 ARC1_aC3_at_53_6 ARC1_aC3_at_54_6 ARC1_aC3_at_55_6 ARC1_aC3_at_56_6 ARC1_aC3_at_57_6 ARC1_aC3_at_58_6 ARC1_aC3_at_59_6 ARC1_aC3_at_510_6 ARC1_aC3_at_511_6 ARC1_aC3_at_512_6 ARC1_aC3_at_513_6 ARC1_aC3_at_514_6 ARC1_aC3_at_515_6 ARC1_aC3_at_516_6 ARC1_aC3_at_517_6 ARC1_aC3_at_518_6 ARC1_aC3_at_519_6 ARC1_aC3_at_520_6 ARC1_aC3_at_521_6 ARC1_aC3_at_522_6 ARC1_aC3_at_523_6 ARC1_aC3_at_524_6 ARC1_aC3_at_525_6 ARC1_aC3_at_526_6 ARC1_aC3_at_527_6 ARC1_aC3_at_528_6 ARC1_aC3_at_529_6 ARC1_aC3_at_530_6 ARC1_aC3_at_531_6 ARC1_aC3_af_50_6 ARC1_aC3_af_51_6 ARC1_aC3_af_52_6 ARC1_aC3_af_53_6 ARC1_aC3_af_54_6 ARC1_aC3_af_55_6 ARC1_aC3_af_56_6 ARC1_aC3_af_57_6 ARC1_aC3_af_58_6 ARC1_aC3_af_59_6 ARC1_aC3_af_510_6 ARC1_aC3_af_511_6 ARC1_aC3_af_512_6 ARC1_aC3_af_513_6 ARC1_aC3_af_514_6 ARC1_aC3_af_515_6 ARC1_aC3_af_516_6 ARC1_aC3_af_517_6 ARC1_aC3_af_518_6 ARC1_aC3_af_519_6 ARC1_aC3_af_520_6 ARC1_aC3_af_521_6 ARC1_aC3_af_522_6 ARC1_aC3_af_523_6 ARC1_aC3_af_524_6 ARC1_aC3_af_525_6 ARC1_aC3_af_526_6 ARC1_aC3_af_527_6 ARC1_aC3_af_528_6 ARC1_aC3_af_529_6 ARC1_aC3_af_530_6 ARC1_aC3_af_531_6 ARC1_aC3_aa PRT_aC1_at_50_6 PRT_aC1_at_51_6 PRT_aC1_at_52_6 PRT_aC1_at_53_6 PRT_aC1_at_54_6 PRT_aC1_at_55_6 PRT_aC1_at_56_6 PRT_aC1_at_57_6 PRT_aC1_at_58_6 PRT_aC1_at_59_6 PRT_aC1_at_510_6 PRT_aC1_at_511_6 PRT_aC1_at_512_6 PRT_aC1_at_513_6 PRT_aC1_at_514_6 PRT_aC1_at_515_6 PRT_aC1_at_516_6 PRT_aC1_at_517_6 PRT_aC1_at_518_6 PRT_aC1_at_519_6 PRT_aC1_at_520_6 PRT_aC1_at_521_6 PRT_aC1_at_522_6 PRT_aC1_at_523_6 PRT_aC1_at_524_6 PRT_aC1_at_525_6 PRT_aC1_at_526_6 PRT_aC1_at_527_6 PRT_aC1_at_528_6 PRT_aC1_at_529_6 PRT_aC1_at_530_6 PRT_aC1_at_531_6 PRT_aC1_af_50_6 PRT_aC1_af_51_6 PRT_aC1_af_52_6 PRT_aC1_af_53_6 PRT_aC1_af_54_6 PRT_aC1_af_55_6 PRT_aC1_af_56_6 PRT_aC1_af_57_6 PRT_aC1_af_58_6 PRT_aC1_af_59_6 PRT_aC1_af_510_6 PRT_aC1_af_511_6 PRT_aC1_af_512_6 PRT_aC1_af_513_6 PRT_aC1_af_514_6 PRT_aC1_af_515_6 PRT_aC1_af_516_6 PRT_aC1_af_517_6 PRT_aC1_af_518_6 PRT_aC1_af_519_6 PRT_aC1_af_520_6 PRT_aC1_af_521_6 PRT_aC1_af_522_6 PRT_aC1_af_523_6 PRT_aC1_af_524_6 PRT_aC1_af_525_6 PRT_aC1_af_526_6 PRT_aC1_af_527_6 PRT_aC1_af_528_6 PRT_aC1_af_529_6 PRT_aC1_af_530_6 PRT_aC1_af_531_6 PRT_aC1_aa MU_aC1_at_50_6 MU_aC1_at_51_6 MU_aC1_at_52_6 MU_aC1_at_53_6 MU_aC1_at_54_6 MU_aC1_at_55_6 MU_aC1_at_56_6 MU_aC1_at_57_6 MU_aC1_at_58_6 MU_aC1_at_59_6 MU_aC1_at_510_6 MU_aC1_at_511_6 MU_aC1_at_512_6 MU_aC1_at_513_6 MU_aC1_at_514_6 MU_aC1_at_515_6 MU_aC1_at_516_6 MU_aC1_at_517_6 MU_aC1_at_518_6 MU_aC1_at_519_6 MU_aC1_at_520_6 MU_aC1_at_521_6 MU_aC1_at_522_6 MU_aC1_at_523_6 MU_aC1_at_524_6 MU_aC1_at_525_6 MU_aC1_at_526_6 MU_aC1_at_527_6 MU_aC1_at_528_6 MU_aC1_at_529_6 MU_aC1_at_530_6 MU_aC1_at_531_6 MU_aC1_af_50_6 MU_aC1_af_51_6 MU_aC1_af_52_6 MU_aC1_af_53_6 MU_aC1_af_54_6 MU_aC1_af_55_6 MU_aC1_af_56_6 MU_aC1_af_57_6 MU_aC1_af_58_6 MU_aC1_af_59_6 MU_aC1_af_510_6 MU_aC1_af_511_6 MU_aC1_af_512_6 MU_aC1_af_513_6 MU_aC1_af_514_6 MU_aC1_af_515_6 MU_aC1_af_516_6 MU_aC1_af_517_6 MU_aC1_af_518_6 MU_aC1_af_519_6 MU_aC1_af_520_6 MU_aC1_af_521_6 MU_aC1_af_522_6 MU_aC1_af_523_6 MU_aC1_af_524_6 MU_aC1_af_525_6 MU_aC1_af_526_6 MU_aC1_af_527_6 MU_aC1_af_528_6 MU_aC1_af_529_6 MU_aC1_af_530_6 MU_aC1_af_531_6 MU_aC1_aa C1o_at_50_6 C1o_at_51_6 C1o_at_52_6 C1o_at_53_6 C1o_at_54_6 C1o_at_55_6 C1o_at_56_6 C1o_at_57_6 C1o_at_58_6 C1o_at_59_6 C1o_at_510_6 C1o_at_511_6 C1o_at_512_6 C1o_at_513_6 C1o_at_514_6 C1o_at_515_6 C1o_at_516_6 C1o_at_517_6 C1o_at_518_6 C1o_at_519_6 C1o_at_520_6 C1o_at_521_6 C1o_at_522_6 C1o_at_523_6 C1o_at_524_6 C1o_at_525_6 C1o_at_526_6 C1o_at_527_6 C1o_at_528_6 C1o_at_529_6 C1o_at_530_6 C1o_at_531_6 C1o_af_50_6 C1o_af_51_6 C1o_af_52_6 C1o_af_53_6 C1o_af_54_6 C1o_af_55_6 C1o_af_56_6 C1o_af_57_6 C1o_af_58_6 C1o_af_59_6 C1o_af_510_6 C1o_af_511_6 C1o_af_512_6 C1o_af_513_6 C1o_af_514_6 C1o_af_515_6 C1o_af_516_6 C1o_af_517_6 C1o_af_518_6 C1o_af_519_6 C1o_af_520_6 C1o_af_521_6 C1o_af_522_6 C1o_af_523_6 C1o_af_524_6 C1o_af_525_6 C1o_af_526_6 C1o_af_527_6 C1o_af_528_6 C1o_af_529_6 C1o_af_530_6 C1o_af_531_6 C1o_aa Arb
xCRT2 reset C2i_at_50_6 C2i_at_51_6 C2i_at_52_6 C2i_at_53_6 C2i_at_54_6 C2i_at_55_6 C2i_at_56_6 C2i_at_57_6 C2i_at_58_6 C2i_at_59_6 C2i_at_510_6 C2i_at_511_6 C2i_at_512_6 C2i_at_513_6 C2i_at_514_6 C2i_at_515_6 C2i_at_516_6 C2i_at_517_6 C2i_at_518_6 C2i_at_519_6 C2i_at_520_6 C2i_at_521_6 C2i_at_522_6 C2i_at_523_6 C2i_at_524_6 C2i_at_525_6 C2i_at_526_6 C2i_at_527_6 C2i_at_528_6 C2i_at_529_6 C2i_at_530_6 C2i_at_531_6 C2i_af_50_6 C2i_af_51_6 C2i_af_52_6 C2i_af_53_6 C2i_af_54_6 C2i_af_55_6 C2i_af_56_6 C2i_af_57_6 C2i_af_58_6 C2i_af_59_6 C2i_af_510_6 C2i_af_511_6 C2i_af_512_6 C2i_af_513_6 C2i_af_514_6 C2i_af_515_6 C2i_af_516_6 C2i_af_517_6 C2i_af_518_6 C2i_af_519_6 C2i_af_520_6 C2i_af_521_6 C2i_af_522_6 C2i_af_523_6 C2i_af_524_6 C2i_af_525_6 C2i_af_526_6 C2i_af_527_6 C2i_af_528_6 C2i_af_529_6 C2i_af_530_6 C2i_af_531_6 C2i_aa ARM_aC2_at_50_6 ARM_aC2_at_51_6 ARM_aC2_at_52_6 ARM_aC2_at_53_6 ARM_aC2_at_54_6 ARM_aC2_at_55_6 ARM_aC2_at_56_6 ARM_aC2_at_57_6 ARM_aC2_at_58_6 ARM_aC2_at_59_6 ARM_aC2_at_510_6 ARM_aC2_at_511_6 ARM_aC2_at_512_6 ARM_aC2_at_513_6 ARM_aC2_at_514_6 ARM_aC2_at_515_6 ARM_aC2_at_516_6 ARM_aC2_at_517_6 ARM_aC2_at_518_6 ARM_aC2_at_519_6 ARM_aC2_at_520_6 ARM_aC2_at_521_6 ARM_aC2_at_522_6 ARM_aC2_at_523_6 ARM_aC2_at_524_6 ARM_aC2_at_525_6 ARM_aC2_at_526_6 ARM_aC2_at_527_6 ARM_aC2_at_528_6 ARM_aC2_at_529_6 ARM_aC2_at_530_6 ARM_aC2_at_531_6 ARM_aC2_af_50_6 ARM_aC2_af_51_6 ARM_aC2_af_52_6 ARM_aC2_af_53_6 ARM_aC2_af_54_6 ARM_aC2_af_55_6 ARM_aC2_af_56_6 ARM_aC2_af_57_6 ARM_aC2_af_58_6 ARM_aC2_af_59_6 ARM_aC2_af_510_6 ARM_aC2_af_511_6 ARM_aC2_af_512_6 ARM_aC2_af_513_6 ARM_aC2_af_514_6 ARM_aC2_af_515_6 ARM_aC2_af_516_6 ARM_aC2_af_517_6 ARM_aC2_af_518_6 ARM_aC2_af_519_6 ARM_aC2_af_520_6 ARM_aC2_af_521_6 ARM_aC2_af_522_6 ARM_aC2_af_523_6 ARM_aC2_af_524_6 ARM_aC2_af_525_6 ARM_aC2_af_526_6 ARM_aC2_af_527_6 ARM_aC2_af_528_6 ARM_aC2_af_529_6 ARM_aC2_af_530_6 ARM_aC2_af_531_6 ARM_aC2_aa ARP_aC2_at_50_6 ARP_aC2_at_51_6 ARP_aC2_at_52_6 ARP_aC2_at_53_6 ARP_aC2_at_54_6 ARP_aC2_at_55_6 ARP_aC2_at_56_6 ARP_aC2_at_57_6 ARP_aC2_at_58_6 ARP_aC2_at_59_6 ARP_aC2_at_510_6 ARP_aC2_at_511_6 ARP_aC2_at_512_6 ARP_aC2_at_513_6 ARP_aC2_at_514_6 ARP_aC2_at_515_6 ARP_aC2_at_516_6 ARP_aC2_at_517_6 ARP_aC2_at_518_6 ARP_aC2_at_519_6 ARP_aC2_at_520_6 ARP_aC2_at_521_6 ARP_aC2_at_522_6 ARP_aC2_at_523_6 ARP_aC2_at_524_6 ARP_aC2_at_525_6 ARP_aC2_at_526_6 ARP_aC2_at_527_6 ARP_aC2_at_528_6 ARP_aC2_at_529_6 ARP_aC2_at_530_6 ARP_aC2_at_531_6 ARP_aC2_af_50_6 ARP_aC2_af_51_6 ARP_aC2_af_52_6 ARP_aC2_af_53_6 ARP_aC2_af_54_6 ARP_aC2_af_55_6 ARP_aC2_af_56_6 ARP_aC2_af_57_6 ARP_aC2_af_58_6 ARP_aC2_af_59_6 ARP_aC2_af_510_6 ARP_aC2_af_511_6 ARP_aC2_af_512_6 ARP_aC2_af_513_6 ARP_aC2_af_514_6 ARP_aC2_af_515_6 ARP_aC2_af_516_6 ARP_aC2_af_517_6 ARP_aC2_af_518_6 ARP_aC2_af_519_6 ARP_aC2_af_520_6 ARP_aC2_af_521_6 ARP_aC2_af_522_6 ARP_aC2_af_523_6 ARP_aC2_af_524_6 ARP_aC2_af_525_6 ARP_aC2_af_526_6 ARP_aC2_af_527_6 ARP_aC2_af_528_6 ARP_aC2_af_529_6 ARP_aC2_af_530_6 ARP_aC2_af_531_6 ARP_aC2_aa ARC0_aC2_at_50_6 ARC0_aC2_at_51_6 ARC0_aC2_at_52_6 ARC0_aC2_at_53_6 ARC0_aC2_at_54_6 ARC0_aC2_at_55_6 ARC0_aC2_at_56_6 ARC0_aC2_at_57_6 ARC0_aC2_at_58_6 ARC0_aC2_at_59_6 ARC0_aC2_at_510_6 ARC0_aC2_at_511_6 ARC0_aC2_at_512_6 ARC0_aC2_at_513_6 ARC0_aC2_at_514_6 ARC0_aC2_at_515_6 ARC0_aC2_at_516_6 ARC0_aC2_at_517_6 ARC0_aC2_at_518_6 ARC0_aC2_at_519_6 ARC0_aC2_at_520_6 ARC0_aC2_at_521_6 ARC0_aC2_at_522_6 ARC0_aC2_at_523_6 ARC0_aC2_at_524_6 ARC0_aC2_at_525_6 ARC0_aC2_at_526_6 ARC0_aC2_at_527_6 ARC0_aC2_at_528_6 ARC0_aC2_at_529_6 ARC0_aC2_at_530_6 ARC0_aC2_at_531_6 ARC0_aC2_af_50_6 ARC0_aC2_af_51_6 ARC0_aC2_af_52_6 ARC0_aC2_af_53_6 ARC0_aC2_af_54_6 ARC0_aC2_af_55_6 ARC0_aC2_af_56_6 ARC0_aC2_af_57_6 ARC0_aC2_af_58_6 ARC0_aC2_af_59_6 ARC0_aC2_af_510_6 ARC0_aC2_af_511_6 ARC0_aC2_af_512_6 ARC0_aC2_af_513_6 ARC0_aC2_af_514_6 ARC0_aC2_af_515_6 ARC0_aC2_af_516_6 ARC0_aC2_af_517_6 ARC0_aC2_af_518_6 ARC0_aC2_af_519_6 ARC0_aC2_af_520_6 ARC0_aC2_af_521_6 ARC0_aC2_af_522_6 ARC0_aC2_af_523_6 ARC0_aC2_af_524_6 ARC0_aC2_af_525_6 ARC0_aC2_af_526_6 ARC0_aC2_af_527_6 ARC0_aC2_af_528_6 ARC0_aC2_af_529_6 ARC0_aC2_af_530_6 ARC0_aC2_af_531_6 ARC0_aC2_aa ARC1_aC2_at_50_6 ARC1_aC2_at_51_6 ARC1_aC2_at_52_6 ARC1_aC2_at_53_6 ARC1_aC2_at_54_6 ARC1_aC2_at_55_6 ARC1_aC2_at_56_6 ARC1_aC2_at_57_6 ARC1_aC2_at_58_6 ARC1_aC2_at_59_6 ARC1_aC2_at_510_6 ARC1_aC2_at_511_6 ARC1_aC2_at_512_6 ARC1_aC2_at_513_6 ARC1_aC2_at_514_6 ARC1_aC2_at_515_6 ARC1_aC2_at_516_6 ARC1_aC2_at_517_6 ARC1_aC2_at_518_6 ARC1_aC2_at_519_6 ARC1_aC2_at_520_6 ARC1_aC2_at_521_6 ARC1_aC2_at_522_6 ARC1_aC2_at_523_6 ARC1_aC2_at_524_6 ARC1_aC2_at_525_6 ARC1_aC2_at_526_6 ARC1_aC2_at_527_6 ARC1_aC2_at_528_6 ARC1_aC2_at_529_6 ARC1_aC2_at_530_6 ARC1_aC2_at_531_6 ARC1_aC2_af_50_6 ARC1_aC2_af_51_6 ARC1_aC2_af_52_6 ARC1_aC2_af_53_6 ARC1_aC2_af_54_6 ARC1_aC2_af_55_6 ARC1_aC2_af_56_6 ARC1_aC2_af_57_6 ARC1_aC2_af_58_6 ARC1_aC2_af_59_6 ARC1_aC2_af_510_6 ARC1_aC2_af_511_6 ARC1_aC2_af_512_6 ARC1_aC2_af_513_6 ARC1_aC2_af_514_6 ARC1_aC2_af_515_6 ARC1_aC2_af_516_6 ARC1_aC2_af_517_6 ARC1_aC2_af_518_6 ARC1_aC2_af_519_6 ARC1_aC2_af_520_6 ARC1_aC2_af_521_6 ARC1_aC2_af_522_6 ARC1_aC2_af_523_6 ARC1_aC2_af_524_6 ARC1_aC2_af_525_6 ARC1_aC2_af_526_6 ARC1_aC2_af_527_6 ARC1_aC2_af_528_6 ARC1_aC2_af_529_6 ARC1_aC2_af_530_6 ARC1_aC2_af_531_6 ARC1_aC2_aa ARC2_aC2_at_50_6 ARC2_aC2_at_51_6 ARC2_aC2_at_52_6 ARC2_aC2_at_53_6 ARC2_aC2_at_54_6 ARC2_aC2_at_55_6 ARC2_aC2_at_56_6 ARC2_aC2_at_57_6 ARC2_aC2_at_58_6 ARC2_aC2_at_59_6 ARC2_aC2_at_510_6 ARC2_aC2_at_511_6 ARC2_aC2_at_512_6 ARC2_aC2_at_513_6 ARC2_aC2_at_514_6 ARC2_aC2_at_515_6 ARC2_aC2_at_516_6 ARC2_aC2_at_517_6 ARC2_aC2_at_518_6 ARC2_aC2_at_519_6 ARC2_aC2_at_520_6 ARC2_aC2_at_521_6 ARC2_aC2_at_522_6 ARC2_aC2_at_523_6 ARC2_aC2_at_524_6 ARC2_aC2_at_525_6 ARC2_aC2_at_526_6 ARC2_aC2_at_527_6 ARC2_aC2_at_528_6 ARC2_aC2_at_529_6 ARC2_aC2_at_530_6 ARC2_aC2_at_531_6 ARC2_aC2_af_50_6 ARC2_aC2_af_51_6 ARC2_aC2_af_52_6 ARC2_aC2_af_53_6 ARC2_aC2_af_54_6 ARC2_aC2_af_55_6 ARC2_aC2_af_56_6 ARC2_aC2_af_57_6 ARC2_aC2_af_58_6 ARC2_aC2_af_59_6 ARC2_aC2_af_510_6 ARC2_aC2_af_511_6 ARC2_aC2_af_512_6 ARC2_aC2_af_513_6 ARC2_aC2_af_514_6 ARC2_aC2_af_515_6 ARC2_aC2_af_516_6 ARC2_aC2_af_517_6 ARC2_aC2_af_518_6 ARC2_aC2_af_519_6 ARC2_aC2_af_520_6 ARC2_aC2_af_521_6 ARC2_aC2_af_522_6 ARC2_aC2_af_523_6 ARC2_aC2_af_524_6 ARC2_aC2_af_525_6 ARC2_aC2_af_526_6 ARC2_aC2_af_527_6 ARC2_aC2_af_528_6 ARC2_aC2_af_529_6 ARC2_aC2_af_530_6 ARC2_aC2_af_531_6 ARC2_aC2_aa ARC3_aC2_at_50_6 ARC3_aC2_at_51_6 ARC3_aC2_at_52_6 ARC3_aC2_at_53_6 ARC3_aC2_at_54_6 ARC3_aC2_at_55_6 ARC3_aC2_at_56_6 ARC3_aC2_at_57_6 ARC3_aC2_at_58_6 ARC3_aC2_at_59_6 ARC3_aC2_at_510_6 ARC3_aC2_at_511_6 ARC3_aC2_at_512_6 ARC3_aC2_at_513_6 ARC3_aC2_at_514_6 ARC3_aC2_at_515_6 ARC3_aC2_at_516_6 ARC3_aC2_at_517_6 ARC3_aC2_at_518_6 ARC3_aC2_at_519_6 ARC3_aC2_at_520_6 ARC3_aC2_at_521_6 ARC3_aC2_at_522_6 ARC3_aC2_at_523_6 ARC3_aC2_at_524_6 ARC3_aC2_at_525_6 ARC3_aC2_at_526_6 ARC3_aC2_at_527_6 ARC3_aC2_at_528_6 ARC3_aC2_at_529_6 ARC3_aC2_at_530_6 ARC3_aC2_at_531_6 ARC3_aC2_af_50_6 ARC3_aC2_af_51_6 ARC3_aC2_af_52_6 ARC3_aC2_af_53_6 ARC3_aC2_af_54_6 ARC3_aC2_af_55_6 ARC3_aC2_af_56_6 ARC3_aC2_af_57_6 ARC3_aC2_af_58_6 ARC3_aC2_af_59_6 ARC3_aC2_af_510_6 ARC3_aC2_af_511_6 ARC3_aC2_af_512_6 ARC3_aC2_af_513_6 ARC3_aC2_af_514_6 ARC3_aC2_af_515_6 ARC3_aC2_af_516_6 ARC3_aC2_af_517_6 ARC3_aC2_af_518_6 ARC3_aC2_af_519_6 ARC3_aC2_af_520_6 ARC3_aC2_af_521_6 ARC3_aC2_af_522_6 ARC3_aC2_af_523_6 ARC3_aC2_af_524_6 ARC3_aC2_af_525_6 ARC3_aC2_af_526_6 ARC3_aC2_af_527_6 ARC3_aC2_af_528_6 ARC3_aC2_af_529_6 ARC3_aC2_af_530_6 ARC3_aC2_af_531_6 ARC3_aC2_aa ChildRouter
xMU reset MU_aI_at_50_6 MU_aI_at_51_6 MU_aI_at_52_6 MU_aI_at_53_6 MU_aI_at_54_6 MU_aI_at_55_6 MU_aI_at_56_6 MU_aI_at_57_6 MU_aI_at_58_6 MU_aI_at_59_6 MU_aI_at_510_6 MU_aI_at_511_6 MU_aI_at_512_6 MU_aI_at_513_6 MU_aI_at_514_6 MU_aI_at_515_6 MU_aI_at_516_6 MU_aI_at_517_6 MU_aI_at_518_6 MU_aI_at_519_6 MU_aI_at_520_6 MU_aI_at_521_6 MU_aI_at_522_6 MU_aI_at_523_6 MU_aI_at_524_6 MU_aI_at_525_6 MU_aI_at_526_6 MU_aI_at_527_6 MU_aI_at_528_6 MU_aI_at_529_6 MU_aI_at_530_6 MU_aI_at_531_6 MU_aI_af_50_6 MU_aI_af_51_6 MU_aI_af_52_6 MU_aI_af_53_6 MU_aI_af_54_6 MU_aI_af_55_6 MU_aI_af_56_6 MU_aI_af_57_6 MU_aI_af_58_6 MU_aI_af_59_6 MU_aI_af_510_6 MU_aI_af_511_6 MU_aI_af_512_6 MU_aI_af_513_6 MU_aI_af_514_6 MU_aI_af_515_6 MU_aI_af_516_6 MU_aI_af_517_6 MU_aI_af_518_6 MU_aI_af_519_6 MU_aI_af_520_6 MU_aI_af_521_6 MU_aI_af_522_6 MU_aI_af_523_6 MU_aI_af_524_6 MU_aI_af_525_6 MU_aI_af_526_6 MU_aI_af_527_6 MU_aI_af_528_6 MU_aI_af_529_6 MU_aI_af_530_6 MU_aI_af_531_6 MU_aI_aa MU_aC0_at_50_6 MU_aC0_at_51_6 MU_aC0_at_52_6 MU_aC0_at_53_6 MU_aC0_at_54_6 MU_aC0_at_55_6 MU_aC0_at_56_6 MU_aC0_at_57_6 MU_aC0_at_58_6 MU_aC0_at_59_6 MU_aC0_at_510_6 MU_aC0_at_511_6 MU_aC0_at_512_6 MU_aC0_at_513_6 MU_aC0_at_514_6 MU_aC0_at_515_6 MU_aC0_at_516_6 MU_aC0_at_517_6 MU_aC0_at_518_6 MU_aC0_at_519_6 MU_aC0_at_520_6 MU_aC0_at_521_6 MU_aC0_at_522_6 MU_aC0_at_523_6 MU_aC0_at_524_6 MU_aC0_at_525_6 MU_aC0_at_526_6 MU_aC0_at_527_6 MU_aC0_at_528_6 MU_aC0_at_529_6 MU_aC0_at_530_6 MU_aC0_at_531_6 MU_aC0_af_50_6 MU_aC0_af_51_6 MU_aC0_af_52_6 MU_aC0_af_53_6 MU_aC0_af_54_6 MU_aC0_af_55_6 MU_aC0_af_56_6 MU_aC0_af_57_6 MU_aC0_af_58_6 MU_aC0_af_59_6 MU_aC0_af_510_6 MU_aC0_af_511_6 MU_aC0_af_512_6 MU_aC0_af_513_6 MU_aC0_af_514_6 MU_aC0_af_515_6 MU_aC0_af_516_6 MU_aC0_af_517_6 MU_aC0_af_518_6 MU_aC0_af_519_6 MU_aC0_af_520_6 MU_aC0_af_521_6 MU_aC0_af_522_6 MU_aC0_af_523_6 MU_aC0_af_524_6 MU_aC0_af_525_6 MU_aC0_af_526_6 MU_aC0_af_527_6 MU_aC0_af_528_6 MU_aC0_af_529_6 MU_aC0_af_530_6 MU_aC0_af_531_6 MU_aC0_aa MU_aC1_at_50_6 MU_aC1_at_51_6 MU_aC1_at_52_6 MU_aC1_at_53_6 MU_aC1_at_54_6 MU_aC1_at_55_6 MU_aC1_at_56_6 MU_aC1_at_57_6 MU_aC1_at_58_6 MU_aC1_at_59_6 MU_aC1_at_510_6 MU_aC1_at_511_6 MU_aC1_at_512_6 MU_aC1_at_513_6 MU_aC1_at_514_6 MU_aC1_at_515_6 MU_aC1_at_516_6 MU_aC1_at_517_6 MU_aC1_at_518_6 MU_aC1_at_519_6 MU_aC1_at_520_6 MU_aC1_at_521_6 MU_aC1_at_522_6 MU_aC1_at_523_6 MU_aC1_at_524_6 MU_aC1_at_525_6 MU_aC1_at_526_6 MU_aC1_at_527_6 MU_aC1_at_528_6 MU_aC1_at_529_6 MU_aC1_at_530_6 MU_aC1_at_531_6 MU_aC1_af_50_6 MU_aC1_af_51_6 MU_aC1_af_52_6 MU_aC1_af_53_6 MU_aC1_af_54_6 MU_aC1_af_55_6 MU_aC1_af_56_6 MU_aC1_af_57_6 MU_aC1_af_58_6 MU_aC1_af_59_6 MU_aC1_af_510_6 MU_aC1_af_511_6 MU_aC1_af_512_6 MU_aC1_af_513_6 MU_aC1_af_514_6 MU_aC1_af_515_6 MU_aC1_af_516_6 MU_aC1_af_517_6 MU_aC1_af_518_6 MU_aC1_af_519_6 MU_aC1_af_520_6 MU_aC1_af_521_6 MU_aC1_af_522_6 MU_aC1_af_523_6 MU_aC1_af_524_6 MU_aC1_af_525_6 MU_aC1_af_526_6 MU_aC1_af_527_6 MU_aC1_af_528_6 MU_aC1_af_529_6 MU_aC1_af_530_6 MU_aC1_af_531_6 MU_aC1_aa MU_aC2_at_50_6 MU_aC2_at_51_6 MU_aC2_at_52_6 MU_aC2_at_53_6 MU_aC2_at_54_6 MU_aC2_at_55_6 MU_aC2_at_56_6 MU_aC2_at_57_6 MU_aC2_at_58_6 MU_aC2_at_59_6 MU_aC2_at_510_6 MU_aC2_at_511_6 MU_aC2_at_512_6 MU_aC2_at_513_6 MU_aC2_at_514_6 MU_aC2_at_515_6 MU_aC2_at_516_6 MU_aC2_at_517_6 MU_aC2_at_518_6 MU_aC2_at_519_6 MU_aC2_at_520_6 MU_aC2_at_521_6 MU_aC2_at_522_6 MU_aC2_at_523_6 MU_aC2_at_524_6 MU_aC2_at_525_6 MU_aC2_at_526_6 MU_aC2_at_527_6 MU_aC2_at_528_6 MU_aC2_at_529_6 MU_aC2_at_530_6 MU_aC2_at_531_6 MU_aC2_af_50_6 MU_aC2_af_51_6 MU_aC2_af_52_6 MU_aC2_af_53_6 MU_aC2_af_54_6 MU_aC2_af_55_6 MU_aC2_af_56_6 MU_aC2_af_57_6 MU_aC2_af_58_6 MU_aC2_af_59_6 MU_aC2_af_510_6 MU_aC2_af_511_6 MU_aC2_af_512_6 MU_aC2_af_513_6 MU_aC2_af_514_6 MU_aC2_af_515_6 MU_aC2_af_516_6 MU_aC2_af_517_6 MU_aC2_af_518_6 MU_aC2_af_519_6 MU_aC2_af_520_6 MU_aC2_af_521_6 MU_aC2_af_522_6 MU_aC2_af_523_6 MU_aC2_af_524_6 MU_aC2_af_525_6 MU_aC2_af_526_6 MU_aC2_af_527_6 MU_aC2_af_528_6 MU_aC2_af_529_6 MU_aC2_af_530_6 MU_aC2_af_531_6 MU_aC2_aa MU_aC3_at_50_6 MU_aC3_at_51_6 MU_aC3_at_52_6 MU_aC3_at_53_6 MU_aC3_at_54_6 MU_aC3_at_55_6 MU_aC3_at_56_6 MU_aC3_at_57_6 MU_aC3_at_58_6 MU_aC3_at_59_6 MU_aC3_at_510_6 MU_aC3_at_511_6 MU_aC3_at_512_6 MU_aC3_at_513_6 MU_aC3_at_514_6 MU_aC3_at_515_6 MU_aC3_at_516_6 MU_aC3_at_517_6 MU_aC3_at_518_6 MU_aC3_at_519_6 MU_aC3_at_520_6 MU_aC3_at_521_6 MU_aC3_at_522_6 MU_aC3_at_523_6 MU_aC3_at_524_6 MU_aC3_at_525_6 MU_aC3_at_526_6 MU_aC3_at_527_6 MU_aC3_at_528_6 MU_aC3_at_529_6 MU_aC3_at_530_6 MU_aC3_at_531_6 MU_aC3_af_50_6 MU_aC3_af_51_6 MU_aC3_af_52_6 MU_aC3_af_53_6 MU_aC3_af_54_6 MU_aC3_af_55_6 MU_aC3_af_56_6 MU_aC3_af_57_6 MU_aC3_af_58_6 MU_aC3_af_59_6 MU_aC3_af_510_6 MU_aC3_af_511_6 MU_aC3_af_512_6 MU_aC3_af_513_6 MU_aC3_af_514_6 MU_aC3_af_515_6 MU_aC3_af_516_6 MU_aC3_af_517_6 MU_aC3_af_518_6 MU_aC3_af_519_6 MU_aC3_af_520_6 MU_aC3_af_521_6 MU_aC3_af_522_6 MU_aC3_af_523_6 MU_aC3_af_524_6 MU_aC3_af_525_6 MU_aC3_af_526_6 MU_aC3_af_527_6 MU_aC3_af_528_6 MU_aC3_af_529_6 MU_aC3_af_530_6 MU_aC3_af_531_6 MU_aC3_aa MltcUnit
xCRT0 reset C0i_at_50_6 C0i_at_51_6 C0i_at_52_6 C0i_at_53_6 C0i_at_54_6 C0i_at_55_6 C0i_at_56_6 C0i_at_57_6 C0i_at_58_6 C0i_at_59_6 C0i_at_510_6 C0i_at_511_6 C0i_at_512_6 C0i_at_513_6 C0i_at_514_6 C0i_at_515_6 C0i_at_516_6 C0i_at_517_6 C0i_at_518_6 C0i_at_519_6 C0i_at_520_6 C0i_at_521_6 C0i_at_522_6 C0i_at_523_6 C0i_at_524_6 C0i_at_525_6 C0i_at_526_6 C0i_at_527_6 C0i_at_528_6 C0i_at_529_6 C0i_at_530_6 C0i_at_531_6 C0i_af_50_6 C0i_af_51_6 C0i_af_52_6 C0i_af_53_6 C0i_af_54_6 C0i_af_55_6 C0i_af_56_6 C0i_af_57_6 C0i_af_58_6 C0i_af_59_6 C0i_af_510_6 C0i_af_511_6 C0i_af_512_6 C0i_af_513_6 C0i_af_514_6 C0i_af_515_6 C0i_af_516_6 C0i_af_517_6 C0i_af_518_6 C0i_af_519_6 C0i_af_520_6 C0i_af_521_6 C0i_af_522_6 C0i_af_523_6 C0i_af_524_6 C0i_af_525_6 C0i_af_526_6 C0i_af_527_6 C0i_af_528_6 C0i_af_529_6 C0i_af_530_6 C0i_af_531_6 C0i_aa ARM_aC0_at_50_6 ARM_aC0_at_51_6 ARM_aC0_at_52_6 ARM_aC0_at_53_6 ARM_aC0_at_54_6 ARM_aC0_at_55_6 ARM_aC0_at_56_6 ARM_aC0_at_57_6 ARM_aC0_at_58_6 ARM_aC0_at_59_6 ARM_aC0_at_510_6 ARM_aC0_at_511_6 ARM_aC0_at_512_6 ARM_aC0_at_513_6 ARM_aC0_at_514_6 ARM_aC0_at_515_6 ARM_aC0_at_516_6 ARM_aC0_at_517_6 ARM_aC0_at_518_6 ARM_aC0_at_519_6 ARM_aC0_at_520_6 ARM_aC0_at_521_6 ARM_aC0_at_522_6 ARM_aC0_at_523_6 ARM_aC0_at_524_6 ARM_aC0_at_525_6 ARM_aC0_at_526_6 ARM_aC0_at_527_6 ARM_aC0_at_528_6 ARM_aC0_at_529_6 ARM_aC0_at_530_6 ARM_aC0_at_531_6 ARM_aC0_af_50_6 ARM_aC0_af_51_6 ARM_aC0_af_52_6 ARM_aC0_af_53_6 ARM_aC0_af_54_6 ARM_aC0_af_55_6 ARM_aC0_af_56_6 ARM_aC0_af_57_6 ARM_aC0_af_58_6 ARM_aC0_af_59_6 ARM_aC0_af_510_6 ARM_aC0_af_511_6 ARM_aC0_af_512_6 ARM_aC0_af_513_6 ARM_aC0_af_514_6 ARM_aC0_af_515_6 ARM_aC0_af_516_6 ARM_aC0_af_517_6 ARM_aC0_af_518_6 ARM_aC0_af_519_6 ARM_aC0_af_520_6 ARM_aC0_af_521_6 ARM_aC0_af_522_6 ARM_aC0_af_523_6 ARM_aC0_af_524_6 ARM_aC0_af_525_6 ARM_aC0_af_526_6 ARM_aC0_af_527_6 ARM_aC0_af_528_6 ARM_aC0_af_529_6 ARM_aC0_af_530_6 ARM_aC0_af_531_6 ARM_aC0_aa ARP_aC0_at_50_6 ARP_aC0_at_51_6 ARP_aC0_at_52_6 ARP_aC0_at_53_6 ARP_aC0_at_54_6 ARP_aC0_at_55_6 ARP_aC0_at_56_6 ARP_aC0_at_57_6 ARP_aC0_at_58_6 ARP_aC0_at_59_6 ARP_aC0_at_510_6 ARP_aC0_at_511_6 ARP_aC0_at_512_6 ARP_aC0_at_513_6 ARP_aC0_at_514_6 ARP_aC0_at_515_6 ARP_aC0_at_516_6 ARP_aC0_at_517_6 ARP_aC0_at_518_6 ARP_aC0_at_519_6 ARP_aC0_at_520_6 ARP_aC0_at_521_6 ARP_aC0_at_522_6 ARP_aC0_at_523_6 ARP_aC0_at_524_6 ARP_aC0_at_525_6 ARP_aC0_at_526_6 ARP_aC0_at_527_6 ARP_aC0_at_528_6 ARP_aC0_at_529_6 ARP_aC0_at_530_6 ARP_aC0_at_531_6 ARP_aC0_af_50_6 ARP_aC0_af_51_6 ARP_aC0_af_52_6 ARP_aC0_af_53_6 ARP_aC0_af_54_6 ARP_aC0_af_55_6 ARP_aC0_af_56_6 ARP_aC0_af_57_6 ARP_aC0_af_58_6 ARP_aC0_af_59_6 ARP_aC0_af_510_6 ARP_aC0_af_511_6 ARP_aC0_af_512_6 ARP_aC0_af_513_6 ARP_aC0_af_514_6 ARP_aC0_af_515_6 ARP_aC0_af_516_6 ARP_aC0_af_517_6 ARP_aC0_af_518_6 ARP_aC0_af_519_6 ARP_aC0_af_520_6 ARP_aC0_af_521_6 ARP_aC0_af_522_6 ARP_aC0_af_523_6 ARP_aC0_af_524_6 ARP_aC0_af_525_6 ARP_aC0_af_526_6 ARP_aC0_af_527_6 ARP_aC0_af_528_6 ARP_aC0_af_529_6 ARP_aC0_af_530_6 ARP_aC0_af_531_6 ARP_aC0_aa ARC0_aC0_at_50_6 ARC0_aC0_at_51_6 ARC0_aC0_at_52_6 ARC0_aC0_at_53_6 ARC0_aC0_at_54_6 ARC0_aC0_at_55_6 ARC0_aC0_at_56_6 ARC0_aC0_at_57_6 ARC0_aC0_at_58_6 ARC0_aC0_at_59_6 ARC0_aC0_at_510_6 ARC0_aC0_at_511_6 ARC0_aC0_at_512_6 ARC0_aC0_at_513_6 ARC0_aC0_at_514_6 ARC0_aC0_at_515_6 ARC0_aC0_at_516_6 ARC0_aC0_at_517_6 ARC0_aC0_at_518_6 ARC0_aC0_at_519_6 ARC0_aC0_at_520_6 ARC0_aC0_at_521_6 ARC0_aC0_at_522_6 ARC0_aC0_at_523_6 ARC0_aC0_at_524_6 ARC0_aC0_at_525_6 ARC0_aC0_at_526_6 ARC0_aC0_at_527_6 ARC0_aC0_at_528_6 ARC0_aC0_at_529_6 ARC0_aC0_at_530_6 ARC0_aC0_at_531_6 ARC0_aC0_af_50_6 ARC0_aC0_af_51_6 ARC0_aC0_af_52_6 ARC0_aC0_af_53_6 ARC0_aC0_af_54_6 ARC0_aC0_af_55_6 ARC0_aC0_af_56_6 ARC0_aC0_af_57_6 ARC0_aC0_af_58_6 ARC0_aC0_af_59_6 ARC0_aC0_af_510_6 ARC0_aC0_af_511_6 ARC0_aC0_af_512_6 ARC0_aC0_af_513_6 ARC0_aC0_af_514_6 ARC0_aC0_af_515_6 ARC0_aC0_af_516_6 ARC0_aC0_af_517_6 ARC0_aC0_af_518_6 ARC0_aC0_af_519_6 ARC0_aC0_af_520_6 ARC0_aC0_af_521_6 ARC0_aC0_af_522_6 ARC0_aC0_af_523_6 ARC0_aC0_af_524_6 ARC0_aC0_af_525_6 ARC0_aC0_af_526_6 ARC0_aC0_af_527_6 ARC0_aC0_af_528_6 ARC0_aC0_af_529_6 ARC0_aC0_af_530_6 ARC0_aC0_af_531_6 ARC0_aC0_aa ARC1_aC0_at_50_6 ARC1_aC0_at_51_6 ARC1_aC0_at_52_6 ARC1_aC0_at_53_6 ARC1_aC0_at_54_6 ARC1_aC0_at_55_6 ARC1_aC0_at_56_6 ARC1_aC0_at_57_6 ARC1_aC0_at_58_6 ARC1_aC0_at_59_6 ARC1_aC0_at_510_6 ARC1_aC0_at_511_6 ARC1_aC0_at_512_6 ARC1_aC0_at_513_6 ARC1_aC0_at_514_6 ARC1_aC0_at_515_6 ARC1_aC0_at_516_6 ARC1_aC0_at_517_6 ARC1_aC0_at_518_6 ARC1_aC0_at_519_6 ARC1_aC0_at_520_6 ARC1_aC0_at_521_6 ARC1_aC0_at_522_6 ARC1_aC0_at_523_6 ARC1_aC0_at_524_6 ARC1_aC0_at_525_6 ARC1_aC0_at_526_6 ARC1_aC0_at_527_6 ARC1_aC0_at_528_6 ARC1_aC0_at_529_6 ARC1_aC0_at_530_6 ARC1_aC0_at_531_6 ARC1_aC0_af_50_6 ARC1_aC0_af_51_6 ARC1_aC0_af_52_6 ARC1_aC0_af_53_6 ARC1_aC0_af_54_6 ARC1_aC0_af_55_6 ARC1_aC0_af_56_6 ARC1_aC0_af_57_6 ARC1_aC0_af_58_6 ARC1_aC0_af_59_6 ARC1_aC0_af_510_6 ARC1_aC0_af_511_6 ARC1_aC0_af_512_6 ARC1_aC0_af_513_6 ARC1_aC0_af_514_6 ARC1_aC0_af_515_6 ARC1_aC0_af_516_6 ARC1_aC0_af_517_6 ARC1_aC0_af_518_6 ARC1_aC0_af_519_6 ARC1_aC0_af_520_6 ARC1_aC0_af_521_6 ARC1_aC0_af_522_6 ARC1_aC0_af_523_6 ARC1_aC0_af_524_6 ARC1_aC0_af_525_6 ARC1_aC0_af_526_6 ARC1_aC0_af_527_6 ARC1_aC0_af_528_6 ARC1_aC0_af_529_6 ARC1_aC0_af_530_6 ARC1_aC0_af_531_6 ARC1_aC0_aa ARC2_aC0_at_50_6 ARC2_aC0_at_51_6 ARC2_aC0_at_52_6 ARC2_aC0_at_53_6 ARC2_aC0_at_54_6 ARC2_aC0_at_55_6 ARC2_aC0_at_56_6 ARC2_aC0_at_57_6 ARC2_aC0_at_58_6 ARC2_aC0_at_59_6 ARC2_aC0_at_510_6 ARC2_aC0_at_511_6 ARC2_aC0_at_512_6 ARC2_aC0_at_513_6 ARC2_aC0_at_514_6 ARC2_aC0_at_515_6 ARC2_aC0_at_516_6 ARC2_aC0_at_517_6 ARC2_aC0_at_518_6 ARC2_aC0_at_519_6 ARC2_aC0_at_520_6 ARC2_aC0_at_521_6 ARC2_aC0_at_522_6 ARC2_aC0_at_523_6 ARC2_aC0_at_524_6 ARC2_aC0_at_525_6 ARC2_aC0_at_526_6 ARC2_aC0_at_527_6 ARC2_aC0_at_528_6 ARC2_aC0_at_529_6 ARC2_aC0_at_530_6 ARC2_aC0_at_531_6 ARC2_aC0_af_50_6 ARC2_aC0_af_51_6 ARC2_aC0_af_52_6 ARC2_aC0_af_53_6 ARC2_aC0_af_54_6 ARC2_aC0_af_55_6 ARC2_aC0_af_56_6 ARC2_aC0_af_57_6 ARC2_aC0_af_58_6 ARC2_aC0_af_59_6 ARC2_aC0_af_510_6 ARC2_aC0_af_511_6 ARC2_aC0_af_512_6 ARC2_aC0_af_513_6 ARC2_aC0_af_514_6 ARC2_aC0_af_515_6 ARC2_aC0_af_516_6 ARC2_aC0_af_517_6 ARC2_aC0_af_518_6 ARC2_aC0_af_519_6 ARC2_aC0_af_520_6 ARC2_aC0_af_521_6 ARC2_aC0_af_522_6 ARC2_aC0_af_523_6 ARC2_aC0_af_524_6 ARC2_aC0_af_525_6 ARC2_aC0_af_526_6 ARC2_aC0_af_527_6 ARC2_aC0_af_528_6 ARC2_aC0_af_529_6 ARC2_aC0_af_530_6 ARC2_aC0_af_531_6 ARC2_aC0_aa ARC3_aC0_at_50_6 ARC3_aC0_at_51_6 ARC3_aC0_at_52_6 ARC3_aC0_at_53_6 ARC3_aC0_at_54_6 ARC3_aC0_at_55_6 ARC3_aC0_at_56_6 ARC3_aC0_at_57_6 ARC3_aC0_at_58_6 ARC3_aC0_at_59_6 ARC3_aC0_at_510_6 ARC3_aC0_at_511_6 ARC3_aC0_at_512_6 ARC3_aC0_at_513_6 ARC3_aC0_at_514_6 ARC3_aC0_at_515_6 ARC3_aC0_at_516_6 ARC3_aC0_at_517_6 ARC3_aC0_at_518_6 ARC3_aC0_at_519_6 ARC3_aC0_at_520_6 ARC3_aC0_at_521_6 ARC3_aC0_at_522_6 ARC3_aC0_at_523_6 ARC3_aC0_at_524_6 ARC3_aC0_at_525_6 ARC3_aC0_at_526_6 ARC3_aC0_at_527_6 ARC3_aC0_at_528_6 ARC3_aC0_at_529_6 ARC3_aC0_at_530_6 ARC3_aC0_at_531_6 ARC3_aC0_af_50_6 ARC3_aC0_af_51_6 ARC3_aC0_af_52_6 ARC3_aC0_af_53_6 ARC3_aC0_af_54_6 ARC3_aC0_af_55_6 ARC3_aC0_af_56_6 ARC3_aC0_af_57_6 ARC3_aC0_af_58_6 ARC3_aC0_af_59_6 ARC3_aC0_af_510_6 ARC3_aC0_af_511_6 ARC3_aC0_af_512_6 ARC3_aC0_af_513_6 ARC3_aC0_af_514_6 ARC3_aC0_af_515_6 ARC3_aC0_af_516_6 ARC3_aC0_af_517_6 ARC3_aC0_af_518_6 ARC3_aC0_af_519_6 ARC3_aC0_af_520_6 ARC3_aC0_af_521_6 ARC3_aC0_af_522_6 ARC3_aC0_af_523_6 ARC3_aC0_af_524_6 ARC3_aC0_af_525_6 ARC3_aC0_af_526_6 ARC3_aC0_af_527_6 ARC3_aC0_af_528_6 ARC3_aC0_af_529_6 ARC3_aC0_af_530_6 ARC3_aC0_af_531_6 ARC3_aC0_aa ChildRouter
.ends
*---- end of process: Router<> -----
